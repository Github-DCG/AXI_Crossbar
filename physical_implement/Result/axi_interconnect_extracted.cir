* Extracted by KLayout on : 18/08/2024 14:51

.SUBCKT axi_interconnect M0_AXI_ARADDR[15] pwrite psel prdata[5] prdata[4]
+ prdata[3] prdata[2] prdata[1] prdata[0] penable paddr[9] S1_AXI_AWADDR[22]
+ paddr[8] paddr[7] paddr[6] paddr[5] paddr[4] paddr[3] paddr[31] paddr[30]
+ S1_AXI_AWADDR[12] paddr[2] paddr[29] S1_AXI_AWADDR[31] paddr[28] paddr[27]
+ paddr[26] paddr[25] paddr[24] S1_AXI_AWADDR[26] paddr[23] paddr[22]
+ S1_AXI_AWADDR[19] paddr[21] paddr[20] paddr[1] paddr[19] paddr[18] paddr[17]
+ S1_AXI_AWADDR[24] S1_AXI_AWADDR[29] paddr[16] paddr[15] paddr[14] paddr[13]
+ paddr[12] S1_AXI_AWADDR[13] paddr[11] S1_AXI_AWADDR[14] paddr[10]
+ S1_AXI_AWLEN[0] paddr[0] M1_AXI_ARLEN[3] S1_AXI_AWID[2] S1_AXI_AWLEN[4]
+ S1_AXI_AWID[3] M1_AXI_ARADDR[0] M1_AXI_ARADDR[10] M1_AXI_ARADDR[16]
+ M1_AXI_ARADDR[3] S1_AXI_AWID[5] M1_AXI_ARADDR[23] S1_AXI_AWLEN[3]
+ M1_AXI_ARBURST[0] S1_AXI_AWLEN[1] S1_AXI_AWLEN[5] M1_AXI_ARADDR[19]
+ M1_AXI_ARADDR[29] S1_AXI_AWID[1] M1_AXI_ARADDR[22] M1_AXI_ARADDR[24]
+ M1_AXI_ARADDR[20] M1_AXI_ARSIZE[0] M1_AXI_ARADDR[2] S1_AXI_AWREADY
+ S1_AXI_AWLEN[6] M1_AXI_ARADDR[27] S1_AXI_AWVALID S1_AXI_AWLEN[2]
+ S1_AXI_AWLEN[7] M1_AXI_ARADDR[28] M1_AXI_ARADDR[6] M1_AXI_ARADDR[17]
+ M1_AXI_ARADDR[25] M1_AXI_ARADDR[26] M1_AXI_ARADDR[31] M1_AXI_ARREADY
+ M1_AXI_ARADDR[8] M1_AXI_ARADDR[9] M1_AXI_ARVALID M1_AXI_ARADDR[7]
+ M1_AXI_ARSIZE[2] M1_AXI_ARADDR[18] M1_AXI_ARADDR[30] M1_AXI_ARADDR[13]
+ M1_AXI_ARADDR[15] M1_AXI_ARADDR[4] M1_AXI_ARADDR[21] M1_AXI_ARADDR[5]
+ M0_AXI_ARSIZE[0] M1_AXI_ARADDR[12] M0_AXI_ARADDR[21] M0_AXI_ARADDR[18]
+ M1_AXI_ARBURST[1] M0_AXI_ARADDR[24] M1_AXI_ARADDR[1] M1_AXI_ARADDR[11]
+ M0_AXI_ARADDR[29] M0_AXI_ARADDR[19] M0_AXI_ARADDR[27] M0_AXI_ARADDR[26]
+ M0_AXI_ARADDR[3] M0_AXI_ARADDR[28] M0_AXI_ARSIZE[2] M1_AXI_ARADDR[14]
+ M1_AXI_ARLEN[2] S2_AXI_ARADDR[6] S2_AXI_ARSIZE[0] S2_AXI_ARADDR[9]
+ S2_AXI_ARADDR[8] S2_AXI_ARADDR[7] M1_AXI_ARSIZE[1] M0_AXI_ARADDR[20]
+ M0_AXI_ARADDR[5] M0_AXI_ARBURST[0] M0_AXI_ARADDR[16] M0_AXI_ARADDR[17]
+ M0_AXI_ARADDR[12] M0_AXI_ARADDR[23] M0_AXI_ARADDR[6] M0_AXI_ARADDR[30]
+ M0_AXI_ARADDR[7] M0_AXI_ARADDR[2] M2_AXI_ARLEN[0] M2_AXI_ARADDR[5]
+ M0_AXI_ARADDR[25] M0_AXI_ARADDR[31] M2_AXI_ARADDR[13] M2_AXI_ARLEN[4]
+ M2_AXI_ARADDR[2] M2_AXI_ARADDR[18] M0_AXI_ARADDR[22] M2_AXI_ARADDR[19]
+ M2_AXI_ARADDR[26] M2_AXI_ARADDR[27] M2_AXI_ARADDR[3] M0_AXI_ARADDR[8]
+ M2_AXI_ARADDR[30] M0_AXI_ARLEN[3] M2_AXI_ARADDR[29] M2_AXI_ARID[0]
+ M2_AXI_ARLEN[1] M2_AXI_ARADDR[22] M2_AXI_ARADDR[24] M2_AXI_ARADDR[25]
+ M2_AXI_ARADDR[9] M0_AXI_ARADDR[13] M0_AXI_ARADDR[4] M0_AXI_ARADDR[14]
+ M2_AXI_ARADDR[7] M0_AXI_ARSIZE[1] M2_AXI_ARADDR[16] M2_AXI_ARADDR[28]
+ M2_AXI_ARADDR[31] M2_AXI_ARADDR[1] M2_AXI_ARADDR[15] M2_AXI_ARADDR[23]
+ M2_AXI_ARADDR[12] M2_AXI_ARADDR[8] M0_AXI_ARADDR[11] M2_AXI_ARADDR[17]
+ M2_AXI_ARADDR[14] M0_AXI_ARBURST[1] M2_AXI_ARSIZE[0] M0_AXI_ARADDR[10]
+ M0_AXI_ARADDR[1] M0_AXI_ARADDR[0] M0_AXI_ARLEN[7] S2_AXI_ARADDR[19]
+ S2_AXI_ARADDR[23] M2_AXI_ARADDR[6] S2_AXI_ARADDR[22] S2_AXI_ARADDR[5]
+ S2_AXI_ARADDR[26] M2_AXI_ARADDR[20] S2_AXI_ARADDR[3] S2_AXI_ARADDR[2]
+ S2_AXI_ARADDR[31] M0_AXI_ARADDR[9] M2_AXI_ARBURST[0] M2_AXI_ARADDR[0]
+ S2_AXI_ARADDR[25] S0_AXI_ARLEN[4] M2_AXI_ARADDR[4] M2_AXI_ARADDR[21]
+ S0_AXI_ARLEN[1] S0_AXI_RREADY S2_AXI_ARADDR[28] S0_AXI_ARADDR[3]
+ S0_AXI_ARLEN[0] S2_AXI_ARADDR[29] S2_AXI_ARADDR[30] M2_AXI_ARBURST[1]
+ S2_AXI_ARADDR[1] S2_AXI_ARADDR[24] S2_AXI_ARADDR[20] M2_AXI_ARID[2]
+ M2_AXI_ARLEN[3] S2_AXI_ARADDR[27] M2_AXI_ARLEN[6] S2_AXI_ARADDR[14]
+ M2_AXI_ARSIZE[2] S2_AXI_ARADDR[16] S2_AXI_ARADDR[15] M2_AXI_ARID[3]
+ S0_AXI_ARBURST[0] S0_AXI_ARADDR[26] S0_AXI_ARADDR[22] S0_AXI_ARADDR[8]
+ S2_AXI_ARADDR[12] S0_AXI_RVALID M2_AXI_ARSIZE[1] M2_AXI_ARLEN[2]
+ S2_AXI_ARADDR[4] S0_AXI_ARADDR[28] S2_AXI_ARADDR[18] M2_AXI_ARADDR[10]
+ M2_AXI_ARADDR[11] S0_AXI_ARADDR[29] S2_AXI_ARADDR[21] S0_AXI_ARID[0]
+ S0_AXI_ARADDR[19] M2_AXI_ARLEN[5] S0_AXI_ARADDR[25] S0_AXI_ARADDR[24]
+ S0_AXI_ARLEN[6] S0_AXI_ARADDR[2] S2_AXI_ARADDR[0] S2_AXI_ARADDR[17]
+ M2_AXI_ARLEN[7] M2_AXI_ARID[1] S0_AXI_ARADDR[13] S0_AXI_ARLEN[2]
+ S0_AXI_ARADDR[5] S0_AXI_ARADDR[20] S0_AXI_ARADDR[31] S0_AXI_ARADDR[30]
+ S0_AXI_ARADDR[27] S0_AXI_ARSIZE[0] S0_AXI_ARADDR[6] S0_AXI_ARID[2]
+ S2_AXI_ARADDR[10] S0_AXI_ARADDR[16] S2_AXI_ARADDR[13] S0_AXI_ARADDR[12]
+ S0_AXI_ARSIZE[2] S2_AXI_ARADDR[11] S0_AXI_ARADDR[14] S0_AXI_ARADDR[4]
+ S0_AXI_ARADDR[17] S0_AXI_ARADDR[15] S0_AXI_ARVALID S0_AXI_ARREADY
+ S0_AXI_ARADDR[21] S0_AXI_ARADDR[18] S0_AXI_ARADDR[1] S1_AXI_ARID[0]
+ S0_AXI_ARLEN[7] S1_AXI_ARLEN[1] S0_AXI_ARID[4] S1_AXI_ARADDR[24]
+ S1_AXI_ARADDR[19] S0_AXI_ARADDR[23] S1_AXI_ARADDR[20] S0_AXI_ARADDR[9]
+ S1_AXI_ARADDR[2] S1_AXI_ARID[5] S1_AXI_ARADDR[26] S1_AXI_ARADDR[27]
+ S1_AXI_ARLEN[7] S0_AXI_ARID[6] S0_AXI_ARSIZE[1] S1_AXI_ARADDR[9]
+ S0_AXI_ARLEN[5] S0_AXI_ARLEN[3] S0_AXI_ARADDR[10] S1_AXI_ARADDR[18]
+ S0_AXI_ARID[3] S1_AXI_ARADDR[16] S1_AXI_ARADDR[29] S0_AXI_ARADDR[0]
+ S1_AXI_ARLEN[5] S1_AXI_ARBURST[0] S1_AXI_ARID[2] S1_AXI_ARID[4]
+ S1_AXI_ARLEN[6] S0_AXI_ARID[5] S1_AXI_ARADDR[6] S1_AXI_ARADDR[25]
+ S1_AXI_ARADDR[30] S1_AXI_ARLEN[4] S1_AXI_ARADDR[23] S1_AXI_ARADDR[11]
+ S1_AXI_ARADDR[22] S0_AXI_ARADDR[7] S1_AXI_ARADDR[14] S1_AXI_ARBURST[1]
+ S1_AXI_ARADDR[1] S0_AXI_ARBURST[1] S1_AXI_ARADDR[8] S1_AXI_ARADDR[5]
+ S1_AXI_ARADDR[12] S0_AXI_ARADDR[11] S1_AXI_ARSIZE[0] S1_AXI_ARADDR[3]
+ S1_AXI_ARADDR[7] S1_AXI_ARLEN[0] S1_AXI_ARADDR[28] S1_AXI_ARADDR[4]
+ S1_AXI_ARADDR[31] S1_AXI_ARADDR[15] S2_AXI_ARID[7] S1_AXI_ARSIZE[1]
+ S2_AXI_ARBURST[0] S2_AXI_BVALID S2_AXI_ARID[6] S2_AXI_ARSIZE[1] S2_AXI_BREADY
+ S2_AXI_ARID[5] S1_AXI_ARSIZE[2] S2_AXI_ARID[4] S1_AXI_BVALID S1_AXI_ARID[7]
+ S2_AXI_ARSIZE[2] S1_AXI_ARADDR[10] S1_AXI_BREADY S2_AXI_ARBURST[1]
+ S1_AXI_ARADDR[0] S1_AXI_BID[5] S1_AXI_BID[0] S1_AXI_BID[4] S1_AXI_BRESP[0]
+ S1_AXI_BID[1] S1_AXI_BID[2] S1_AXI_BID[3] S1_AXI_BRESP[1] M1_AXI_BVALID
+ M1_AXI_BREADY AXI_CLK AXI_RSTn M1_AXI_BRESP[0] M1_AXI_BRESP[1]
+ S2_AXI_BRESP[1] S2_AXI_BRESP[0] M1_AXI_BID[3] M1_AXI_BID[1] S2_AXI_BID[4]
+ M0_AXI_BREADY S2_AXI_BID[1] M0_AXI_BVALID M1_AXI_BID[0] M1_AXI_BID[2]
+ S2_AXI_BID[3] M0_AXI_BRESP[1] S2_AXI_BID[5] M0_AXI_BRESP[0] S2_AXI_BID[2]
+ S1_AXI_ARADDR[21] M0_AXI_BID[0] S2_AXI_BID[0] M0_AXI_BID[1] M0_AXI_BID[2]
+ M0_AXI_BID[3] S1_AXI_ARADDR[17] S0_AXI_BRESP[1] S1_AXI_ARADDR[13]
+ S0_AXI_BRESP[0] S1_AXI_AWBURST[1] S1_AXI_AWSIZE[1] S1_AXI_AWADDR[0]
+ S0_AXI_BID[3] S0_AXI_BID[2] S1_AXI_AWSIZE[0] S1_AXI_AWSIZE[2]
+ S1_AXI_AWADDR[21] S1_AXI_AWADDR[11] S0_AXI_BID[4] S1_AXI_AWID[7]
+ S1_AXI_AWADDR[2] S1_AXI_AWADDR[27] S1_AXI_AWADDR[23] S0_AXI_BID[1]
+ S0_AXI_BID[0] M1_AXI_AWBURST[0] M2_AXI_ARREADY S1_AXI_ARLEN[2]
+ M0_AXI_AWADDR[0] M1_AXI_AWADDR[0] M0_AXI_ARLEN[4] M1_AXI_ARLEN[0]
+ S2_AXI_ARLEN[2] S1_AXI_AWADDR[28] M0_AXI_AWLEN[1] M1_AXI_AWADDR[20]
+ S0_AXI_BID[5] S1_AXI_AWADDR[16] S1_AXI_AWADDR[6] S1_AXI_AWADDR[17]
+ S1_AXI_ARLEN[3] S1_AXI_AWID[4] M1_AXI_AWADDR[23] S1_AXI_ARID[3]
+ M1_AXI_AWADDR[28] S1_AXI_AWADDR[1] M1_AXI_AWADDR[25] S2_AXI_ARLEN[3]
+ S1_AXI_AWADDR[18] M1_AXI_ARLEN[1] S1_AXI_AWBURST[0] S1_AXI_AWADDR[5]
+ M1_AXI_ARLEN[4] M1_AXI_ARLEN[5] M2_AXI_BID[3] S0_AXI_BREADY M2_AXI_BID[1]
+ S0_AXI_BVALID M2_AXI_BID[2] S1_AXI_AWADDR[7] M1_AXI_AWADDR[21]
+ M1_AXI_AWADDR[26] M2_AXI_BVALID S1_AXI_AWADDR[15] S1_AXI_ARID[1]
+ M0_AXI_ARLEN[5] M1_AXI_ARLEN[6] M2_AXI_BREADY S1_AXI_AWADDR[30]
+ S1_AXI_AWID[0] S1_AXI_AWADDR[25] M2_AXI_BRESP[0] S1_AXI_AWADDR[3]
+ S1_AXI_AWADDR[4] S1_AXI_AWADDR[20] S1_AXI_ARVALID S1_AXI_ARREADY
+ M1_AXI_ARLEN[7] M2_AXI_ARVALID M2_AXI_BID[0] S2_AXI_ARLEN[6]
+ M1_AXI_AWADDR[13] S1_AXI_AWADDR[8] M1_AXI_AWADDR[18] S2_AXI_ARLEN[4]
+ M2_AXI_BRESP[1] M1_AXI_AWADDR[31] S2_AXI_ARVALID S1_AXI_WDATA[7]
+ M1_AXI_AWADDR[14] M0_AXI_ARID[3] M1_AXI_AWADDR[12] S2_AXI_ARID[2]
+ S2_AXI_ARREADY S2_AXI_ARID[3] M1_AXI_ARID[3] M1_AXI_AWADDR[19] S2_AXI_ARID[1]
+ S1_AXI_WREADY S2_AXI_ARLEN[7] M1_AXI_AWADDR[11] S1_AXI_AWADDR[9]
+ S2_AXI_ARLEN[5] S1_AXI_WID[0] M1_AXI_AWADDR[6] M0_AXI_AWVALID
+ S1_AXI_AWADDR[10] S1_AXI_WVALID S0_AXI_RID[0] M0_AXI_AWID[1] M0_AXI_AWREADY
+ M1_AXI_WDATA[2] M1_AXI_WSTRB[3] M1_AXI_ARID[0] M1_AXI_AWADDR[10]
+ M1_AXI_ARID[2] M0_AXI_AWADDR[13] S0_AXI_WVALID S0_AXI_ARID[1]
+ M0_AXI_WDATA[16] M1_AXI_AWADDR[17] M0_AXI_AWSIZE[1] M1_AXI_WVALID
+ M1_AXI_WREADY M0_AXI_ARLEN[0] M1_AXI_ARID[1] S0_AXI_WREADY S0_AXI_RID[5]
+ M1_AXI_WDATA[25] M1_AXI_WDATA[4] M0_AXI_AWADDR[25] M0_AXI_AWID[0]
+ M0_AXI_AWADDR[18] S0_AXI_WDATA[6] M1_AXI_AWADDR[29] M1_AXI_AWSIZE[1]
+ S0_AXI_RLAST M1_AXI_WDATA[22] S0_AXI_WLAST S0_AXI_WDATA[10] M0_AXI_ARLEN[2]
+ M0_AXI_AWADDR[30] M0_AXI_AWADDR[17] M1_AXI_WDATA[6] S0_AXI_WDATA[22]
+ S0_AXI_WID[0] M0_AXI_ARLEN[1] M1_AXI_AWREADY M1_AXI_AWSIZE[2] M1_AXI_WID[0]
+ M0_AXI_AWADDR[12] M1_AXI_AWVALID S0_AXI_WDATA[13] M1_AXI_WLAST
+ M0_AXI_AWADDR[15] M0_AXI_AWBURST[0] S0_AXI_WDATA[29] M1_AXI_WID[1]
+ M1_AXI_WDATA[16] M0_AXI_AWBURST[1] M0_AXI_ARID[1] M1_AXI_WDATA[13]
+ S0_AXI_WDATA[27] S0_AXI_WDATA[3] M0_AXI_ARID[0] M1_AXI_AWBURST[1]
+ M1_AXI_AWADDR[24] M0_AXI_ARLEN[6] M0_AXI_AWADDR[29] M1_AXI_WDATA[27]
+ M1_AXI_WDATA[11] M1_AXI_WDATA[10] M0_AXI_AWADDR[20] M1_AXI_WSTRB[2]
+ M1_AXI_WDATA[24] M1_AXI_WDATA[29] M0_AXI_AWID[2] M0_AXI_ARID[2]
+ M1_AXI_WDATA[5] M1_AXI_WDATA[30] M0_AXI_AWADDR[31] M1_AXI_AWADDR[22]
+ M0_AXI_AWADDR[6] M1_AXI_WDATA[18] M1_AXI_WSTRB[0] M1_AXI_AWADDR[5]
+ M1_AXI_AWADDR[27] M1_AXI_WDATA[12] S0_AXI_WSTRB[3] M1_AXI_AWADDR[2]
+ M0_AXI_AWADDR[24] M0_AXI_WDATA[7] M1_AXI_WDATA[21] M1_AXI_WDATA[3]
+ M1_AXI_WSTRB[1] M0_AXI_AWADDR[14] M1_AXI_AWADDR[15] M1_AXI_AWID[1]
+ M1_AXI_WDATA[7] M0_AXI_AWADDR[23] M0_AXI_AWSIZE[2] M1_AXI_WDATA[19]
+ S0_AXI_RID[6] M1_AXI_WDATA[1] M0_AXI_AWID[3] M0_AXI_AWADDR[2]
+ M0_AXI_AWADDR[11] M1_AXI_WID[2] S0_AXI_RID[4] S0_AXI_RID[7] M1_AXI_AWADDR[16]
+ M1_AXI_AWADDR[30] M1_AXI_AWADDR[7] M1_AXI_WDATA[14] M1_AXI_WDATA[28]
+ M0_AXI_AWADDR[19] M0_AXI_AWADDR[10] M0_AXI_AWADDR[22] M1_AXI_WID[3]
+ S0_AXI_WDATA[9] S0_AXI_WDATA[7] M0_AXI_AWADDR[27] M0_AXI_AWADDR[16]
+ S0_AXI_WID[1] M0_AXI_ARVALID M0_AXI_ARREADY M1_AXI_WDATA[8] M1_AXI_WDATA[0]
+ S0_AXI_WDATA[30] S0_AXI_AWADDR[0] M2_AXI_AWREADY M1_AXI_WDATA[17]
+ M1_AXI_WDATA[31] S0_AXI_AWADDR[2] M0_AXI_AWADDR[1] M0_AXI_AWADDR[3]
+ M1_AXI_WDATA[9] M1_AXI_WDATA[26] M1_AXI_WDATA[23] S1_AXI_WDATA[13]
+ M0_AXI_AWADDR[21] M0_AXI_AWADDR[5] M2_AXI_AWADDR[12] M1_AXI_WDATA[20]
+ M1_AXI_WDATA[15] S0_AXI_WID[5] M0_AXI_AWADDR[28] M2_AXI_AWVALID
+ M2_AXI_WDATA[3] S1_AXI_WDATA[29] M0_AXI_AWADDR[7] M0_AXI_AWADDR[26]
+ M2_AXI_AWADDR[17] M2_AXI_WVALID M2_AXI_WREADY M2_AXI_AWADDR[14]
+ S0_AXI_AWADDR[20] S0_AXI_AWADDR[31] S0_AXI_WDATA[11] M2_AXI_WDATA[13]
+ M2_AXI_WDATA[30] M2_AXI_AWADDR[29] S0_AXI_AWADDR[30] S0_AXI_AWBURST[0]
+ M2_AXI_WID[0] M2_AXI_WDATA[6] S0_AXI_WID[4] S1_AXI_WDATA[10] S0_AXI_AWADDR[6]
+ M0_AXI_AWADDR[9] M2_AXI_WLAST S0_AXI_AWADDR[14] M1_AXI_AWADDR[3]
+ M1_AXI_AWLEN[2] M2_AXI_WDATA[7] S0_AXI_WDATA[2] S1_AXI_WDATA[22]
+ M0_AXI_AWLEN[2] M0_AXI_AWADDR[8] S0_AXI_AWADDR[22] M0_AXI_WREADY
+ M2_AXI_WDATA[10] M0_AXI_WVALID S0_AXI_AWVALID S0_AXI_AWREADY
+ M2_AXI_AWBURST[0] M2_AXI_WDATA[29] M2_AXI_WDATA[22] S0_AXI_WDATA[16]
+ S0_AXI_AWADDR[13] M2_AXI_AWADDR[15] S0_AXI_AWID[1] M2_AXI_WDATA[9]
+ M0_AXI_WDATA[22] M0_AXI_WDATA[10] M2_AXI_AWADDR[6] S0_AXI_AWADDR[23]
+ M0_AXI_WLAST S0_AXI_WDATA[21] S0_AXI_AWADDR[18] M0_AXI_AWLEN[5]
+ M0_AXI_AWLEN[6] M0_AXI_WDATA[3] S0_AXI_WSTRB[2] M0_AXI_WDATA[9]
+ M1_AXI_AWID[3] S0_AXI_AWADDR[17] M0_AXI_AWLEN[0] M0_AXI_WDATA[13]
+ M0_AXI_WDATA[29] M0_AXI_WDATA[30] M0_AXI_AWLEN[4] S0_AXI_AWID[3]
+ M2_AXI_AWSIZE[1] M0_AXI_WDATA[6] M0_AXI_WDATA[4] S0_AXI_WDATA[5]
+ M0_AXI_AWSIZE[0] M2_AXI_AWADDR[2] S0_AXI_AWADDR[15] M2_AXI_WDATA[16]
+ M0_AXI_WID[1] M2_AXI_WID[1] M0_AXI_AWLEN[3] M0_AXI_AWLEN[7] M1_AXI_AWLEN[7]
+ S0_AXI_WDATA[17] M2_AXI_WDATA[14] M0_AXI_WDATA[5] M2_AXI_AWADDR[0]
+ S0_AXI_AWADDR[12] S0_AXI_AWLEN[2] M0_AXI_AWADDR[4] M2_AXI_RREADY
+ S1_AXI_WDATA[27] S1_AXI_WDATA[16] M2_AXI_RVALID M1_AXI_AWADDR[8]
+ M2_AXI_AWADDR[19] M2_AXI_WDATA[27] M0_AXI_WDATA[27] S0_AXI_AWADDR[19]
+ M2_AXI_AWADDR[31] S0_AXI_AWADDR[21] M2_AXI_WDATA[5] M2_AXI_WDATA[18]
+ S0_AXI_WDATA[14] M1_AXI_AWADDR[1] M1_AXI_AWLEN[0] M2_AXI_RID[2]
+ S0_AXI_WDATA[4] M1_AXI_AWLEN[6] M1_AXI_AWADDR[9] M2_AXI_WSTRB[3]
+ S0_AXI_RID[1] M1_AXI_AWID[2] M2_AXI_AWADDR[10] M0_AXI_WSTRB[3]
+ M2_AXI_WDATA[26] M2_AXI_AWADDR[30] S0_AXI_AWID[4] S0_AXI_AWSIZE[2]
+ S1_AXI_WDATA[26] M0_AXI_WDATA[14] S0_AXI_WDATA[19] M2_AXI_AWADDR[23]
+ M1_AXI_AWLEN[1] M2_AXI_WDATA[4] M2_AXI_RID[1] M2_AXI_AWADDR[25]
+ M1_AXI_AWADDR[4] M2_AXI_WDATA[25] S0_AXI_RID[2] M1_AXI_AWLEN[4]
+ M1_AXI_AWSIZE[0] M1_AXI_AWID[0] S1_AXI_WDATA[18] M2_AXI_WSTRB[2]
+ S0_AXI_WDATA[26] M1_AXI_AWLEN[3] M1_AXI_AWLEN[5] S0_AXI_WDATA[8]
+ S0_AXI_WDATA[23] M2_AXI_AWADDR[26] M2_AXI_AWADDR[22] S0_AXI_AWBURST[1]
+ S1_AXI_WDATA[24] S0_AXI_WDATA[24] S0_AXI_WDATA[25] M2_AXI_AWADDR[28]
+ S0_AXI_AWID[0] M2_AXI_AWADDR[3] M2_AXI_WDATA[11] S1_AXI_WDATA[11]
+ S0_AXI_WDATA[18] M2_AXI_AWLEN[2] S0_AXI_AWADDR[3] S0_AXI_WDATA[20]
+ M2_AXI_WDATA[24] S0_AXI_AWLEN[4] S0_AXI_AWADDR[10] S2_AXI_RID[4]
+ M0_AXI_WDATA[25] M2_AXI_WDATA[8] S2_AXI_RID[2] S2_AXI_RID[5]
+ M2_AXI_AWADDR[20] M1_AXI_RID[0] M2_AXI_WDATA[2] M2_AXI_WDATA[20]
+ S1_AXI_WDATA[14] S0_AXI_AWADDR[11] S0_AXI_AWLEN[6] M0_AXI_WDATA[20]
+ M0_AXI_WDATA[26] S0_AXI_AWADDR[28] M2_AXI_AWADDR[13] S1_AXI_WDATA[17]
+ M2_AXI_RLAST S2_AXI_RID[6] M2_AXI_AWADDR[18] M2_AXI_AWSIZE[2] S0_AXI_WDATA[0]
+ S0_AXI_WDATA[1] S0_AXI_WDATA[31] S2_AXI_RID[1] M2_AXI_AWID[1]
+ M2_AXI_WDATA[23] M2_AXI_WDATA[17] S0_AXI_AWADDR[24] M2_AXI_AWBURST[1]
+ S0_AXI_AWADDR[16] M2_AXI_WDATA[28] M2_AXI_RID[3] S0_AXI_WDATA[28]
+ M2_AXI_AWLEN[4] S0_AXI_AWSIZE[1] S0_AXI_WID[6] M0_AXI_WDATA[21]
+ S0_AXI_AWSIZE[0] S0_AXI_AWADDR[25] S2_AXI_RDATA[6] S1_AXI_WDATA[20]
+ S0_AXI_WSTRB[1] M2_AXI_WDATA[1] M2_AXI_AWLEN[1] M2_AXI_AWID[2]
+ S1_AXI_WDATA[15] S1_AXI_WDATA[23] S0_AXI_AWADDR[1] S0_AXI_AWADDR[8]
+ S0_AXI_WDATA[15] M2_AXI_WDATA[19] M2_AXI_AWLEN[3] M2_AXI_AWLEN[0]
+ S0_AXI_AWADDR[7] M0_AXI_WDATA[15] M2_AXI_WDATA[12] M0_AXI_WDATA[8]
+ S2_AXI_RID[3] M2_AXI_AWID[0] M2_AXI_AWADDR[9] M2_AXI_WID[3] M2_AXI_RID[0]
+ S0_AXI_AWADDR[27] M2_AXI_AWLEN[6] M0_AXI_WDATA[24] M2_AXI_WDATA[31]
+ S0_AXI_WID[7] S0_AXI_AWADDR[9] S0_AXI_AWADDR[5] S1_AXI_WDATA[0]
+ M2_AXI_WDATA[0] S2_AXI_RREADY S0_AXI_AWADDR[4] S2_AXI_RVALID S0_AXI_WID[3]
+ S1_AXI_WDATA[25] M0_AXI_WSTRB[2] M2_AXI_AWLEN[7] S2_AXI_AWADDR[24]
+ S2_AXI_AWADDR[31] S1_AXI_WDATA[19] S0_AXI_WDATA[12] M2_AXI_WDATA[21]
+ S2_AXI_AWLEN[6] S2_AXI_AWBURST[0] S1_AXI_WDATA[2] M1_AXI_RVALID
+ S2_AXI_RRESP[1] S2_AXI_AWADDR[19] S2_AXI_AWID[3] S2_AXI_AWADDR[8]
+ S0_AXI_WID[2] S0_AXI_WSTRB[0] M2_AXI_WID[2] M2_AXI_WDATA[15] S2_AXI_AWADDR[5]
+ S1_AXI_WDATA[1] S2_AXI_AWADDR[20] S2_AXI_AWADDR[3] M0_AXI_WDATA[2]
+ M1_AXI_RREADY S2_AXI_AWID[2] S2_AXI_RDATA[5] S2_AXI_AWADDR[22]
+ M2_AXI_WSTRB[0] M0_AXI_WDATA[17] M1_AXI_RID[3] S2_AXI_AWID[0] S2_AXI_AWID[5]
+ S2_AXI_AWADDR[30] S2_AXI_WDATA[16] S2_AXI_WDATA[20] S2_AXI_WDATA[31]
+ S2_AXI_AWLEN[2] S2_AXI_AWADDR[15] S1_AXI_WDATA[3] S1_AXI_WDATA[4]
+ S2_AXI_AWBURST[1] S2_AXI_AWLEN[1] S1_AXI_WID[2] S1_AXI_WDATA[31]
+ S2_AXI_AWLEN[0] S2_AXI_AWSIZE[1] S2_AXI_RDATA[8] S2_AXI_AWADDR[14]
+ S1_AXI_WID[5] M0_AXI_WDATA[23] S1_AXI_WSTRB[2] S1_AXI_WID[6] S2_AXI_AWID[1]
+ S2_AXI_AWADDR[9] S2_AXI_AWADDR[26] S1_AXI_WID[4] S2_AXI_WDATA[29]
+ S2_AXI_WDATA[5] S2_AXI_AWADDR[6] S2_AXI_WDATA[3] S2_AXI_AWLEN[5]
+ S2_AXI_AWLEN[7] S2_AXI_AWSIZE[2] S2_AXI_WSTRB[2] S1_AXI_WDATA[30]
+ M0_AXI_WDATA[1] S2_AXI_AWADDR[25] S2_AXI_AWLEN[4] S1_AXI_WDATA[5]
+ S2_AXI_WID[7] S2_AXI_AWADDR[21] S2_AXI_AWADDR[18] S2_AXI_WDATA[30]
+ S2_AXI_WDATA[4] S2_AXI_AWADDR[7] S2_AXI_AWSIZE[0] S2_AXI_AWADDR[23]
+ S2_AXI_WID[2] S2_AXI_WDATA[13] M0_AXI_WID[2] S2_AXI_AWADDR[27]
+ S2_AXI_AWADDR[12] S2_AXI_AWADDR[28] S2_AXI_WID[3] S2_AXI_WDATA[0]
+ S2_AXI_WDATA[10] S2_AXI_AWADDR[4] S2_AXI_AWLEN[3] S2_AXI_WDATA[1]
+ S2_AXI_WDATA[24] S2_AXI_AWID[7] S2_AXI_AWADDR[29] S2_AXI_AWADDR[1]
+ S2_AXI_WID[4] S2_AXI_WDATA[23] S2_AXI_WDATA[17] S2_AXI_AWVALID S2_AXI_AWREADY
+ M0_AXI_WDATA[19] S2_AXI_WID[5] S2_AXI_AWID[6] S2_AXI_AWADDR[16] M0_AXI_WID[3]
+ S1_AXI_WID[3] S2_AXI_AWADDR[2] S2_AXI_AWADDR[10] S2_AXI_AWADDR[17]
+ S2_AXI_AWADDR[11] M0_AXI_WDATA[0] S2_AXI_WID[6] S1_AXI_WID[7]
+ S2_AXI_WDATA[19] S2_AXI_AWADDR[0] S2_AXI_AWID[4] S2_AXI_AWADDR[13]
+ M2_AXI_AWADDR[8] S0_AXI_AWADDR[26] M2_AXI_AWADDR[4] M2_AXI_AWADDR[27]
+ M2_AXI_AWSIZE[0] M2_AXI_AWADDR[7] M2_AXI_AWADDR[21] M2_AXI_AWADDR[24]
+ S2_AXI_RLAST M2_AXI_AWID[3] M2_AXI_AWLEN[5] S2_AXI_RID[7] M2_AXI_AWADDR[1]
+ S2_AXI_RRESP[0] M2_AXI_AWADDR[16] M2_AXI_AWADDR[5] S0_AXI_AWADDR[29]
+ M2_AXI_AWADDR[11] S2_AXI_RID[0] M0_AXI_RDATA[25] S0_AXI_RDATA[25]
+ M0_AXI_RDATA[9] M0_AXI_RDATA[21] S0_AXI_RDATA[16] M0_AXI_RID[1]
+ M2_AXI_RDATA[8] M1_AXI_RDATA[7] S1_AXI_RDATA[4] S0_AXI_RDATA[4] M0_AXI_RLAST
+ M0_AXI_RDATA[19] M2_AXI_RDATA[26] M2_AXI_RDATA[17] S1_AXI_WDATA[21]
+ S2_AXI_WDATA[6] prdata[24] S2_AXI_WDATA[26] S2_AXI_WDATA[2] S2_AXI_WLAST
+ S1_AXI_WID[1] S0_AXI_RDATA[28] S1_AXI_WLAST M0_AXI_WSTRB[1] M2_AXI_RRESP[0]
+ M0_AXI_RDATA[17] M2_AXI_RDATA[30] S2_AXI_RDATA[18] M2_AXI_RDATA[14]
+ M2_AXI_RDATA[28] M2_AXI_RDATA[10] M2_AXI_RDATA[31] M2_AXI_RDATA[0]
+ M1_AXI_RDATA[29] S2_AXI_RDATA[14] M2_AXI_RDATA[2] M2_AXI_RRESP[1]
+ S1_AXI_RDATA[31] M2_AXI_RDATA[9] S1_AXI_RDATA[17] M0_AXI_RDATA[8]
+ S0_AXI_RDATA[26] S1_AXI_RDATA[7] M1_AXI_RDATA[21] M0_AXI_RDATA[28]
+ M1_AXI_RDATA[18] M1_AXI_RDATA[9] S1_AXI_RDATA[21] S0_AXI_RDATA[14]
+ M1_AXI_RLAST S0_AXI_RDATA[13] S0_AXI_RDATA[17] S1_AXI_RDATA[8]
+ S0_AXI_RDATA[21] S1_AXI_RDATA[12] S2_AXI_RDATA[1] S2_AXI_RDATA[10]
+ S2_AXI_RDATA[31] S1_AXI_RDATA[19] M0_AXI_RDATA[4] S1_AXI_RDATA[30]
+ M0_AXI_RDATA[1] M2_AXI_RDATA[29] M1_AXI_RDATA[13] M2_AXI_RDATA[24]
+ S0_AXI_AWID[7] prdata[20] S2_AXI_WDATA[27] S2_AXI_WDATA[8] S2_AXI_WREADY
+ M2_AXI_WSTRB[1] M0_AXI_RDATA[29] M0_AXI_RDATA[14] M0_AXI_RDATA[23]
+ M1_AXI_RID[1] M2_AXI_RDATA[18] M0_AXI_RDATA[10] S2_AXI_RDATA[16]
+ S2_AXI_RDATA[15] S1_AXI_RRESP[0] M1_AXI_RDATA[15] S1_AXI_WDATA[28] prdata[21]
+ S2_AXI_RDATA[9] S2_AXI_RDATA[7] S0_AXI_AWID[6] S2_AXI_RDATA[28]
+ S2_AXI_WSTRB[3] S2_AXI_WDATA[12] S2_AXI_RDATA[26] S0_AXI_AWLEN[0]
+ S2_AXI_RDATA[0] S2_AXI_RDATA[4] M2_AXI_RDATA[12] S1_AXI_RDATA[1]
+ M0_AXI_RDATA[26] M2_AXI_RDATA[3] M1_AXI_RDATA[12] M1_AXI_RDATA[20]
+ M1_AXI_RRESP[0] S0_AXI_RDATA[12] S1_AXI_RRESP[1] S1_AXI_RID[0]
+ M1_AXI_RDATA[3] S1_AXI_RDATA[20] M1_AXI_RDATA[11] prdata[30] prdata[17]
+ prdata[6] M0_AXI_WID[0] prdata[25] M0_AXI_WDATA[31] prdata[8] prdata[23]
+ prdata[16] S2_AXI_WDATA[28] S0_AXI_RDATA[18] M0_AXI_WDATA[11]
+ S1_AXI_RDATA[14] M0_AXI_RID[0] M0_AXI_WSTRB[0] S1_AXI_RDATA[6]
+ S2_AXI_WSTRB[0] S0_AXI_RDATA[29] S0_AXI_RDATA[7] S0_AXI_RDATA[20]
+ S1_AXI_RDATA[26] M0_AXI_RVALID S2_AXI_WDATA[15] M0_AXI_WDATA[28]
+ S2_AXI_RDATA[23] S0_AXI_AWID[5] S1_AXI_RDATA[2] S2_AXI_RDATA[19]
+ S1_AXI_RDATA[16] S2_AXI_RDATA[25] M0_AXI_RDATA[18] S2_AXI_RDATA[24]
+ S1_AXI_RDATA[5] S1_AXI_RVALID M0_AXI_RDATA[20] S1_AXI_RDATA[11] S1_AXI_RID[2]
+ M0_AXI_RREADY S1_AXI_RDATA[3] S1_AXI_RDATA[9] S1_AXI_RDATA[15] S1_AXI_RID[6]
+ S1_AXI_RDATA[23] M0_AXI_WDATA[12] S1_AXI_RDATA[27] S0_AXI_RDATA[3]
+ S0_AXI_RDATA[5] S1_AXI_RDATA[25] S0_AXI_RDATA[23] S0_AXI_RDATA[6]
+ M2_AXI_RDATA[11] S1_AXI_RDATA[0] S1_AXI_RID[1] S0_AXI_RRESP[0]
+ S1_AXI_RDATA[24] S0_AXI_RDATA[1] S0_AXI_RDATA[22] S0_AXI_RDATA[31]
+ M2_AXI_RDATA[5] S0_AXI_RDATA[10] M0_AXI_RDATA[27] M1_AXI_RDATA[24]
+ M1_AXI_RDATA[8] M1_AXI_RDATA[1] M2_AXI_RDATA[4] S2_AXI_RDATA[11]
+ S2_AXI_RDATA[21] net1419 prdata[28] S2_AXI_WDATA[18] prdata[18]
+ S2_AXI_WDATA[22] prdata[19] S2_AXI_WID[0] prdata[29] prdata[12]
+ S2_AXI_WDATA[11] M0_AXI_WDATA[18] prdata[10] prdata[31] S2_AXI_WDATA[14]
+ prdata[26] S2_AXI_WDATA[25] prdata[15] S1_AXI_WDATA[6] S1_AXI_WDATA[9]
+ S2_AXI_WDATA[9] prdata[22] prdata[11] S2_AXI_WDATA[7] S1_AXI_AWID[6]
+ S1_AXI_WSTRB[0] prdata[13] prdata[27] S2_AXI_WDATA[21] S1_AXI_WSTRB[3]
+ S1_AXI_ARID[6] S1_AXI_WSTRB[1] prdata[14] S2_AXI_WSTRB[1] S2_AXI_WVALID
+ prdata[7] prdata[9] S1_AXI_WDATA[12] S0_AXI_AWLEN[7] S2_AXI_WID[1]
+ S1_AXI_WDATA[8] M2_AXI_RDATA[13] M2_AXI_RDATA[22] M2_AXI_RDATA[27]
+ M2_AXI_RDATA[21] S0_AXI_AWID[2] M2_AXI_RDATA[16] M0_AXI_RDATA[12]
+ M2_AXI_RDATA[1] M2_AXI_RDATA[23] M2_AXI_RDATA[20] S0_AXI_RID[3]
+ M2_AXI_RDATA[15] S2_AXI_RDATA[27] M1_AXI_RDATA[30] M2_AXI_RDATA[19]
+ M0_AXI_RDATA[31] M0_AXI_RDATA[2] M2_AXI_RDATA[6] M1_AXI_RDATA[27]
+ S2_AXI_RDATA[13] M1_AXI_RDATA[10] S1_AXI_RDATA[22] S0_AXI_AWLEN[3]
+ M2_AXI_RDATA[7] M2_AXI_RDATA[25] M1_AXI_RDATA[17] M1_AXI_RDATA[23]
+ M0_AXI_RDATA[15] M1_AXI_RRESP[1] S1_AXI_RDATA[29] M1_AXI_RDATA[4]
+ S2_AXI_RDATA[20] S0_AXI_AWLEN[5] M1_AXI_RDATA[0] M1_AXI_RDATA[31]
+ S1_AXI_RID[5] S2_AXI_RDATA[29] M1_AXI_RDATA[25] M1_AXI_RDATA[16]
+ M1_AXI_RDATA[28] M1_AXI_RDATA[22] M1_AXI_RDATA[2] S0_AXI_AWLEN[1]
+ M1_AXI_RDATA[5] S2_AXI_RDATA[30] M0_AXI_RDATA[24] M1_AXI_RDATA[14]
+ S2_AXI_RDATA[3] M1_AXI_RDATA[6] M1_AXI_RID[2] S2_AXI_RDATA[2]
+ M1_AXI_RDATA[19] M0_AXI_RDATA[0] M1_AXI_RDATA[26] M0_AXI_RRESP[1]
+ S1_AXI_RREADY S0_AXI_RDATA[24] S2_AXI_RDATA[22] S0_AXI_RDATA[27]
+ S2_AXI_RDATA[12] S0_AXI_RDATA[19] S0_AXI_RRESP[1] M0_AXI_RDATA[6]
+ M0_AXI_RRESP[0] M0_AXI_RID[3] M0_AXI_RDATA[5] M0_AXI_RDATA[30]
+ M0_AXI_RDATA[13] S0_AXI_RDATA[2] S2_AXI_ARLEN[0] S2_AXI_ARLEN[1]
+ S1_AXI_RDATA[10] M0_AXI_RDATA[3] M0_AXI_RID[2] M0_AXI_RDATA[11]
+ S1_AXI_RDATA[28] M0_AXI_RDATA[16] S1_AXI_RID[7] S0_AXI_RDATA[30]
+ M0_AXI_RDATA[7] S0_AXI_RDATA[8] S2_AXI_ARID[0] S0_AXI_RDATA[11]
+ M0_AXI_RDATA[22] S1_AXI_RDATA[13] S0_AXI_RDATA[15] S1_AXI_RID[4]
+ S1_AXI_RDATA[18] S1_AXI_RLAST S0_AXI_RDATA[9] S1_AXI_RID[3] S2_AXI_RDATA[17]
+ S0_AXI_RDATA[0] NWELL PWELL BULK
X$2 M0_AXI_ARADDR[15] \$9459 NWELL PWELL BULK CLKBUF_X2
X$8 pwrite \$1046 NWELL PWELL BULK BUF_X1
X$14 psel \$387 NWELL PWELL BULK BUF_X1
X$19 \$3570 prdata[5] NWELL PWELL BULK BUF_X1
X$26 \$545 prdata[4] NWELL PWELL BULK BUF_X1
X$32 \$2937 prdata[3] NWELL PWELL BULK BUF_X1
X$38 \$922 prdata[2] NWELL PWELL BULK BUF_X1
X$44 \$2298 prdata[1] NWELL PWELL BULK BUF_X1
X$50 \$2297 prdata[0] NWELL PWELL BULK BUF_X1
X$60 penable \$390 NWELL PWELL BULK BUF_X1
X$62 paddr[9] \$428 NWELL PWELL BULK BUF_X1
X$68 \$598 S1_AXI_AWADDR[22] NWELL PWELL BULK BUF_X1
X$74 paddr[8] \$1290 NWELL PWELL BULK BUF_X1
X$80 paddr[7] \$923 NWELL PWELL BULK BUF_X1
X$86 paddr[6] \$1443 NWELL PWELL BULK BUF_X1
X$92 paddr[5] \$924 NWELL PWELL BULK BUF_X1
X$98 paddr[4] \$1045 NWELL PWELL BULK BUF_X1
X$104 paddr[3] \$927 NWELL PWELL BULK BUF_X1
X$110 paddr[31] \$926 NWELL PWELL BULK BUF_X1
X$116 paddr[30] \$925 NWELL PWELL BULK BUF_X1
X$122 \$1431 S1_AXI_AWADDR[12] NWELL PWELL BULK BUF_X1
X$128 paddr[2] \$2841 NWELL PWELL BULK BUF_X1
X$134 paddr[29] \$1774 NWELL PWELL BULK BUF_X1
X$140 \$2473 S1_AXI_AWADDR[31] NWELL PWELL BULK BUF_X1
X$146 paddr[28] \$628 NWELL PWELL BULK BUF_X1
X$152 paddr[27] \$438 NWELL PWELL BULK BUF_X1
X$158 paddr[26] \$1285 NWELL PWELL BULK BUF_X1
X$164 paddr[25] \$1287 NWELL PWELL BULK BUF_X1
X$170 paddr[24] \$647 NWELL PWELL BULK BUF_X1
X$176 \$2485 S1_AXI_AWADDR[26] NWELL PWELL BULK BUF_X1
X$182 paddr[23] \$653 NWELL PWELL BULK BUF_X1
X$188 paddr[22] \$650 NWELL PWELL BULK BUF_X1
X$194 \$2470 S1_AXI_AWADDR[19] NWELL PWELL BULK BUF_X1
X$200 paddr[21] \$930 NWELL PWELL BULK BUF_X1
X$206 paddr[20] \$929 NWELL PWELL BULK BUF_X1
X$212 paddr[1] \$547 NWELL PWELL BULK BUF_X1
X$218 paddr[19] \$1932 NWELL PWELL BULK BUF_X1
X$224 paddr[18] \$548 NWELL PWELL BULK BUF_X1
X$230 paddr[17] \$1294 NWELL PWELL BULK BUF_X1
X$236 \$2489 S1_AXI_AWADDR[24] NWELL PWELL BULK BUF_X1
X$242 \$4312 S1_AXI_AWADDR[29] NWELL PWELL BULK BUF_X1
X$248 paddr[16] \$932 NWELL PWELL BULK BUF_X1
X$254 paddr[15] \$1972 NWELL PWELL BULK BUF_X1
X$260 paddr[14] \$391 NWELL PWELL BULK BUF_X1
X$270 paddr[13] \$395 NWELL PWELL BULK BUF_X1
X$272 paddr[12] \$1978 NWELL PWELL BULK BUF_X1
X$278 \$2513 S1_AXI_AWADDR[13] NWELL PWELL BULK BUF_X1
X$284 paddr[11] \$1090 NWELL PWELL BULK BUF_X1
X$290 \$2507 S1_AXI_AWADDR[14] NWELL PWELL BULK BUF_X1
X$296 paddr[10] \$393 NWELL PWELL BULK BUF_X1
X$302 \$696 S1_AXI_AWLEN[0] NWELL PWELL BULK BUF_X1
X$308 paddr[0] \$456 NWELL PWELL BULK BUF_X1
X$314 M1_AXI_ARLEN[3] \$18748 NWELL PWELL BULK CLKBUF_X2
X$320 \$1991 S1_AXI_AWID[2] NWELL PWELL BULK BUF_X1
X$326 \$1297 S1_AXI_AWLEN[4] NWELL PWELL BULK BUF_X1
X$332 \$693 S1_AXI_AWID[3] NWELL PWELL BULK BUF_X1
X$338 M1_AXI_ARADDR[0] \$1104 NWELL PWELL BULK BUF_X1
X$344 M1_AXI_ARADDR[10] \$1987 NWELL PWELL BULK BUF_X1
X$350 M1_AXI_ARADDR[16] \$2007 NWELL PWELL BULK BUF_X1
X$356 M1_AXI_ARADDR[3] \$1783 NWELL PWELL BULK BUF_X1
X$362 \$2522 S1_AXI_AWID[5] NWELL PWELL BULK BUF_X1
X$368 M1_AXI_ARADDR[23] \$1126 NWELL PWELL BULK BUF_X1
X$374 \$2005 S1_AXI_AWLEN[3] NWELL PWELL BULK BUF_X1
X$380 M1_AXI_ARBURST[0] \$389 NWELL PWELL BULK BUF_X1
X$386 \$723 S1_AXI_AWLEN[1] NWELL PWELL BULK BUF_X1
X$392 \$734 S1_AXI_AWLEN[5] NWELL PWELL BULK BUF_X1
X$402 M1_AXI_ARADDR[19] \$2030 NWELL PWELL BULK BUF_X1
X$404 M1_AXI_ARADDR[29] \$2025 NWELL PWELL BULK BUF_X1
X$410 \$3183 S1_AXI_AWID[1] NWELL PWELL BULK BUF_X1
X$416 M1_AXI_ARADDR[22] \$1128 NWELL PWELL BULK CLKBUF_X2
X$422 M1_AXI_ARADDR[24] \$1524 NWELL PWELL BULK BUF_X1
X$428 M1_AXI_ARADDR[20] \$2033 NWELL PWELL BULK BUF_X1
X$434 M1_AXI_ARSIZE[0] \$2027 NWELL PWELL BULK BUF_X1
X$440 M1_AXI_ARADDR[2] \$449 NWELL PWELL BULK BUF_X1
X$446 S1_AXI_AWREADY \$933 NWELL PWELL BULK BUF_X1
X$452 \$470 S1_AXI_AWLEN[6] NWELL PWELL BULK BUF_X1
X$458 M1_AXI_ARADDR[27] \$2320 NWELL PWELL BULK BUF_X1
X$464 \$471 S1_AXI_AWVALID NWELL PWELL BULK BUF_X1
X$470 \$2035 S1_AXI_AWLEN[2] NWELL PWELL BULK BUF_X1
X$476 \$3778 S1_AXI_AWLEN[7] NWELL PWELL BULK BUF_X1
X$482 M1_AXI_ARADDR[28] \$2051 NWELL PWELL BULK BUF_X1
X$488 M1_AXI_ARADDR[6] \$2558 NWELL PWELL BULK BUF_X1
X$494 M1_AXI_ARADDR[17] \$1169 NWELL PWELL BULK BUF_X1
X$500 M1_AXI_ARADDR[25] \$3589 NWELL PWELL BULK BUF_X1
X$506 M1_AXI_ARADDR[26] \$2063 NWELL PWELL BULK BUF_X1
X$512 M1_AXI_ARADDR[31] \$1796 NWELL PWELL BULK BUF_X1
X$518 \$2573 M1_AXI_ARREADY NWELL PWELL BULK BUF_X1
X$524 M1_AXI_ARADDR[8] \$4996 NWELL PWELL BULK BUF_X1
X$530 M1_AXI_ARADDR[9] \$942 NWELL PWELL BULK BUF_X1
X$536 M1_AXI_ARVALID \$1183 NWELL PWELL BULK CLKBUF_X2
X$542 M1_AXI_ARADDR[7] \$554 NWELL PWELL BULK BUF_X1
X$548 M1_AXI_ARSIZE[2] \$1141 NWELL PWELL BULK BUF_X1
X$554 M1_AXI_ARADDR[18] \$2074 NWELL PWELL BULK BUF_X1
X$560 M1_AXI_ARADDR[30] \$2328 NWELL PWELL BULK BUF_X1
X$568 M1_AXI_ARADDR[13] \$1178 NWELL PWELL BULK CLKBUF_X2
X$574 M1_AXI_ARADDR[15] \$2082 NWELL PWELL BULK BUF_X1
X$580 M1_AXI_ARADDR[4] \$4334 NWELL PWELL BULK BUF_X1
X$586 M1_AXI_ARADDR[21] \$3194 NWELL PWELL BULK BUF_X1
X$592 M1_AXI_ARADDR[5] \$1789 NWELL PWELL BULK BUF_X1
X$598 M0_AXI_ARSIZE[0] \$947 NWELL PWELL BULK BUF_X1
X$604 M1_AXI_ARADDR[12] \$399 NWELL PWELL BULK BUF_X1
X$610 M0_AXI_ARADDR[21] \$2101 NWELL PWELL BULK BUF_X1
X$616 M0_AXI_ARADDR[18] \$2105 NWELL PWELL BULK BUF_X1
X$622 M1_AXI_ARBURST[1] \$3033 NWELL PWELL BULK BUF_X1
X$628 M0_AXI_ARADDR[24] \$2106 NWELL PWELL BULK BUF_X1
X$634 M1_AXI_ARADDR[1] \$559 NWELL PWELL BULK BUF_X1
X$640 M1_AXI_ARADDR[11] \$1797 NWELL PWELL BULK BUF_X1
X$646 M0_AXI_ARADDR[29] \$2098 NWELL PWELL BULK BUF_X1
X$654 M0_AXI_ARADDR[19] \$2119 NWELL PWELL BULK BUF_X1
X$660 M0_AXI_ARADDR[27] \$2339 NWELL PWELL BULK BUF_X1
X$666 M0_AXI_ARADDR[26] \$2112 NWELL PWELL BULK BUF_X1
X$672 M0_AXI_ARADDR[3] \$2111 NWELL PWELL BULK BUF_X1
X$678 M0_AXI_ARADDR[28] \$3196 NWELL PWELL BULK BUF_X1
X$684 M0_AXI_ARSIZE[2] \$944 NWELL PWELL BULK BUF_X1
X$690 M1_AXI_ARADDR[14] \$954 NWELL PWELL BULK CLKBUF_X2
X$696 M1_AXI_ARLEN[2] \$1237 NWELL PWELL BULK CLKBUF_X2
X$702 \$1321 S2_AXI_ARADDR[6] NWELL PWELL BULK BUF_X1
X$708 \$1604 S2_AXI_ARSIZE[0] NWELL PWELL BULK BUF_X1
X$714 \$828 S2_AXI_ARADDR[9] NWELL PWELL BULK BUF_X1
X$720 \$832 S2_AXI_ARADDR[8] NWELL PWELL BULK BUF_X1
X$726 \$839 S2_AXI_ARADDR[7] NWELL PWELL BULK BUF_X1
X$732 M1_AXI_ARSIZE[1] \$1305 NWELL PWELL BULK BUF_X1
X$738 M0_AXI_ARADDR[20] \$1234 NWELL PWELL BULK CLKBUF_X2
X$744 M0_AXI_ARADDR[5] \$2625 NWELL PWELL BULK BUF_X1
X$752 M0_AXI_ARBURST[0] \$398 NWELL PWELL BULK BUF_X1
X$758 M0_AXI_ARADDR[16] \$2134 NWELL PWELL BULK BUF_X1
X$764 M0_AXI_ARADDR[17] \$1257 NWELL PWELL BULK BUF_X1
X$770 M0_AXI_ARADDR[12] \$1246 NWELL PWELL BULK BUF_X1
X$776 M0_AXI_ARADDR[23] \$1606 NWELL PWELL BULK BUF_X1
X$782 M0_AXI_ARADDR[6] \$4677 NWELL PWELL BULK BUF_X1
X$788 M0_AXI_ARADDR[30] \$2168 NWELL PWELL BULK BUF_X1
X$794 M0_AXI_ARADDR[7] \$563 NWELL PWELL BULK BUF_X1
X$800 M0_AXI_ARADDR[2] \$1314 NWELL PWELL BULK BUF_X1
X$808 M2_AXI_ARLEN[0] \$1259 NWELL PWELL BULK CLKBUF_X2
X$814 M2_AXI_ARADDR[5] \$956 NWELL PWELL BULK BUF_X1
X$820 M0_AXI_ARADDR[25] \$958 NWELL PWELL BULK BUF_X1
X$826 M0_AXI_ARADDR[31] \$401 NWELL PWELL BULK BUF_X1
X$832 M2_AXI_ARADDR[13] \$1643 NWELL PWELL BULK CLKBUF_X2
X$838 M2_AXI_ARLEN[4] \$1270 NWELL PWELL BULK CLKBUF_X2
X$844 M2_AXI_ARADDR[2] \$2350 NWELL PWELL BULK BUF_X1
X$850 M2_AXI_ARADDR[18] \$1268 NWELL PWELL BULK BUF_X1
X$856 M0_AXI_ARADDR[22] \$1276 NWELL PWELL BULK BUF_X1
X$862 M2_AXI_ARADDR[19] \$1275 NWELL PWELL BULK BUF_X1
X$868 M2_AXI_ARADDR[26] \$565 NWELL PWELL BULK BUF_X1
X$874 M2_AXI_ARADDR[27] \$1817 NWELL PWELL BULK BUF_X1
X$880 M2_AXI_ARADDR[3] \$564 NWELL PWELL BULK BUF_X1
X$886 M0_AXI_ARADDR[8] \$1821 NWELL PWELL BULK BUF_X1
X$892 M2_AXI_ARADDR[30] \$2206 NWELL PWELL BULK BUF_X1
X$902 M0_AXI_ARLEN[3] \$895 NWELL PWELL BULK BUF_X2
X$904 M2_AXI_ARADDR[29] \$404 NWELL PWELL BULK BUF_X1
X$910 M2_AXI_ARID[0] \$566 NWELL PWELL BULK BUF_X2
X$916 M2_AXI_ARLEN[1] \$907 NWELL PWELL BULK BUF_X2
X$922 M2_AXI_ARADDR[22] \$1829 NWELL PWELL BULK BUF_X1
X$928 M2_AXI_ARADDR[24] \$1679 NWELL PWELL BULK BUF_X1
X$934 M2_AXI_ARADDR[25] \$2355 NWELL PWELL BULK BUF_X1
X$940 M2_AXI_ARADDR[9] \$1823 NWELL PWELL BULK BUF_X1
X$946 M0_AXI_ARADDR[13] \$1260 NWELL PWELL BULK CLKBUF_X2
X$952 M0_AXI_ARADDR[4] \$1333 NWELL PWELL BULK BUF_X1
X$958 M0_AXI_ARADDR[14] \$913 NWELL PWELL BULK BUF_X2
X$964 M2_AXI_ARADDR[7] \$964 NWELL PWELL BULK BUF_X1
X$974 M0_AXI_ARSIZE[1] \$567 NWELL PWELL BULK BUF_X1
X$976 M2_AXI_ARADDR[16] \$1698 NWELL PWELL BULK BUF_X1
X$982 M2_AXI_ARADDR[28] \$2361 NWELL PWELL BULK BUF_X1
X$988 M2_AXI_ARADDR[31] \$1254 NWELL PWELL BULK BUF_X1
X$994 M2_AXI_ARADDR[1] \$1231 NWELL PWELL BULK BUF_X1
X$1000 M2_AXI_ARADDR[15] \$1693 NWELL PWELL BULK BUF_X1
X$1010 M2_AXI_ARADDR[23] \$406 NWELL PWELL BULK BUF_X1
X$1012 M2_AXI_ARADDR[12] \$1340 NWELL PWELL BULK BUF_X1
X$1018 M2_AXI_ARADDR[8] \$2237 NWELL PWELL BULK BUF_X1
X$1024 M0_AXI_ARADDR[11] \$1342 NWELL PWELL BULK BUF_X1
X$1030 M2_AXI_ARADDR[17] \$1244 NWELL PWELL BULK CLKBUF_X2
X$1036 M2_AXI_ARADDR[14] \$1251 NWELL PWELL BULK CLKBUF_X2
X$1042 M0_AXI_ARBURST[1] \$2717 NWELL PWELL BULK BUF_X1
X$1048 M2_AXI_ARSIZE[0] \$1341 NWELL PWELL BULK BUF_X1
X$1054 M0_AXI_ARADDR[10] \$2375 NWELL PWELL BULK BUF_X1
X$1060 M0_AXI_ARADDR[1] \$1837 NWELL PWELL BULK BUF_X1
X$1070 M0_AXI_ARADDR[0] \$970 NWELL PWELL BULK BUF_X1
X$1072 M0_AXI_ARLEN[7] \$890 NWELL PWELL BULK BUF_X2
X$1078 \$2729 S2_AXI_ARADDR[19] NWELL PWELL BULK BUF_X1
X$1084 \$2723 S2_AXI_ARADDR[23] NWELL PWELL BULK BUF_X1
X$1090 M2_AXI_ARADDR[6] \$3500 NWELL PWELL BULK BUF_X1
X$1096 \$2730 S2_AXI_ARADDR[22] NWELL PWELL BULK BUF_X1
X$1102 \$2245 S2_AXI_ARADDR[5] NWELL PWELL BULK BUF_X1
X$1108 \$885 S2_AXI_ARADDR[26] NWELL PWELL BULK BUF_X1
X$1114 M2_AXI_ARADDR[20] \$1239 NWELL PWELL BULK CLKBUF_X2
X$1120 \$2273 S2_AXI_ARADDR[3] NWELL PWELL BULK BUF_X1
X$1126 \$896 S2_AXI_ARADDR[2] NWELL PWELL BULK BUF_X1
X$1132 \$880 S2_AXI_ARADDR[31] NWELL PWELL BULK BUF_X1
X$1138 M0_AXI_ARADDR[9] \$974 NWELL PWELL BULK BUF_X1
X$1144 M2_AXI_ARBURST[0] \$571 NWELL PWELL BULK BUF_X1
X$1150 M2_AXI_ARADDR[0] \$1770 NWELL PWELL BULK BUF_X1
X$1156 \$510 S2_AXI_ARADDR[25] NWELL PWELL BULK BUF_X1
X$1162 \$860 S0_AXI_ARLEN[4] NWELL PWELL BULK BUF_X1
X$1168 M2_AXI_ARADDR[4] \$1737 NWELL PWELL BULK BUF_X1
X$1174 M2_AXI_ARADDR[21] \$1749 NWELL PWELL BULK BUF_X1
X$1180 \$529 S0_AXI_ARLEN[1] NWELL PWELL BULK BUF_X1
X$1186 \$570 S0_AXI_RREADY NWELL PWELL BULK BUF_X1
X$1192 \$1760 S2_AXI_ARADDR[28] NWELL PWELL BULK BUF_X1
X$1198 \$572 S0_AXI_ARADDR[3] NWELL PWELL BULK BUF_X1
X$1204 \$528 S0_AXI_ARLEN[0] NWELL PWELL BULK BUF_X1
X$1210 \$861 S2_AXI_ARADDR[29] NWELL PWELL BULK BUF_X1
X$1216 \$2762 S2_AXI_ARADDR[30] NWELL PWELL BULK BUF_X1
X$1222 M2_AXI_ARBURST[1] \$2205 NWELL PWELL BULK BUF_X1
X$1228 \$1848 S2_AXI_ARADDR[1] NWELL PWELL BULK BUF_X1
X$1234 \$2271 S2_AXI_ARADDR[24] NWELL PWELL BULK BUF_X1
X$1240 \$2779 S2_AXI_ARADDR[20] NWELL PWELL BULK BUF_X1
X$1246 M2_AXI_ARID[2] \$407 NWELL PWELL BULK CLKBUF_X2
X$1252 M2_AXI_ARLEN[3] \$1210 NWELL PWELL BULK CLKBUF_X2
X$1258 \$1349 S2_AXI_ARADDR[27] NWELL PWELL BULK BUF_X1
X$1264 M2_AXI_ARLEN[6] \$1208 NWELL PWELL BULK CLKBUF_X2
X$1270 \$844 S2_AXI_ARADDR[14] NWELL PWELL BULK BUF_X1
X$1276 M2_AXI_ARSIZE[2] \$408 NWELL PWELL BULK BUF_X1
X$1282 \$838 S2_AXI_ARADDR[16] NWELL PWELL BULK BUF_X1
X$1288 \$2787 S2_AXI_ARADDR[15] NWELL PWELL BULK BUF_X1
X$1294 M2_AXI_ARID[3] \$1184 NWELL PWELL BULK CLKBUF_X2
X$1300 \$836 S0_AXI_ARBURST[0] NWELL PWELL BULK BUF_X1
X$1306 \$830 S0_AXI_ARADDR[26] NWELL PWELL BULK BUF_X1
X$1312 \$2794 S0_AXI_ARADDR[22] NWELL PWELL BULK BUF_X1
X$1318 \$1354 S0_AXI_ARADDR[8] NWELL PWELL BULK BUF_X1
X$1324 \$2799 S2_AXI_ARADDR[12] NWELL PWELL BULK BUF_X1
X$1330 S0_AXI_RVALID \$2242 NWELL PWELL BULK BUF_X1
X$1340 M2_AXI_ARSIZE[1] \$983 NWELL PWELL BULK BUF_X1
X$1346 M2_AXI_ARLEN[2] \$1179 NWELL PWELL BULK CLKBUF_X2
X$1348 \$985 S2_AXI_ARADDR[4] NWELL PWELL BULK BUF_X1
X$1354 \$3546 S0_AXI_ARADDR[28] NWELL PWELL BULK BUF_X1
X$1360 \$1722 S2_AXI_ARADDR[18] NWELL PWELL BULK BUF_X1
X$1366 M2_AXI_ARADDR[10] \$1174 NWELL PWELL BULK BUF_X1
X$1372 M2_AXI_ARADDR[11] \$786 NWELL PWELL BULK BUF_X1
X$1378 \$1858 S0_AXI_ARADDR[29] NWELL PWELL BULK BUF_X1
X$1384 \$1855 S2_AXI_ARADDR[21] NWELL PWELL BULK BUF_X1
X$1390 \$2821 S0_AXI_ARID[0] NWELL PWELL BULK BUF_X1
X$1396 \$2828 S0_AXI_ARADDR[19] NWELL PWELL BULK BUF_X1
X$1402 M2_AXI_ARLEN[5] \$1167 NWELL PWELL BULK CLKBUF_X2
X$1408 \$800 S0_AXI_ARADDR[25] NWELL PWELL BULK BUF_X1
X$1414 \$2831 S0_AXI_ARADDR[24] NWELL PWELL BULK BUF_X1
X$1420 \$798 S0_AXI_ARLEN[6] NWELL PWELL BULK BUF_X1
X$1426 \$1155 S0_AXI_ARADDR[2] NWELL PWELL BULK BUF_X1
X$1432 \$770 S2_AXI_ARADDR[0] NWELL PWELL BULK BUF_X1
X$1438 \$2834 S2_AXI_ARADDR[17] NWELL PWELL BULK BUF_X1
X$1444 M2_AXI_ARLEN[7] \$1156 NWELL PWELL BULK CLKBUF_X2
X$1450 M2_AXI_ARID[1] \$1138 NWELL PWELL BULK CLKBUF_X2
X$1456 \$2830 S0_AXI_ARADDR[13] NWELL PWELL BULK BUF_X1
X$1462 \$776 S0_AXI_ARLEN[2] NWELL PWELL BULK BUF_X1
X$1468 \$2152 S0_AXI_ARADDR[5] NWELL PWELL BULK BUF_X1
X$1474 \$769 S0_AXI_ARADDR[20] NWELL PWELL BULK BUF_X1
X$1480 \$782 S0_AXI_ARADDR[31] NWELL PWELL BULK BUF_X1
X$1486 \$2817 S0_AXI_ARADDR[30] NWELL PWELL BULK BUF_X1
X$1492 \$778 S0_AXI_ARADDR[27] NWELL PWELL BULK BUF_X1
X$1498 \$777 S0_AXI_ARSIZE[0] NWELL PWELL BULK BUF_X1
X$1504 \$3259 S0_AXI_ARADDR[6] NWELL PWELL BULK BUF_X1
X$1510 \$783 S0_AXI_ARID[2] NWELL PWELL BULK BUF_X1
X$1516 \$409 S2_AXI_ARADDR[10] NWELL PWELL BULK BUF_X1
X$1522 \$775 S0_AXI_ARADDR[16] NWELL PWELL BULK BUF_X1
X$1528 \$2151 S2_AXI_ARADDR[13] NWELL PWELL BULK BUF_X1
X$1534 \$756 S0_AXI_ARADDR[12] NWELL PWELL BULK BUF_X1
X$1540 \$3810 S0_AXI_ARSIZE[2] NWELL PWELL BULK BUF_X1
X$1546 \$1878 S2_AXI_ARADDR[11] NWELL PWELL BULK BUF_X1
X$1552 \$763 S0_AXI_ARADDR[14] NWELL PWELL BULK BUF_X1
X$1558 \$2767 S0_AXI_ARADDR[4] NWELL PWELL BULK BUF_X1
X$1566 \$759 S0_AXI_ARADDR[17] NWELL PWELL BULK BUF_X1
X$1572 \$1376 S0_AXI_ARADDR[15] NWELL PWELL BULK BUF_X1
X$1578 \$2792 S0_AXI_ARVALID NWELL PWELL BULK BUF_X1
X$1584 S0_AXI_ARREADY \$1125 NWELL PWELL BULK CLKBUF_X2
X$1590 \$2124 S0_AXI_ARADDR[21] NWELL PWELL BULK BUF_X1
X$1596 \$3263 S0_AXI_ARADDR[18] NWELL PWELL BULK BUF_X1
X$1602 \$2776 S0_AXI_ARADDR[1] NWELL PWELL BULK BUF_X1
X$1608 \$749 S1_AXI_ARID[0] NWELL PWELL BULK BUF_X1
X$1614 \$2121 S0_AXI_ARLEN[7] NWELL PWELL BULK BUF_X1
X$1620 \$1382 S1_AXI_ARLEN[1] NWELL PWELL BULK BUF_X1
X$1626 \$2113 S0_AXI_ARID[4] NWELL PWELL BULK BUF_X1
X$1632 \$3267 S1_AXI_ARADDR[24] NWELL PWELL BULK BUF_X1
X$1638 \$729 S1_AXI_ARADDR[19] NWELL PWELL BULK BUF_X1
X$1646 \$2741 S0_AXI_ARADDR[23] NWELL PWELL BULK BUF_X1
X$1652 \$2748 S1_AXI_ARADDR[20] NWELL PWELL BULK BUF_X1
X$1658 \$2104 S0_AXI_ARADDR[9] NWELL PWELL BULK BUF_X1
X$1664 \$732 S1_AXI_ARADDR[2] NWELL PWELL BULK BUF_X1
X$1670 \$1611 S1_AXI_ARID[5] NWELL PWELL BULK BUF_X1
X$1676 \$738 S1_AXI_ARADDR[26] NWELL PWELL BULK BUF_X1
X$1682 \$704 S1_AXI_ARADDR[27] NWELL PWELL BULK BUF_X1
X$1688 \$2090 S1_AXI_ARLEN[7] NWELL PWELL BULK BUF_X1
X$1694 \$1882 S0_AXI_ARID[6] NWELL PWELL BULK BUF_X1
X$1700 \$1385 S0_AXI_ARSIZE[1] NWELL PWELL BULK BUF_X1
X$1706 \$717 S1_AXI_ARADDR[9] NWELL PWELL BULK BUF_X1
X$1712 \$712 S0_AXI_ARLEN[5] NWELL PWELL BULK BUF_X1
X$1718 \$726 S0_AXI_ARLEN[3] NWELL PWELL BULK BUF_X1
X$1724 \$2716 S0_AXI_ARADDR[10] NWELL PWELL BULK BUF_X1
X$1730 \$2072 S1_AXI_ARADDR[18] NWELL PWELL BULK BUF_X1
X$1736 \$2052 S0_AXI_ARID[3] NWELL PWELL BULK BUF_X1
X$1742 \$711 S1_AXI_ARADDR[16] NWELL PWELL BULK BUF_X1
X$1748 \$415 S1_AXI_ARADDR[29] NWELL PWELL BULK BUF_X1
X$1754 \$710 S0_AXI_ARADDR[0] NWELL PWELL BULK BUF_X1
X$1760 \$705 S1_AXI_ARLEN[5] NWELL PWELL BULK BUF_X1
X$1766 \$2071 S1_AXI_ARBURST[0] NWELL PWELL BULK BUF_X1
X$1772 \$1571 S1_AXI_ARID[2] NWELL PWELL BULK BUF_X1
X$1778 \$701 S1_AXI_ARID[4] NWELL PWELL BULK BUF_X1
X$1784 \$2042 S1_AXI_ARLEN[6] NWELL PWELL BULK BUF_X1
X$1790 \$2056 S0_AXI_ARID[5] NWELL PWELL BULK BUF_X1
X$1796 \$2701 S1_AXI_ARADDR[6] NWELL PWELL BULK BUF_X1
X$1802 \$2688 S1_AXI_ARADDR[25] NWELL PWELL BULK BUF_X1
X$1808 \$2702 S1_AXI_ARADDR[30] NWELL PWELL BULK BUF_X1
X$1814 \$2040 S1_AXI_ARLEN[4] NWELL PWELL BULK BUF_X1
X$1820 \$1891 S1_AXI_ARADDR[23] NWELL PWELL BULK BUF_X1
X$1826 \$680 S1_AXI_ARADDR[11] NWELL PWELL BULK BUF_X1
X$1832 \$672 S1_AXI_ARADDR[22] NWELL PWELL BULK BUF_X1
X$1838 \$2415 S0_AXI_ARADDR[7] NWELL PWELL BULK BUF_X1
X$1844 \$676 S1_AXI_ARADDR[14] NWELL PWELL BULK BUF_X1
X$1850 \$1398 S1_AXI_ARBURST[1] NWELL PWELL BULK BUF_X1
X$1856 \$586 S1_AXI_ARADDR[1] NWELL PWELL BULK BUF_X1
X$1862 \$1005 S0_AXI_ARBURST[1] NWELL PWELL BULK BUF_X1
X$1868 \$1904 S1_AXI_ARADDR[8] NWELL PWELL BULK BUF_X1
X$1874 \$1067 S1_AXI_ARADDR[5] NWELL PWELL BULK BUF_X1
X$1880 \$2029 S1_AXI_ARADDR[12] NWELL PWELL BULK BUF_X1
X$1886 \$674 S0_AXI_ARADDR[11] NWELL PWELL BULK BUF_X1
X$1892 \$434 S1_AXI_ARSIZE[0] NWELL PWELL BULK BUF_X1
X$1898 \$587 S1_AXI_ARADDR[3] NWELL PWELL BULK BUF_X1
X$1904 \$1053 S1_AXI_ARADDR[7] NWELL PWELL BULK BUF_X1
X$1910 \$2013 S1_AXI_ARLEN[0] NWELL PWELL BULK BUF_X1
X$1916 \$2015 S1_AXI_ARADDR[28] NWELL PWELL BULK BUF_X1
X$1922 \$591 S1_AXI_ARADDR[4] NWELL PWELL BULK BUF_X1
X$1928 \$660 S1_AXI_ARADDR[31] NWELL PWELL BULK BUF_X1
X$1934 \$656 S1_AXI_ARADDR[15] NWELL PWELL BULK BUF_X1
X$1940 \$649 S2_AXI_ARID[7] NWELL PWELL BULK BUF_X1
X$1946 \$2429 S1_AXI_ARSIZE[1] NWELL PWELL BULK BUF_X1
X$1952 \$589 S2_AXI_ARBURST[0] NWELL PWELL BULK BUF_X1
X$1958 S2_AXI_BVALID \$1047 NWELL PWELL BULK BUF_X1
X$1964 \$1408 S2_AXI_ARID[6] NWELL PWELL BULK BUF_X1
X$1970 \$2001 S2_AXI_ARSIZE[1] NWELL PWELL BULK BUF_X1
X$1976 \$1411 S2_AXI_BREADY NWELL PWELL BULK BUF_X1
X$1982 \$646 S2_AXI_ARID[5] NWELL PWELL BULK BUF_X1
X$1988 \$1021 S1_AXI_ARSIZE[2] NWELL PWELL BULK BUF_X1
X$1996 \$642 S2_AXI_ARID[4] NWELL PWELL BULK BUF_X1
X$2000 S1_AXI_BVALID \$1038 NWELL PWELL BULK BUF_X1
X$2006 \$1416 S1_AXI_ARID[7] NWELL PWELL BULK BUF_X1
X$2012 \$4050 S2_AXI_ARSIZE[2] NWELL PWELL BULK BUF_X1
X$2018 \$1948 S1_AXI_ARADDR[10] NWELL PWELL BULK BUF_X1
X$2024 \$625 S1_AXI_BREADY NWELL PWELL BULK BUF_X1
X$2030 \$592 S2_AXI_ARBURST[1] NWELL PWELL BULK BUF_X1
X$2036 \$1937 S1_AXI_ARADDR[0] NWELL PWELL BULK BUF_X1
X$2042 S1_AXI_BID[5] \$1452 NWELL PWELL BULK BUF_X1
X$2048 S1_AXI_BID[0] \$1023 NWELL PWELL BULK BUF_X1
X$2054 S1_AXI_BID[4] \$4406 NWELL PWELL BULK BUF_X1
X$2060 S1_AXI_BRESP[0] \$1024 NWELL PWELL BULK BUF_X1
X$2066 S1_AXI_BID[1] \$1921 NWELL PWELL BULK BUF_X1
X$2072 S1_AXI_BID[2] \$2451 NWELL PWELL BULK BUF_X1
X$2078 S1_AXI_BID[3] \$1025 NWELL PWELL BULK BUF_X1
X$2084 S1_AXI_BRESP[1] \$1029 NWELL PWELL BULK BUF_X1
X$2090 \$599 M1_AXI_BVALID NWELL PWELL BULK BUF_X1
X$2096 M1_AXI_BREADY \$420 NWELL PWELL BULK BUF_X1
X$2103 \$387 \$1435 NWELL PWELL BULK INV_X1
X$2105 \$388 \$1774 \$1285 \$1932 \$1289 NWELL PWELL BULK NOR4_X1
X$2107 \$628 \$388 NWELL PWELL BULK INV_X1
X$2112 \$2482 \$2301 \$389 \$1931 NWELL PWELL BULK MUX2_X1
X$2115 \$1776 \$1777 \$389 \$1946 NWELL PWELL BULK MUX2_X1
X$2117 \$1058 \$394 \$389 \$1055 NWELL PWELL BULK MUX2_X1
X$2119 \$389 \$445 \$1061 \$1462 NWELL PWELL BULK MUX2_X1
X$2125 \$390 \$438 \$456 \$547 \$928 NWELL PWELL BULK NOR4_X1
X$2130 \$448 \$552 \$1294 \$391 \$1081 NWELL PWELL BULK NOR4_X1
X$2134 \$932 \$393 \$1090 \$428 \$1476 NWELL PWELL BULK NOR4_X1
X$2138 \$22528 \$394 \$21365 \$22863 NWELL PWELL BULK MUX2_X1
X$2141 \$5419 \$394 \$1104 \$5530 NWELL PWELL BULK MUX2_X1
X$2145 \$3933 \$394 \$1783 \$4426 NWELL PWELL BULK MUX2_X1
X$2149 \$6037 \$394 \$2027 \$6158 NWELL PWELL BULK MUX2_X1
X$2151 \$7241 \$394 \$2320 \$7095 NWELL PWELL BULK MUX2_X1
X$2154 \$8846 \$394 \$2051 \$9210 NWELL PWELL BULK MUX2_X1
X$2157 \$24678 \$394 \$24153 \$24351 NWELL PWELL BULK MUX2_X1
X$2159 \$22510 \$394 \$21771 \$22509 NWELL PWELL BULK MUX2_X1
X$2162 \$25870 \$394 \$25336 \$26135 NWELL PWELL BULK MUX2_X1
X$2165 \$557 \$394 \$559 \$1129 NWELL PWELL BULK MUX2_X1
X$2168 \$9849 \$394 \$2082 \$9844 NWELL PWELL BULK MUX2_X1
X$2171 \$16908 \$394 \$2033 \$16461 NWELL PWELL BULK MUX2_X1
X$2174 \$9351 \$394 \$1524 \$9696 NWELL PWELL BULK MUX2_X1
X$2176 \$13175 \$394 \$2328 \$13172 NWELL PWELL BULK MUX2_X1
X$2178 \$12010 \$394 \$2007 \$12317 NWELL PWELL BULK MUX2_X1
X$2180 \$21366 \$23176 \$21785 \$394 NWELL PWELL BULK AND3_X4
X$2182 \$21372 \$394 \$1237 \$21373 NWELL PWELL BULK MUX2_X1
X$2184 \$27260 \$394 \$24441 \$27259 NWELL PWELL BULK MUX2_X1
X$2187 \$11373 \$394 \$1796 \$11572 NWELL PWELL BULK MUX2_X1
X$2189 \$12014 \$394 \$2030 \$12630 NWELL PWELL BULK MUX2_X1
X$2191 \$14984 \$394 \$1169 \$14713 NWELL PWELL BULK MUX2_X1
X$2194 \$15314 \$394 \$3194 \$16084 NWELL PWELL BULK MUX2_X1
X$2196 \$6549 \$394 \$942 \$7253 NWELL PWELL BULK MUX2_X1
X$2198 \$11561 \$394 \$2025 \$11562 NWELL PWELL BULK MUX2_X1
X$2200 \$8032 \$394 \$1987 \$8490 NWELL PWELL BULK MUX2_X1
X$2202 \$7860 \$394 \$2063 \$8049 NWELL PWELL BULK MUX2_X1
X$2204 \$19104 \$394 \$954 \$19949 NWELL PWELL BULK MUX2_X1
X$2207 \$16627 \$394 \$1128 \$17374 NWELL PWELL BULK MUX2_X1
X$2210 \$19441 \$394 \$1178 \$19934 NWELL PWELL BULK MUX2_X1
X$2213 \$671 \$394 \$449 \$1079 NWELL PWELL BULK MUX2_X1
X$2215 \$2036 \$394 \$1305 \$2553 NWELL PWELL BULK MUX2_X1
X$2217 \$26676 \$394 \$24429 \$26368 NWELL PWELL BULK MUX2_X1
X$2220 \$21195 \$394 \$18748 \$20662 NWELL PWELL BULK MUX2_X1
X$2222 \$26694 \$394 \$25877 \$26700 NWELL PWELL BULK MUX2_X1
X$2225 \$22030 \$394 \$22226 \$22026 NWELL PWELL BULK MUX2_X1
X$2227 \$7106 \$394 \$3589 \$7264 NWELL PWELL BULK MUX2_X1
X$2229 \$23457 \$394 \$23744 \$23164 NWELL PWELL BULK MUX2_X1
X$2231 \$8526 \$394 \$399 \$8857 NWELL PWELL BULK MUX2_X1
X$2233 \$6566 \$394 \$4334 \$6042 NWELL PWELL BULK MUX2_X1
X$2235 \$1110 \$394 \$554 \$1101 NWELL PWELL BULK MUX2_X1
X$2238 \$20832 \$394 \$19682 \$20655 NWELL PWELL BULK MUX2_X1
X$2241 \$4489 \$394 \$3033 \$3947 NWELL PWELL BULK MUX2_X1
X$2243 \$3184 \$394 \$1797 \$3182 NWELL PWELL BULK MUX2_X1
X$2245 \$4454 \$394 \$1141 \$4108 NWELL PWELL BULK MUX2_X1
X$2247 \$4119 \$394 \$1789 \$4112 NWELL PWELL BULK MUX2_X1
X$2250 \$15576 \$394 \$1126 \$15573 NWELL PWELL BULK MUX2_X1
X$2252 \$5551 \$394 \$2558 \$5556 NWELL PWELL BULK MUX2_X1
X$2267 \$17399 \$394 \$2074 \$17796 NWELL PWELL BULK MUX2_X1
X$2288 \$5866 \$394 \$4996 \$5429 NWELL PWELL BULK MUX2_X1
X$2327 \$1290 \$395 \$1978 \$1972 \$448 NWELL PWELL BULK OR4_X1
X$2333 \$1168 \$403 \$398 \$1165 NWELL PWELL BULK MUX2_X1
X$2336 \$1572 \$916 \$398 \$1311 NWELL PWELL BULK MUX2_X1
X$2338 \$398 \$1308 \$1172 \$1177 NWELL PWELL BULK MUX2_X1
X$2341 \$398 \$1242 \$1199 \$797 NWELL PWELL BULK MUX2_X1
X$2346 \$399 \$445 \$8076 \$7865 NWELL PWELL BULK MUX2_X1
X$2349 \$7863 \$1785 \$399 \$8063 NWELL PWELL BULK MUX2_X1
X$2351 \$7864 \$2313 \$399 \$8521 NWELL PWELL BULK MUX2_X1
X$2366 \$400 \$808 \$951 \$952 NWELL PWELL BULK DFF_X1
X$2368 \$400 \$405 \$1597 \$1228 NWELL PWELL BULK MUX2_X1
X$2370 \$401 \$1242 \$11241 \$10981 NWELL PWELL BULK MUX2_X1
X$2373 \$9872 \$7143 \$401 \$9870 NWELL PWELL BULK MUX2_X1
X$2375 \$10509 \$916 \$401 \$10844 NWELL PWELL BULK MUX2_X1
X$2377 \$401 \$1308 \$9880 \$10152 NWELL PWELL BULK MUX2_X1
X$2383 \$4981 \$403 \$2717 \$4980 NWELL PWELL BULK MUX2_X1
X$2385 \$7868 \$403 \$2339 \$8099 NWELL PWELL BULK MUX2_X1
X$2388 \$7578 \$403 \$2106 \$7751 NWELL PWELL BULK MUX2_X1
X$2390 \$10141 \$403 \$3196 \$9973 NWELL PWELL BULK MUX2_X1
X$2392 \$761 \$403 \$944 \$1157 NWELL PWELL BULK MUX2_X1
X$2395 \$808 \$403 \$1314 \$951 NWELL PWELL BULK MUX2_X1
X$2397 \$2598 \$403 \$2625 \$2591 NWELL PWELL BULK MUX2_X1
X$2399 \$11374 \$403 \$9459 \$11934 NWELL PWELL BULK MUX2_X1
X$2401 \$13448 \$403 \$2119 \$13667 NWELL PWELL BULK MUX2_X1
X$2404 \$1696 \$403 \$567 \$2234 NWELL PWELL BULK MUX2_X1
X$2406 \$3502 \$403 \$1837 \$3505 NWELL PWELL BULK MUX2_X1
X$2408 \$1269 \$403 \$1333 \$1267 NWELL PWELL BULK MUX2_X1
X$2410 \$3483 \$403 \$1342 \$2369 NWELL PWELL BULK MUX2_X1
X$2412 \$972 \$403 \$970 \$1236 NWELL PWELL BULK MUX2_X1
X$2417 \$8356 \$403 \$2112 \$8354 NWELL PWELL BULK MUX2_X1
X$2420 \$6937 \$403 \$947 \$6580 NWELL PWELL BULK MUX2_X1
X$2422 \$5743 \$403 \$4677 \$5913 NWELL PWELL BULK MUX2_X1
X$2424 \$3790 \$403 \$2111 \$4139 NWELL PWELL BULK MUX2_X1
X$2427 \$5190 \$403 \$1821 \$5195 NWELL PWELL BULK MUX2_X1
X$2429 \$9970 \$403 \$2098 \$10127 NWELL PWELL BULK MUX2_X1
X$2432 \$403 \$7143 NWELL PWELL BULK BUF_X8
X$2434 \$1226 \$403 \$563 \$953 NWELL PWELL BULK MUX2_X1
X$2471 \$404 \$538 \$12393 \$12652 NWELL PWELL BULK MUX2_X1
X$2473 \$404 \$834 \$12657 \$13249 NWELL PWELL BULK MUX2_X1
X$2476 \$12857 \$9707 \$404 \$13239 NWELL PWELL BULK MUX2_X1
X$2478 \$12029 \$2348 \$404 \$11946 NWELL PWELL BULK MUX2_X1
X$2487 \$3503 \$405 \$3509 \$3511 NWELL PWELL BULK MUX2_X1
X$2490 \$8537 \$405 \$8704 \$8539 NWELL PWELL BULK MUX2_X1
X$2492 \$2259 \$405 \$2270 \$2374 NWELL PWELL BULK MUX2_X1
X$2494 \$2296 \$405 \$1347 \$1842 NWELL PWELL BULK MUX2_X1
X$2496 \$7116 \$405 \$6754 \$8116 NWELL PWELL BULK MUX2_X1
X$2498 \$7868 \$405 \$8108 \$8110 NWELL PWELL BULK MUX2_X1
X$2501 \$6793 \$405 \$6795 \$7070 NWELL PWELL BULK MUX2_X1
X$2503 \$1320 \$405 \$2633 \$2154 NWELL PWELL BULK MUX2_X1
X$2505 \$4169 \$405 \$4532 \$3594 NWELL PWELL BULK MUX2_X1
X$2507 \$2600 \$405 \$2856 \$2602 NWELL PWELL BULK MUX2_X1
X$2510 \$4516 \$405 \$3951 \$3590 NWELL PWELL BULK MUX2_X1
X$2513 \$2572 \$405 \$3018 \$2329 NWELL PWELL BULK MUX2_X1
X$2516 \$6024 \$405 \$6691 \$6026 NWELL PWELL BULK MUX2_X1
X$2518 \$12015 \$405 \$11377 \$12017 NWELL PWELL BULK MUX2_X1
X$2521 \$6685 \$405 NWELL PWELL BULK BUF_X16
X$2523 \$11380 \$405 \$11605 \$11608 NWELL PWELL BULK MUX2_X1
X$2525 \$4982 \$405 \$5338 \$5695 NWELL PWELL BULK MUX2_X1
X$2527 \$11374 \$405 \$11208 \$11943 NWELL PWELL BULK MUX2_X1
X$2529 \$2671 \$405 \$1831 \$2219 NWELL PWELL BULK MUX2_X1
X$2532 \$899 \$405 \$962 \$963 NWELL PWELL BULK MUX2_X1
X$2534 \$2371 \$405 \$2874 \$3497 NWELL PWELL BULK MUX2_X1
X$2537 \$2224 \$405 \$2365 \$2697 NWELL PWELL BULK MUX2_X1
X$2539 \$4278 \$405 \$3618 \$3928 NWELL PWELL BULK MUX2_X1
X$2541 \$918 \$405 \$967 \$968 NWELL PWELL BULK MUX2_X1
X$2543 \$1729 \$405 \$2734 \$2742 NWELL PWELL BULK MUX2_X1
X$2546 \$5917 \$405 \$5744 \$5436 NWELL PWELL BULK MUX2_X1
X$2548 \$1794 \$405 \$2567 \$2579 NWELL PWELL BULK MUX2_X1
X$2550 \$2057 \$405 \$1310 \$2578 NWELL PWELL BULK MUX2_X1
X$2553 \$8707 \$405 \$8360 \$9236 NWELL PWELL BULK MUX2_X1
X$2555 \$5211 \$405 \$5007 \$5626 NWELL PWELL BULK MUX2_X1
X$2558 \$2338 \$405 \$2857 \$2620 NWELL PWELL BULK MUX2_X1
X$2561 \$8356 \$405 \$9230 \$9233 NWELL PWELL BULK MUX2_X1
X$2563 \$7578 \$405 \$8092 \$8353 NWELL PWELL BULK MUX2_X1
X$2565 \$6581 \$405 \$6585 \$6586 NWELL PWELL BULK MUX2_X1
X$2567 \$6951 \$405 \$7300 \$6950 NWELL PWELL BULK MUX2_X1
X$2569 \$5001 \$405 \$5610 \$5622 NWELL PWELL BULK MUX2_X1
X$2571 \$3791 \$405 \$4330 \$3804 NWELL PWELL BULK MUX2_X1
X$2573 \$5006 \$405 \$5205 \$5434 NWELL PWELL BULK MUX2_X1
X$2576 \$9970 \$405 \$10496 \$11222 NWELL PWELL BULK MUX2_X1
X$2578 \$12643 \$405 \$12644 \$12924 NWELL PWELL BULK MUX2_X1
X$2580 \$13448 \$405 \$13784 \$13996 NWELL PWELL BULK MUX2_X1
X$2582 \$1325 \$405 \$2158 \$2159 NWELL PWELL BULK MUX2_X1
X$2585 \$1800 \$405 \$2088 \$1802 NWELL PWELL BULK MUX2_X1
X$2635 \$406 \$834 \$7897 \$8208 NWELL PWELL BULK MUX2_X1
X$2638 \$406 \$538 \$8204 \$8610 NWELL PWELL BULK MUX2_X1
X$2640 \$7414 \$976 \$406 \$7141 NWELL PWELL BULK MUX2_X1
X$2643 \$7388 \$1849 \$406 \$7394 NWELL PWELL BULK MUX2_X1
X$2653 \$407 \$538 \$25800 \$25804 NWELL PWELL BULK MUX2_X1
X$2655 \$23234 \$18371 \$407 \$24073 NWELL PWELL BULK MUX2_X1
X$2657 \$407 \$834 \$24063 \$24066 NWELL PWELL BULK MUX2_X1
X$2659 \$24207 \$17204 \$407 \$24837 NWELL PWELL BULK MUX2_X1
X$2669 \$1176 \$976 \$408 \$1175 NWELL PWELL BULK MUX2_X1
X$2671 \$408 \$538 \$1166 \$1163 NWELL PWELL BULK MUX2_X1
X$2673 \$2223 \$1849 \$408 \$1719 NWELL PWELL BULK MUX2_X1
X$2675 \$408 \$834 \$575 \$987 NWELL PWELL BULK MUX2_X1
X$2680 \$8402 \$3964 \$7621 \$409 NWELL PWELL BULK MUX2_X1
X$2687 \$I177761 \$410 \$997 \$996 NWELL PWELL BULK DFF_X1
X$2689 \$410 \$416 \$501 \$997 NWELL PWELL BULK MUX2_X1
X$2692 \$410 \$413 \$1383 \$733 NWELL PWELL BULK MUX2_X1
X$2696 \$I177601 \$412 \$411 \$996 NWELL PWELL BULK DFF_X1
X$2698 \$501 \$414 \$412 \$411 NWELL PWELL BULK MUX2_X1
X$2700 \$412 \$413 \$1388 \$1103 NWELL PWELL BULK MUX2_X1
X$2707 \$6473 \$413 \$6116 \$6117 NWELL PWELL BULK MUX2_X1
X$2710 \$7643 \$413 \$7184 \$7352 NWELL PWELL BULK MUX2_X1
X$2713 \$595 \$413 \$1022 \$1458 NWELL PWELL BULK MUX2_X1
X$2716 \$2419 \$413 \$2420 \$2421 NWELL PWELL BULK MUX2_X1
X$2718 \$4744 \$413 \$4745 \$4041 NWELL PWELL BULK MUX2_X1
X$2720 \$3289 \$413 \$2923 \$2441 NWELL PWELL BULK MUX2_X1
X$2722 \$629 \$413 \$594 \$1020 NWELL PWELL BULK MUX2_X1
X$2726 \$7502 \$413 \$7163 \$6833 NWELL PWELL BULK MUX2_X1
X$2729 \$7479 \$413 \$7165 \$7482 NWELL PWELL BULK MUX2_X1
X$2731 \$5511 \$413 \$5096 \$4756 NWELL PWELL BULK MUX2_X1
X$2734 \$18171 \$413 \$17236 \$17469 NWELL PWELL BULK MUX2_X1
X$2737 \$16057 \$413 \$16537 \$15897 NWELL PWELL BULK MUX2_X1
X$2739 \$1902 \$413 \$2426 \$1015 NWELL PWELL BULK MUX2_X1
X$2742 \$5197 \$413 \$5093 \$5185 NWELL PWELL BULK MUX2_X1
X$2744 \$3284 \$413 \$2989 \$2596 NWELL PWELL BULK MUX2_X1
X$2747 \$2921 \$413 \$3286 \$2428 NWELL PWELL BULK MUX2_X1
X$2749 \$17986 \$413 \$17233 \$15896 NWELL PWELL BULK MUX2_X1
X$2752 \$1000 \$413 \$1390 \$1391 NWELL PWELL BULK MUX2_X1
X$2754 \$6119 \$413 \$6477 \$6193 NWELL PWELL BULK MUX2_X1
X$2757 \$6470 \$413 \$6845 \$6113 NWELL PWELL BULK MUX2_X1
X$2760 \$7934 \$413 \$7935 \$7936 NWELL PWELL BULK MUX2_X1
X$2762 \$6599 \$413 \$6471 \$6216 NWELL PWELL BULK MUX2_X1
X$2764 \$7180 \$413 \$7641 \$7183 NWELL PWELL BULK MUX2_X1
X$2767 \$5814 \$413 \$5627 \$5086 NWELL PWELL BULK MUX2_X1
X$2770 \$11049 \$413 \$10668 \$10357 NWELL PWELL BULK MUX2_X1
X$2773 \$10666 \$413 \$10356 \$10468 NWELL PWELL BULK MUX2_X1
X$2775 \$9136 \$413 \$9138 \$9220 NWELL PWELL BULK MUX2_X1
X$2778 \$9134 \$413 \$8767 \$8242 NWELL PWELL BULK MUX2_X1
X$2780 \$4757 \$413 \$4405 \$4106 NWELL PWELL BULK MUX2_X1
X$2782 \$12535 \$413 \$12106 \$12107 NWELL PWELL BULK MUX2_X1
X$2784 \$12977 \$413 \$13346 \$12699 NWELL PWELL BULK MUX2_X1
X$2786 \$14191 \$413 \$14498 \$14275 NWELL PWELL BULK MUX2_X1
X$2788 \$14888 \$413 \$15039 \$15040 NWELL PWELL BULK MUX2_X1
X$2791 \$631 \$413 \$635 \$431 NWELL PWELL BULK MUX2_X1
X$2793 \$3663 \$413 \$3664 \$3729 NWELL PWELL BULK MUX2_X1
X$2795 \$2438 \$413 \$2434 \$2440 NWELL PWELL BULK MUX2_X1
X$2797 \$12100 \$413 \$12551 \$12102 NWELL PWELL BULK MUX2_X1
X$2799 \$12972 \$413 \$12974 \$12975 NWELL PWELL BULK MUX2_X1
X$2801 \$8758 \$413 NWELL PWELL BULK BUF_X16
X$2804 \$6961 \$413 \$6837 \$6838 NWELL PWELL BULK MUX2_X1
X$2806 \$8412 \$413 \$8414 \$8920 NWELL PWELL BULK MUX2_X1
X$2808 \$6840 \$413 \$7173 \$6956 NWELL PWELL BULK MUX2_X1
X$2810 \$585 \$413 \$418 \$1006 NWELL PWELL BULK MUX2_X1
X$2812 \$582 \$413 \$1889 \$1087 NWELL PWELL BULK MUX2_X1
X$2814 \$2915 \$413 \$3282 \$3366 NWELL PWELL BULK MUX2_X1
X$2816 \$3280 \$413 \$3279 \$3374 NWELL PWELL BULK MUX2_X1
X$2819 \$5083 \$413 \$5263 \$5252 NWELL PWELL BULK MUX2_X1
X$2821 \$4145 \$413 \$4386 \$4042 NWELL PWELL BULK MUX2_X1
X$2824 \$663 \$413 \$1540 \$1404 NWELL PWELL BULK MUX2_X1
X$2826 \$1405 \$413 \$590 \$1063 NWELL PWELL BULK MUX2_X1
X$2885 \$1396 \$414 \$631 \$1507 NWELL PWELL BULK MUX2_X1
X$2887 \$17808 \$414 \$18398 \$18624 NWELL PWELL BULK MUX2_X1
X$2889 \$11032 \$414 \$11420 \$12597 NWELL PWELL BULK MUX2_X1
X$2891 \$16697 \$414 \$16262 \$17106 NWELL PWELL BULK MUX2_X1
X$2894 \$4402 \$414 \$4757 \$4812 NWELL PWELL BULK MUX2_X1
X$2896 \$13827 \$414 \$14180 \$14486 NWELL PWELL BULK MUX2_X1
X$2898 \$23586 \$414 \$23947 \$24231 NWELL PWELL BULK MUX2_X1
X$2901 \$4018 \$414 \$4145 \$3756 NWELL PWELL BULK MUX2_X1
X$2904 \$13832 \$414 \$14492 \$14184 NWELL PWELL BULK MUX2_X1
X$2907 \$2912 \$414 \$2915 \$3003 NWELL PWELL BULK MUX2_X1
X$2909 \$2916 \$414 \$2921 \$2919 NWELL PWELL BULK MUX2_X1
X$2911 \$1353 \$414 \$1405 \$1897 NWELL PWELL BULK MUX2_X1
X$2913 \$20726 \$414 \$21019 \$21016 NWELL PWELL BULK MUX2_X1
X$2915 \$18404 \$414 \$19378 \$19131 NWELL PWELL BULK MUX2_X1
X$2918 \$19137 \$414 \$20135 \$20134 NWELL PWELL BULK MUX2_X1
X$2920 \$23797 \$414 \$23804 \$23803 NWELL PWELL BULK MUX2_X1
X$2922 \$20602 \$414 \$21443 \$21442 NWELL PWELL BULK MUX2_X1
X$2924 \$11424 \$414 \$12694 \$12815 NWELL PWELL BULK MUX2_X1
X$2927 \$9124 \$414 \$9622 \$9625 NWELL PWELL BULK MUX2_X1
X$2929 \$8238 \$414 \$9136 \$9605 NWELL PWELL BULK MUX2_X1
X$2931 \$5032 \$414 \$5511 \$5510 NWELL PWELL BULK MUX2_X1
X$2933 \$6201 \$414 \$6119 \$6198 NWELL PWELL BULK MUX2_X1
X$2936 \$2432 \$414 \$3289 \$3332 NWELL PWELL BULK MUX2_X1
X$2939 \$7408 \$414 \$7643 \$8176 NWELL PWELL BULK MUX2_X1
X$2941 \$12690 \$414 \$13390 \$12968 NWELL PWELL BULK MUX2_X1
X$2943 \$14181 \$414 \$14187 \$14012 NWELL PWELL BULK MUX2_X1
X$2946 \$17231 \$414 \$17480 \$17483 NWELL PWELL BULK MUX2_X1
X$2948 \$15349 \$414 \$16072 \$15888 NWELL PWELL BULK MUX2_X1
X$2950 \$11769 \$414 \$12535 \$12540 NWELL PWELL BULK MUX2_X1
X$2952 \$9728 \$414 \$9750 \$9878 NWELL PWELL BULK MUX2_X1
X$2955 \$9745 \$414 \$10857 \$11254 NWELL PWELL BULK MUX2_X1
X$2958 \$16257 \$414 \$16057 \$16545 NWELL PWELL BULK MUX2_X1
X$2961 \$18369 \$414 \$18418 \$18569 NWELL PWELL BULK MUX2_X1
X$2963 \$19486 \$414 \$19921 \$19924 NWELL PWELL BULK MUX2_X1
X$2965 \$14189 \$414 \$14191 \$14496 NWELL PWELL BULK MUX2_X1
X$2968 \$11321 \$414 \$12972 \$13644 NWELL PWELL BULK MUX2_X1
X$2970 \$10352 \$414 \$11049 \$11219 NWELL PWELL BULK MUX2_X1
X$2972 \$414 \$419 \$613 NWELL PWELL BULK NAND2_X1
X$2974 \$5082 \$414 \$5814 \$5903 NWELL PWELL BULK MUX2_X1
X$2976 \$6734 \$414 \$6599 \$6601 NWELL PWELL BULK MUX2_X1
X$2979 \$6666 \$414 \$7479 \$6964 NWELL PWELL BULK MUX2_X1
X$2981 \$8253 \$414 \$9134 \$9133 NWELL PWELL BULK MUX2_X1
X$2983 \$6669 \$414 \$6840 \$7413 NWELL PWELL BULK MUX2_X1
X$2985 \$463 \$414 \$2419 \$2418 NWELL PWELL BULK MUX2_X1
X$2987 \$476 \$414 \$582 \$1002 NWELL PWELL BULK MUX2_X1
X$2990 \$21872 \$414 \$21873 \$21439 NWELL PWELL BULK MUX2_X1
X$2992 \$19735 \$414 \$20722 \$21210 NWELL PWELL BULK MUX2_X1
X$2995 \$20123 \$414 \$21001 \$21201 NWELL PWELL BULK MUX2_X1
X$2998 \$22324 \$414 \$22327 \$23035 NWELL PWELL BULK MUX2_X1
X$3000 \$22942 \$414 \$22947 \$23269 NWELL PWELL BULK MUX2_X1
X$3002 \$23274 \$23276 \$23911 \$414 NWELL PWELL BULK OR3_X4
X$3005 \$23930 \$414 \$25005 \$25130 NWELL PWELL BULK MUX2_X1
X$3073 \$11238 \$491 \$11421 \$415 NWELL PWELL BULK MUX2_X1
X$3080 \$1902 \$416 \$1396 \$1901 NWELL PWELL BULK MUX2_X1
X$3082 \$3280 \$416 \$2912 \$2913 NWELL PWELL BULK MUX2_X1
X$3085 \$3284 \$416 \$2916 \$2999 NWELL PWELL BULK MUX2_X1
X$3087 \$8412 \$416 \$8238 \$8614 NWELL PWELL BULK MUX2_X1
X$3090 \$416 \$9411 NWELL PWELL BULK BUF_X8
X$3093 \$10666 \$416 \$10352 \$10664 NWELL PWELL BULK MUX2_X1
X$3096 \$7180 \$416 \$7408 \$7743 NWELL PWELL BULK MUX2_X1
X$3098 \$3663 \$416 \$4402 \$4403 NWELL PWELL BULK MUX2_X1
X$3100 \$5197 \$416 \$5032 \$5206 NWELL PWELL BULK MUX2_X1
X$3102 \$6473 \$416 \$6201 \$6924 NWELL PWELL BULK MUX2_X1
X$3104 \$2438 \$416 \$2432 \$1910 NWELL PWELL BULK MUX2_X1
X$3106 \$629 \$416 \$1019 NWELL PWELL BULK OR2_X1
X$3108 \$7934 \$416 \$8253 \$8256 NWELL PWELL BULK MUX2_X1
X$3111 \$6470 \$416 \$6734 \$6469 NWELL PWELL BULK MUX2_X1
X$3113 \$5083 \$416 \$5082 \$5812 NWELL PWELL BULK MUX2_X1
X$3115 \$7502 \$416 \$6666 \$6969 NWELL PWELL BULK MUX2_X1
X$3118 \$6961 \$416 \$6669 \$7169 NWELL PWELL BULK MUX2_X1
X$3121 \$585 \$416 \$463 \$1086 NWELL PWELL BULK MUX2_X1
X$3123 \$4744 \$416 \$4018 \$5277 NWELL PWELL BULK MUX2_X1
X$3125 \$663 \$416 \$1353 \$1073 NWELL PWELL BULK MUX2_X1
X$3127 \$1000 \$416 \$476 \$1099 NWELL PWELL BULK MUX2_X1
X$3151 \$I179082 \$418 \$1074 \$1007 NWELL PWELL BULK DFF_X1
X$3153 \$463 \$1400 \$418 \$1074 NWELL PWELL BULK MUX2_X1
X$3160 \$595 \$419 NWELL PWELL BULK INV_X1
X$3163 \$599 \$420 \$5834 NWELL PWELL BULK NAND2_X2
X$3173 \$1015 \$491 \$431 \$1053 NWELL PWELL BULK MUX2_X1
X$3176 \$7183 \$491 \$7352 \$434 NWELL PWELL BULK MUX2_X1
X$3187 \$23747 \$21785 \$21366 \$445 NWELL PWELL BULK NAND3_X4
X$3191 \$2320 \$445 \$7568 \$7706 NWELL PWELL BULK MUX2_X1
X$3194 \$2027 \$445 \$6523 \$6881 NWELL PWELL BULK MUX2_X1
X$3197 \$554 \$445 \$1299 \$1516 NWELL PWELL BULK MUX2_X1
X$3199 \$1104 \$445 \$5842 \$5421 NWELL PWELL BULK MUX2_X1
X$3202 \$2558 \$445 \$4663 \$4661 NWELL PWELL BULK MUX2_X1
X$3205 \$1789 \$445 \$3346 \$2973 NWELL PWELL BULK MUX2_X1
X$3208 \$18748 \$445 \$21191 \$21610 NWELL PWELL BULK MUX2_X1
X$3210 \$24153 \$445 \$23432 \$23155 NWELL PWELL BULK MUX2_X1
X$3213 \$21771 \$445 \$23050 \$23444 NWELL PWELL BULK MUX2_X1
X$3216 \$1128 \$445 \$16178 \$16451 NWELL PWELL BULK MUX2_X1
X$3219 \$1305 \$445 \$748 \$1144 NWELL PWELL BULK MUX2_X1
X$3221 \$1797 \$445 \$2992 \$2990 NWELL PWELL BULK MUX2_X1
X$3224 \$2074 \$445 \$17407 \$17571 NWELL PWELL BULK MUX2_X1
X$3226 \$2030 \$445 \$12634 \$12918 NWELL PWELL BULK MUX2_X1
X$3228 \$2025 \$445 \$10610 \$11188 NWELL PWELL BULK MUX2_X1
X$3230 \$1796 \$445 \$10973 \$11577 NWELL PWELL BULK MUX2_X1
X$3233 \$1126 \$445 \$14979 \$15305 NWELL PWELL BULK MUX2_X1
X$3236 \$21365 \$445 \$23462 \$23464 NWELL PWELL BULK MUX2_X1
X$3238 \$24441 \$445 \$26189 \$25671 NWELL PWELL BULK MUX2_X1
X$3240 \$2328 \$445 \$13656 \$13782 NWELL PWELL BULK MUX2_X1
X$3242 \$3194 \$445 \$14728 \$14407 NWELL PWELL BULK MUX2_X1
X$3245 \$1169 \$445 \$14985 \$14717 NWELL PWELL BULK MUX2_X1
X$3248 \$2082 \$445 \$9703 \$9702 NWELL PWELL BULK MUX2_X1
X$3250 \$942 \$445 \$6386 \$6551 NWELL PWELL BULK MUX2_X1
X$3252 \$1524 \$445 \$9194 \$9192 NWELL PWELL BULK MUX2_X1
X$3254 \$2063 \$445 \$8507 \$8696 NWELL PWELL BULK MUX2_X1
X$3256 \$1987 \$445 \$8825 \$8691 NWELL PWELL BULK MUX2_X1
X$3258 \$1178 \$445 \$20060 \$20385 NWELL PWELL BULK MUX2_X1
X$3261 \$1237 \$445 \$20390 \$20672 NWELL PWELL BULK MUX2_X1
X$3264 \$2007 \$445 \$11718 \$12011 NWELL PWELL BULK MUX2_X1
X$3267 \$2033 \$445 \$16629 \$17385 NWELL PWELL BULK MUX2_X1
X$3271 \$954 \$445 \$18595 \$18349 NWELL PWELL BULK MUX2_X1
X$3273 \$449 \$445 \$1093 \$1091 NWELL PWELL BULK MUX2_X1
X$3275 \$559 \$445 \$1537 \$1303 NWELL PWELL BULK MUX2_X1
X$3278 \$1141 \$445 \$3340 \$3336 NWELL PWELL BULK MUX2_X1
X$3280 \$1783 \$445 \$3939 \$3938 NWELL PWELL BULK MUX2_X1
X$3282 \$23744 \$445 \$23980 \$23978 NWELL PWELL BULK MUX2_X1
X$3284 \$4334 \$445 \$6576 \$6577 NWELL PWELL BULK MUX2_X1
X$3286 \$24429 \$445 \$26159 \$26155 NWELL PWELL BULK MUX2_X1
X$3289 \$25877 \$445 \$26711 \$26702 NWELL PWELL BULK MUX2_X1
X$3291 \$3589 \$445 \$7113 \$7284 NWELL PWELL BULK MUX2_X1
X$3293 \$19682 \$445 \$21169 \$21165 NWELL PWELL BULK MUX2_X1
X$3296 \$22226 \$445 \$21173 \$21588 NWELL PWELL BULK MUX2_X1
X$3300 \$25336 \$445 \$26663 \$26366 NWELL PWELL BULK MUX2_X1
X$3302 \$2051 \$445 \$9360 \$9361 NWELL PWELL BULK MUX2_X1
X$3304 \$3033 \$445 \$4329 \$4499 NWELL PWELL BULK MUX2_X1
X$3306 \$4996 \$445 \$5577 \$5574 NWELL PWELL BULK MUX2_X1
X$3380 \$2309 \$1777 \$449 \$2501 NWELL PWELL BULK MUX2_X1
X$3383 \$1778 \$2301 \$449 \$2498 NWELL PWELL BULK MUX2_X1
X$3397 \$2386 \$2766 \$2366 \$463 NWELL PWELL BULK MUX2_X2
X$3402 \$463 \$1885 \$2420 \$1893 NWELL PWELL BULK MUX2_X1
X$3409 \$16881 \$9693 \$16882 \$470 NWELL PWELL BULK MUX2_X1
X$3416 \$8685 \$8013 \$8014 \$471 NWELL PWELL BULK NAND3_X2
X$3419 \$471 \$933 \$7234 NWELL PWELL BULK NAND2_X2
X$3427 \$2391 \$2366 \$2392 \$476 NWELL PWELL BULK MUX2_X1
X$3430 \$476 \$1885 \$1889 \$1887 NWELL PWELL BULK MUX2_X1
X$3434 \$476 \$1400 \$1390 \$2724 NWELL PWELL BULK MUX2_X1
X$3449 \$6117 \$491 \$6193 \$1948 NWELL PWELL BULK MUX2_X1
X$3452 \$17136 \$491 NWELL PWELL BULK BUF_X16
X$3457 \$4041 \$491 \$4042 \$680 NWELL PWELL BULK MUX2_X1
X$3460 \$10481 \$491 \$10156 \$704 NWELL PWELL BULK MUX2_X1
X$3463 \$3374 \$491 \$3366 \$587 NWELL PWELL BULK MUX2_X1
X$3466 \$19357 \$491 \$18798 \$18838 NWELL PWELL BULK MUX2_X1
X$3468 \$6833 \$491 \$7482 \$717 NWELL PWELL BULK MUX2_X1
X$3471 \$5185 \$491 \$4756 \$1904 NWELL PWELL BULK MUX2_X1
X$3473 \$14290 \$491 \$13487 \$729 NWELL PWELL BULK MUX2_X1
X$3476 \$1404 \$491 \$1063 \$1067 NWELL PWELL BULK MUX2_X1
X$3479 \$3729 \$491 \$4106 \$1937 NWELL PWELL BULK MUX2_X1
X$3482 \$14491 \$491 \$14909 \$2072 NWELL PWELL BULK MUX2_X1
X$3484 \$13402 \$491 \$12592 \$711 NWELL PWELL BULK MUX2_X1
X$3486 \$15896 \$491 \$15897 \$2013 NWELL PWELL BULK MUX2_X1
X$3488 \$10867 \$491 \$10178 \$738 NWELL PWELL BULK MUX2_X1
X$3491 \$1391 \$491 \$1087 \$2071 NWELL PWELL BULK MUX2_X1
X$3495 \$7936 \$491 \$8242 \$2688 NWELL PWELL BULK MUX2_X1
X$3497 \$6838 \$491 \$6956 \$2701 NWELL PWELL BULK MUX2_X1
X$3500 \$12102 \$491 \$12975 \$660 NWELL PWELL BULK MUX2_X1
X$3503 \$11048 \$491 \$11536 \$1891 NWELL PWELL BULK MUX2_X1
X$3507 \$12699 \$491 \$12107 \$656 NWELL PWELL BULK MUX2_X1
X$3509 \$18411 \$491 \$17129 \$676 NWELL PWELL BULK MUX2_X1
X$3512 \$17469 \$491 \$16701 \$17292 NWELL PWELL BULK MUX2_X1
X$3516 \$1020 \$491 \$1458 \$1416 NWELL PWELL BULK MUX2_X1
X$3518 \$2440 \$491 \$2441 \$1021 NWELL PWELL BULK MUX2_X1
X$3521 \$2596 \$491 \$2428 \$2429 NWELL PWELL BULK MUX2_X1
X$3524 \$15035 \$491 \$13833 \$2702 NWELL PWELL BULK MUX2_X1
X$3526 \$15040 \$491 \$14275 \$672 NWELL PWELL BULK MUX2_X1
X$3528 \$10468 \$491 \$10357 \$2015 NWELL PWELL BULK MUX2_X1
X$3530 \$8963 \$491 \$8958 \$3267 NWELL PWELL BULK MUX2_X1
X$3532 \$6113 \$491 \$6216 \$591 NWELL PWELL BULK MUX2_X1
X$3534 \$8920 \$491 \$9220 \$2029 NWELL PWELL BULK MUX2_X1
X$3536 \$1006 \$491 \$2421 \$586 NWELL PWELL BULK MUX2_X1
X$3538 \$5252 \$491 \$5086 \$1398 NWELL PWELL BULK MUX2_X1
X$3540 \$733 \$491 \$1103 \$732 NWELL PWELL BULK MUX2_X1
X$3585 \$3475 \$3132 \$2366 \$501 NWELL PWELL BULK MUX2_X2
X$3589 \$501 \$1400 \$1383 \$2771 NWELL PWELL BULK MUX2_X1
X$3593 \$501 \$1885 \$1388 \$1612 NWELL PWELL BULK MUX2_X1
X$3603 \$6055 \$3964 \$6633 \$510 NWELL PWELL BULK MUX2_X1
X$3610 \$25395 \$2782 \$24977 \$528 NWELL PWELL BULK MUX2_X1
X$3618 \$27613 \$26973 \$2782 \$529 NWELL PWELL BULK MUX2_X2
X$3626 \$24168 \$24933 \$24028 \$538 NWELL PWELL BULK NAND3_X4
X$3628 \$907 \$538 \$25712 \$25715 NWELL PWELL BULK MUX2_X1
X$3630 \$1643 \$538 \$18760 \$19011 NWELL PWELL BULK MUX2_X1
X$3633 \$3500 \$538 \$6357 \$6354 NWELL PWELL BULK MUX2_X1
X$3635 \$1749 \$538 \$16226 \$16669 NWELL PWELL BULK MUX2_X1
X$3637 \$565 \$538 \$10986 \$10519 NWELL PWELL BULK MUX2_X1
X$3640 \$1275 \$538 \$12932 \$13455 NWELL PWELL BULK MUX2_X1
X$3642 \$1829 \$538 \$14144 \$14029 NWELL PWELL BULK MUX2_X1
X$3646 \$1698 \$538 \$15002 \$14809 NWELL PWELL BULK MUX2_X1
X$3649 \$1259 \$538 \$21375 \$22106 NWELL PWELL BULK MUX2_X1
X$3651 \$2206 \$538 \$18628 \$18360 NWELL PWELL BULK MUX2_X1
X$3653 \$2350 \$538 \$2862 \$3413 NWELL PWELL BULK MUX2_X1
X$3655 \$1174 \$538 \$7912 \$8661 NWELL PWELL BULK MUX2_X1
X$3657 \$2205 \$538 \$4636 \$4368 NWELL PWELL BULK MUX2_X1
X$3660 \$1737 \$538 \$4641 \$4647 NWELL PWELL BULK MUX2_X1
X$3662 \$1770 \$538 \$7029 \$7042 NWELL PWELL BULK MUX2_X1
X$3665 \$2237 \$538 \$4900 \$4893 NWELL PWELL BULK MUX2_X1
X$3667 \$2355 \$538 \$7593 \$7133 NWELL PWELL BULK MUX2_X1
X$3670 \$1340 \$538 \$8369 \$8718 NWELL PWELL BULK MUX2_X1
X$3672 \$1679 \$538 \$9078 \$9267 NWELL PWELL BULK MUX2_X1
X$3675 \$1817 \$538 \$7878 \$7590 NWELL PWELL BULK MUX2_X1
X$3678 \$1179 \$538 \$18780 \$19043 NWELL PWELL BULK MUX2_X1
X$3681 \$1268 \$538 \$14019 \$14021 NWELL PWELL BULK MUX2_X1
X$3684 \$1208 \$538 \$24334 \$24336 NWELL PWELL BULK MUX2_X1
X$3689 \$571 \$538 \$1761 \$1764 NWELL PWELL BULK MUX2_X1
X$3691 \$983 \$538 \$3882 \$4279 NWELL PWELL BULK MUX2_X1
X$3695 \$566 \$538 \$23520 \$23518 NWELL PWELL BULK MUX2_X1
X$3697 \$1156 \$538 \$19632 \$19630 NWELL PWELL BULK MUX2_X1
X$3699 \$786 \$538 \$1154 \$1150 NWELL PWELL BULK MUX2_X1
X$3701 \$2361 \$538 \$10526 \$10623 NWELL PWELL BULK MUX2_X1
X$3703 \$1210 \$538 \$22809 \$22299 NWELL PWELL BULK MUX2_X1
X$3705 \$564 \$538 \$960 \$1281 NWELL PWELL BULK MUX2_X1
X$3709 \$964 \$538 \$3105 \$3100 NWELL PWELL BULK MUX2_X1
X$3711 \$1693 \$538 \$12659 \$13269 NWELL PWELL BULK MUX2_X1
X$3713 \$1341 \$538 \$7382 \$7379 NWELL PWELL BULK MUX2_X1
X$3715 \$1254 \$538 \$11660 \$11936 NWELL PWELL BULK MUX2_X1
X$3718 \$1823 \$538 \$5753 \$5947 NWELL PWELL BULK MUX2_X1
X$3721 \$1184 \$538 \$25180 \$25798 NWELL PWELL BULK MUX2_X1
X$3723 \$1270 \$538 \$20066 \$20407 NWELL PWELL BULK MUX2_X1
X$3728 \$1231 \$538 \$2760 \$2759 NWELL PWELL BULK MUX2_X1
X$3731 \$1239 \$538 \$19121 \$19377 NWELL PWELL BULK MUX2_X1
X$3733 \$1138 \$538 \$24311 \$24312 NWELL PWELL BULK MUX2_X1
X$3735 \$1244 \$538 \$18772 \$18773 NWELL PWELL BULK MUX2_X1
X$3738 \$1251 \$538 \$19452 \$19355 NWELL PWELL BULK MUX2_X1
X$3740 \$956 \$538 \$3060 \$3049 NWELL PWELL BULK MUX2_X1
X$3742 \$1167 \$538 \$20988 \$21256 NWELL PWELL BULK MUX2_X1
X$3821 \$545 \$4069 NWELL PWELL BULK INV_X1
X$3823 \$I176454 \$545 \$3930 \$931 NWELL PWELL BULK DFF_X1
X$3833 \$929 \$930 \$548 \$549 NWELL PWELL BULK NOR3_X1
X$3838 \$1068 \$1289 \$549 \$1081 \$1463 NWELL PWELL BULK NAND4_X2
X$3841 \$1282 \$1476 \$1445 \$928 \$552 NWELL PWELL BULK NAND4_X1
X$3846 \$2515 \$1785 \$554 \$1989 NWELL PWELL BULK MUX2_X1
X$3848 \$2314 \$2313 \$554 \$2520 NWELL PWELL BULK MUX2_X1
X$3858 \$1114 \$939 \$556 \$2848 NWELL PWELL BULK MUX2_X1
X$3860 \$556 \$1299 \$1516 \$936 NWELL PWELL BULK DFF_X1
X$3862 \$558 \$557 \$1129 \$936 NWELL PWELL BULK DFF_X1
X$3865 \$558 \$939 \$560 \$2547 NWELL PWELL BULK MUX2_X1
X$3873 \$2316 \$1785 \$559 \$2534 NWELL PWELL BULK MUX2_X1
X$3875 \$2317 \$2313 \$559 \$2540 NWELL PWELL BULK MUX2_X1
X$3884 \$560 \$1537 \$1303 \$941 NWELL PWELL BULK DFF_X1
X$3887 \$563 \$1242 \$955 \$1245 NWELL PWELL BULK MUX2_X1
X$3892 \$563 \$1308 \$2130 \$2627 NWELL PWELL BULK MUX2_X1
X$3894 \$2634 \$916 \$563 \$2148 NWELL PWELL BULK MUX2_X1
X$3903 \$564 \$834 \$957 \$1261 NWELL PWELL BULK MUX2_X1
X$3906 \$1330 \$976 \$564 \$1327 NWELL PWELL BULK MUX2_X1
X$3908 \$2653 \$2348 \$564 \$2180 NWELL PWELL BULK MUX2_X1
X$3916 \$565 \$834 \$9892 \$9579 NWELL PWELL BULK MUX2_X1
X$3919 \$10621 \$2348 \$565 \$11250 NWELL PWELL BULK MUX2_X1
X$3921 \$9886 \$9707 \$565 \$9884 NWELL PWELL BULK MUX2_X1
X$3932 \$22246 \$2348 \$566 \$22879 NWELL PWELL BULK MUX2_X1
X$3935 \$22884 \$9707 \$566 \$23114 NWELL PWELL BULK MUX2_X1
X$3939 \$566 \$834 \$22591 \$22600 NWELL PWELL BULK MUX2_X1
X$3950 \$1258 \$916 \$567 \$1256 NWELL PWELL BULK MUX2_X1
X$3953 \$567 \$1308 \$2687 \$2363 NWELL PWELL BULK MUX2_X1
X$3956 \$567 \$1242 \$2236 \$1702 NWELL PWELL BULK MUX2_X1
X$3959 \$4982 \$4981 \$4980 \$569 NWELL PWELL BULK DFF_X1
X$3961 \$4278 \$3914 \$3910 \$569 NWELL PWELL BULK DFF_X1
X$3964 \$I178101 \$3992 \$4642 \$569 NWELL PWELL BULK DFF_X1
X$3966 \$I175576 \$5347 \$4978 \$569 NWELL PWELL BULK DFF_X1
X$3969 \$5338 \$5333 \$5326 \$569 NWELL PWELL BULK DFF_X1
X$3972 \$6033 \$6031 \$5700 \$569 NWELL PWELL BULK DFF_X1
X$3975 \$6024 \$6019 \$5452 \$569 NWELL PWELL BULK DFF_X1
X$3978 \$I177094 \$4964 \$4959 \$569 NWELL PWELL BULK DFF_X1
X$3981 \$I176893 \$4707 \$4708 \$569 NWELL PWELL BULK DFF_X1
X$3984 \$3618 \$3920 \$3990 \$569 NWELL PWELL BULK DFF_X1
X$3987 \$3503 \$3502 \$3505 \$569 NWELL PWELL BULK DFF_X1
X$3990 \$1756 \$1227 \$977 \$569 NWELL PWELL BULK DFF_X1
X$3993 \$2283 \$2291 \$2292 \$569 NWELL PWELL BULK DFF_X1
X$3995 \$1347 \$1232 \$1736 \$569 NWELL PWELL BULK DFF_X1
X$3997 \$1845 \$2760 \$2759 \$569 NWELL PWELL BULK DFF_X1
X$3999 \$2752 \$2732 \$2743 \$569 NWELL PWELL BULK DFF_X1
X$4001 \$3509 \$2740 \$2735 \$569 NWELL PWELL BULK DFF_X1
X$4004 \$I175731 \$7905 \$8232 \$569 NWELL PWELL BULK DFF_X1
X$4007 \$7902 \$8224 \$8225 \$569 NWELL PWELL BULK DFF_X1
X$4010 \$8229 \$8222 \$8226 \$569 NWELL PWELL BULK DFF_X1
X$4012 \$7429 \$8215 \$7601 \$569 NWELL PWELL BULK DFF_X1
X$4014 \$I174331 \$5685 \$6011 \$569 NWELL PWELL BULK DFF_X1
X$4017 \$I178649 \$5028 \$5449 \$569 NWELL PWELL BULK DFF_X1
X$4019 \$6065 \$6333 \$6324 \$569 NWELL PWELL BULK DFF_X1
X$4021 \$2679 \$569 NWELL PWELL BULK BUF_X4
X$4023 \$6793 \$7071 \$7078 \$569 NWELL PWELL BULK DFF_X1
X$4026 \$6795 \$7456 \$7447 \$569 NWELL PWELL BULK DFF_X1
X$4028 \$7074 \$6694 \$6420 \$569 NWELL PWELL BULK DFF_X1
X$4031 \$6691 \$6343 \$6068 \$569 NWELL PWELL BULK DFF_X1
X$4033 \$6791 \$6790 \$7420 \$569 NWELL PWELL BULK DFF_X1
X$4035 \$7450 \$7435 \$7440 \$569 NWELL PWELL BULK DFF_X1
X$4054 \$570 \$2242 \$1222 NWELL PWELL BULK NAND2_X4
X$4059 \$47213 \$570 NWELL PWELL BULK INV_X2
X$4062 \$571 \$834 \$1186 \$1198 NWELL PWELL BULK MUX2_X1
X$4064 \$2773 \$1849 \$571 \$2267 NWELL PWELL BULK MUX2_X1
X$4066 \$1215 \$976 \$571 \$978 NWELL PWELL BULK MUX2_X1
X$4077 \$4303 \$2782 \$3906 \$572 NWELL PWELL BULK MUX2_X1
X$4080 \$805 \$1365 \$574 \$988 NWELL PWELL BULK MUX2_X1
X$4082 \$574 \$575 \$987 \$991 NWELL PWELL BULK DFF_X1
X$4092 \$I177915 \$582 \$1002 \$996 NWELL PWELL BULK DFF_X1
X$4096 \$I178941 \$585 \$1086 \$1007 NWELL PWELL BULK DFF_X1
X$4105 \$4132 \$4044 \$4045 \$589 NWELL PWELL BULK MUX2_X1
X$4108 \$I178915 \$590 \$1531 \$1007 NWELL PWELL BULK DFF_X1
X$4112 \$1353 \$1885 \$590 \$1531 NWELL PWELL BULK MUX2_X1
X$4117 \$5585 \$4044 \$5213 \$592 NWELL PWELL BULK MUX2_X1
X$4120 \$594 \$1039 NWELL PWELL BULK INV_X1
X$4122 \$I174956 \$594 \$1484 \$596 NWELL PWELL BULK DFF_X1
X$4127 \$I174660 \$595 \$613 \$596 NWELL PWELL BULK DFF_X1
X$4133 \$I178512 \$4405 \$4473 \$596 NWELL PWELL BULK DFF_X1
X$4135 \$I174869 \$5511 \$5510 \$596 NWELL PWELL BULK DFF_X1
X$4138 \$I178091 \$5099 \$5568 \$596 NWELL PWELL BULK DFF_X1
X$4140 \$4761 \$4765 \$4465 \$596 NWELL PWELL BULK DFF_X1
X$4142 \$I178102 \$5093 \$5583 \$596 NWELL PWELL BULK DFF_X1
X$4144 \$I177488 \$5214 \$5508 \$596 NWELL PWELL BULK DFF_X1
X$4146 \$I178628 \$6477 \$6478 \$596 NWELL PWELL BULK DFF_X1
X$4148 \$I178758 \$3664 \$4053 \$596 NWELL PWELL BULK DFF_X1
X$4150 \$I175404 \$3663 \$4403 \$596 NWELL PWELL BULK DFF_X1
X$4153 \$I176642 \$4399 \$4511 \$596 NWELL PWELL BULK DFF_X1
X$4156 \$I176783 \$3286 \$3738 \$596 NWELL PWELL BULK DFF_X1
X$4158 \$I175983 \$5197 \$5206 \$596 NWELL PWELL BULK DFF_X1
X$4160 \$I174795 \$4757 \$4812 \$596 NWELL PWELL BULK DFF_X1
X$4162 \$I174865 \$3289 \$3332 \$596 NWELL PWELL BULK DFF_X1
X$4164 \$I178521 \$5096 \$5097 \$596 NWELL PWELL BULK DFF_X1
X$4166 \$I174564 \$6119 \$6198 \$596 NWELL PWELL BULK DFF_X1
X$4169 \$I178925 \$6849 \$7359 \$596 NWELL PWELL BULK DFF_X1
X$4171 \$I177276 \$635 \$1017 \$596 NWELL PWELL BULK DFF_X1
X$4175 \$I176831 \$629 \$1019 \$596 NWELL PWELL BULK DFF_X1
X$4177 \$I178543 \$2923 \$2924 \$596 NWELL PWELL BULK DFF_X1
X$4180 \$4017 \$596 NWELL PWELL BULK BUF_X4
X$4182 \$I177335 \$2438 \$1910 \$596 NWELL PWELL BULK DFF_X1
X$4185 \$I174976 \$2989 \$2917 \$596 NWELL PWELL BULK DFF_X1
X$4188 \$I175006 \$2921 \$2919 \$596 NWELL PWELL BULK DFF_X1
X$4191 \$I174580 \$4052 \$4131 \$596 NWELL PWELL BULK DFF_X1
X$4193 \$I177230 \$2426 \$2599 \$596 NWELL PWELL BULK DFF_X1
X$4196 \$I178547 \$2434 \$2564 \$596 NWELL PWELL BULK DFF_X1
X$4199 \$I174659 \$1022 \$1417 \$596 NWELL PWELL BULK DFF_X1
X$4203 \$I174756 \$631 \$1507 \$596 NWELL PWELL BULK DFF_X1
X$4233 \$11101 \$10084 \$10954 \$598 NWELL PWELL BULK MUX2_X1
X$4238 \$7670 \$7244 \$7225 \$599 NWELL PWELL BULK NAND3_X2
X$4252 \$6849 \$625 NWELL PWELL BULK INV_X1
X$4254 \$625 \$1038 \$5098 NWELL PWELL BULK NAND2_X4
X$4275 \$1396 \$1885 \$635 \$1017 NWELL PWELL BULK MUX2_X1
X$4283 \$10144 \$4044 \$10673 \$642 NWELL PWELL BULK MUX2_X1
X$4290 \$9857 \$4044 \$9854 \$646 NWELL PWELL BULK MUX2_X1
X$4298 \$647 \$1287 \$650 \$653 \$1068 NWELL PWELL BULK NOR4_X1
X$4300 \$8416 \$4044 \$8586 \$649 NWELL PWELL BULK MUX2_X1
X$4305 \$649 \$1408 NWELL PWELL BULK BUF_X1
X$4331 \$I177985 \$663 \$1073 \$1007 NWELL PWELL BULK DFF_X1
X$4339 \$1487 \$671 \$1079 \$931 NWELL PWELL BULK DFF_X1
X$4348 \$4162 \$2414 \$4037 \$674 NWELL PWELL BULK MUX2_X1
X$4367 \$11898 \$9693 \$11524 \$693 NWELL PWELL BULK MUX2_X1
X$4376 \$17750 \$9693 \$17747 \$696 NWELL PWELL BULK MUX2_X1
X$4390 \$19001 \$17136 \$18998 \$701 NWELL PWELL BULK MUX2_X1
X$4400 \$20125 \$17136 \$21002 \$705 NWELL PWELL BULK MUX2_X1
X$4405 \$5076 \$2414 \$5642 \$710 NWELL PWELL BULK MUX2_X1
X$4418 \$25692 \$2414 \$24228 \$712 NWELL PWELL BULK MUX2_X1
X$4431 \$14310 \$9693 \$13950 \$723 NWELL PWELL BULK MUX2_X1
X$4440 \$25980 \$2414 \$25981 \$726 NWELL PWELL BULK MUX2_X1
X$4459 \$21187 \$9693 \$21189 \$734 NWELL PWELL BULK MUX2_X1
X$4476 \$2034 \$748 \$1144 \$941 NWELL PWELL BULK DFF_X1
X$4481 \$24225 \$17136 \$24226 \$749 NWELL PWELL BULK MUX2_X1
X$4490 \$9407 \$2782 \$9743 \$756 NWELL PWELL BULK MUX2_X1
X$4497 \$16246 \$2782 \$16568 \$759 NWELL PWELL BULK MUX2_X1
X$4505 \$1794 \$761 \$1157 \$941 NWELL PWELL BULK DFF_X1
X$4509 \$19628 \$2782 \$19396 \$763 NWELL PWELL BULK MUX2_X1
X$4516 \$17099 \$2782 \$17521 \$769 NWELL PWELL BULK MUX2_X1
X$4523 \$6441 \$3964 \$6699 \$770 NWELL PWELL BULK MUX2_X1
X$4530 \$13680 \$2782 \$13674 \$775 NWELL PWELL BULK MUX2_X1
X$4540 \$21232 \$2782 \$21222 \$776 NWELL PWELL BULK MUX2_X1
X$4544 \$8320 \$2782 \$7615 \$777 NWELL PWELL BULK MUX2_X1
X$4551 \$9650 \$2782 \$9649 \$778 NWELL PWELL BULK MUX2_X1
X$4558 \$12080 \$2782 \$12563 \$782 NWELL PWELL BULK MUX2_X1
X$4567 \$27218 \$27217 \$2782 \$783 NWELL PWELL BULK MUX2_X2
X$4572 \$786 \$834 \$989 \$1139 NWELL PWELL BULK MUX2_X1
X$4575 \$1865 \$976 \$786 \$1867 NWELL PWELL BULK MUX2_X1
X$4581 \$2186 \$1849 \$786 \$1860 NWELL PWELL BULK MUX2_X1
X$4588 \$2088 \$1199 \$797 \$952 NWELL PWELL BULK DFF_X1
X$4593 \$21860 \$2782 \$21862 \$798 NWELL PWELL BULK MUX2_X1
X$4600 \$10225 \$2782 \$9048 \$800 NWELL PWELL BULK MUX2_X1
X$4607 \$805 \$1176 \$1175 \$979 NWELL PWELL BULK DFF_X1
X$4616 \$6594 \$3964 \$6604 \$828 NWELL PWELL BULK MUX2_X1
X$4623 \$9944 \$2782 \$9943 \$830 NWELL PWELL BULK MUX2_X1
X$4630 \$5931 \$3964 \$5942 \$832 NWELL PWELL BULK MUX2_X1
X$4637 \$1244 \$834 \$17939 \$18261 NWELL PWELL BULK MUX2_X1
X$4639 \$1275 \$834 \$14139 \$15236 NWELL PWELL BULK MUX2_X1
X$4641 \$24168 \$24167 \$24028 \$834 NWELL PWELL BULK NAND3_X4
X$4644 \$1679 \$834 \$9372 \$9988 NWELL PWELL BULK MUX2_X1
X$4646 \$2361 \$834 \$11648 \$11732 NWELL PWELL BULK MUX2_X1
X$4648 \$2206 \$834 \$16987 \$16980 NWELL PWELL BULK MUX2_X1
X$4650 \$1251 \$834 \$17938 \$18636 NWELL PWELL BULK MUX2_X1
X$4653 \$2350 \$834 \$4214 \$4215 NWELL PWELL BULK MUX2_X1
X$4655 \$1737 \$834 \$4941 \$4948 NWELL PWELL BULK MUX2_X1
X$4658 \$1341 \$834 \$6297 \$6295 NWELL PWELL BULK MUX2_X1
X$4661 \$964 \$834 \$3867 \$3864 NWELL PWELL BULK MUX2_X1
X$4663 \$1340 \$834 \$7830 \$8182 NWELL PWELL BULK MUX2_X1
X$4665 \$1270 \$834 \$20867 \$20869 NWELL PWELL BULK MUX2_X1
X$4668 \$1179 \$834 \$19404 \$19402 NWELL PWELL BULK MUX2_X1
X$4670 \$1184 \$834 \$24049 \$24054 NWELL PWELL BULK MUX2_X1
X$4672 \$1254 \$834 \$10303 \$10884 NWELL PWELL BULK MUX2_X1
X$4675 \$1210 \$834 \$21266 \$21265 NWELL PWELL BULK MUX2_X1
X$4678 \$1208 \$834 \$23695 \$23683 NWELL PWELL BULK MUX2_X1
X$4682 \$1770 \$834 \$7509 \$7514 NWELL PWELL BULK MUX2_X1
X$4684 \$1174 \$834 \$9034 \$9038 NWELL PWELL BULK MUX2_X1
X$4686 \$983 \$834 \$2825 \$2823 NWELL PWELL BULK MUX2_X1
X$4692 \$2205 \$834 \$4937 \$4939 NWELL PWELL BULK MUX2_X1
X$4694 \$907 \$834 \$24775 \$24774 NWELL PWELL BULK MUX2_X1
X$4696 \$1259 \$834 \$21378 \$21659 NWELL PWELL BULK MUX2_X1
X$4699 \$1749 \$834 \$17955 \$18702 NWELL PWELL BULK MUX2_X1
X$4701 \$1156 \$834 \$20814 \$21234 NWELL PWELL BULK MUX2_X1
X$4707 \$2237 \$834 \$5273 \$5271 NWELL PWELL BULK MUX2_X1
X$4711 \$1693 \$834 \$12660 \$13459 NWELL PWELL BULK MUX2_X1
X$4713 \$1817 \$834 \$7353 \$7129 NWELL PWELL BULK MUX2_X1
X$4715 \$2355 \$834 \$7886 \$7885 NWELL PWELL BULK MUX2_X1
X$4717 \$1823 \$834 \$5654 \$5645 NWELL PWELL BULK MUX2_X1
X$4721 \$1231 \$834 \$2291 \$2292 NWELL PWELL BULK MUX2_X1
X$4723 \$1138 \$834 \$24761 \$24518 NWELL PWELL BULK MUX2_X1
X$4725 \$1239 \$834 \$18377 \$19385 NWELL PWELL BULK MUX2_X1
X$4727 \$1643 \$834 \$19448 \$19330 NWELL PWELL BULK MUX2_X1
X$4729 \$1829 \$834 \$15326 \$16511 NWELL PWELL BULK MUX2_X1
X$4732 \$1268 \$834 \$14421 \$14770 NWELL PWELL BULK MUX2_X1
X$4734 \$1167 \$834 \$22304 \$22078 NWELL PWELL BULK MUX2_X1
X$4737 \$1698 \$834 \$15859 \$16204 NWELL PWELL BULK MUX2_X1
X$4741 \$3500 \$834 \$6694 \$6420 NWELL PWELL BULK MUX2_X1
X$4743 \$956 \$834 \$2635 \$2342 NWELL PWELL BULK MUX2_X1
X$4830 \$5367 \$2782 \$5379 \$836 NWELL PWELL BULK MUX2_X1
X$4837 \$13359 \$3964 \$13815 \$838 NWELL PWELL BULK MUX2_X1
X$4852 \$4192 \$3964 \$4198 \$839 NWELL PWELL BULK MUX2_X1
X$4855 \$20521 \$3964 \$19646 \$844 NWELL PWELL BULK MUX2_X1
X$4862 \$20098 \$2782 \$19638 \$860 NWELL PWELL BULK MUX2_X1
X$4869 \$12497 \$3964 \$12509 \$861 NWELL PWELL BULK MUX2_X1
X$4876 \$10321 \$3964 \$10322 \$880 NWELL PWELL BULK MUX2_X1
X$4885 \$8992 \$3964 \$9098 \$885 NWELL PWELL BULK MUX2_X1
X$4890 \$28976 \$28515 \$890 \$28978 NWELL PWELL BULK MUX2_X1
X$4893 \$29643 \$29172 \$890 \$28770 NWELL PWELL BULK MUX2_X1
X$4895 \$890 \$1242 \$29647 \$29657 NWELL PWELL BULK MUX2_X1
X$4897 \$890 \$1308 \$30148 \$29950 NWELL PWELL BULK MUX2_X1
X$4909 \$32974 \$28515 \$895 \$32148 NWELL PWELL BULK MUX2_X1
X$4911 \$895 \$1242 \$32396 \$32153 NWELL PWELL BULK MUX2_X1
X$4914 \$895 \$1308 \$31656 \$31658 NWELL PWELL BULK MUX2_X1
X$4916 \$32541 \$29172 \$895 \$32967 NWELL PWELL BULK MUX2_X1
X$4924 \$4600 \$3964 \$4354 \$896 NWELL PWELL BULK MUX2_X1
X$4931 \$899 \$1269 \$1267 \$961 NWELL PWELL BULK DFF_X1
X$4936 \$1241 \$916 \$1342 \$904 NWELL PWELL BULK MUX2_X1
X$4938 \$2259 \$1241 \$904 \$961 NWELL PWELL BULK DFF_X1
X$4944 \$24766 \$2348 \$907 \$24760 NWELL PWELL BULK MUX2_X1
X$4946 \$24034 \$9707 \$907 \$24036 NWELL PWELL BULK MUX2_X1
X$4956 \$913 \$1242 \$20676 \$21241 NWELL PWELL BULK MUX2_X1
X$4961 \$19106 \$7143 \$913 \$19313 NWELL PWELL BULK MUX2_X1
X$4963 \$20392 \$11378 \$913 \$20874 NWELL PWELL BULK MUX2_X1
X$4965 \$913 \$1308 \$19696 \$20400 NWELL PWELL BULK MUX2_X1
X$4975 \$8537 \$916 \$2106 \$8864 NWELL PWELL BULK MUX2_X1
X$4977 \$1822 \$916 \$1333 \$1331 NWELL PWELL BULK MUX2_X1
X$4980 \$9241 \$916 \$1246 \$9066 NWELL PWELL BULK MUX2_X1
X$4982 \$9075 \$916 \$958 \$9254 NWELL PWELL BULK MUX2_X1
X$4984 \$10838 \$916 \$3196 \$10834 NWELL PWELL BULK MUX2_X1
X$4987 \$7116 \$916 \$2339 \$7117 NWELL PWELL BULK MUX2_X1
X$4989 \$3954 \$916 \$2625 \$4165 NWELL PWELL BULK MUX2_X1
X$4991 \$4838 \$916 \$4677 \$4841 NWELL PWELL BULK MUX2_X1
X$4994 \$8224 \$916 \$2375 \$8225 NWELL PWELL BULK MUX2_X1
X$4997 \$4836 \$916 \$1821 \$4833 NWELL PWELL BULK MUX2_X1
X$5000 \$4155 \$916 \$2111 \$4150 NWELL PWELL BULK MUX2_X1
X$5002 \$2326 \$916 \$944 \$2559 NWELL PWELL BULK MUX2_X1
X$5006 \$3914 \$916 \$1837 \$3910 NWELL PWELL BULK MUX2_X1
X$5008 \$6019 \$916 \$2717 \$5452 NWELL PWELL BULK MUX2_X1
X$5013 \$1730 \$916 \$970 \$2293 NWELL PWELL BULK MUX2_X1
X$5016 \$2611 \$916 \$1314 \$2337 NWELL PWELL BULK MUX2_X1
X$5018 \$8707 \$916 \$2112 \$8879 NWELL PWELL BULK MUX2_X1
X$5020 \$6935 \$916 \$947 \$6940 NWELL PWELL BULK MUX2_X1
X$5022 \$916 \$11378 NWELL PWELL BULK BUF_X8
X$5024 \$7071 \$916 \$974 \$7078 NWELL PWELL BULK MUX2_X1
X$5061 \$918 \$1258 \$1256 \$961 NWELL PWELL BULK DFF_X1
X$5066 \$I176516 \$922 \$3572 \$931 NWELL PWELL BULK DFF_X1
X$5068 \$922 \$3695 NWELL PWELL BULK INV_X1
X$5075 \$1443 \$923 \$1045 \$924 \$1282 NWELL PWELL BULK NOR4_X1
X$5080 \$925 \$1283 NWELL PWELL BULK INV_X1
X$5083 \$1046 \$1435 \$1283 \$926 \$1445 NWELL PWELL BULK NOR4_X1
X$5086 \$3932 \$927 \$2841 \$1463 \$3168 NWELL PWELL BULK OR4_X2
X$5089 \$927 \$2841 \$3701 NWELL PWELL BULK AND2_X1
X$5100 \$I178398 \$9782 \$9777 \$931 NWELL PWELL BULK DFF_X1
X$5104 \$1295 \$1093 \$1091 \$931 NWELL PWELL BULK DFF_X1
X$5107 \$3733 \$4099 \$3724 \$931 NWELL PWELL BULK DFF_X1
X$5110 \$3937 \$931 NWELL PWELL BULK BUF_X4
X$5113 \$3712 \$3718 \$3707 \$931 NWELL PWELL BULK DFF_X1
X$5116 \$1939 \$1061 \$1462 \$931 NWELL PWELL BULK DFF_X1
X$5119 \$2959 \$1778 \$2498 \$931 NWELL PWELL BULK DFF_X1
X$5121 \$2310 \$2309 \$2501 \$931 NWELL PWELL BULK DFF_X1
X$5123 \$2303 \$1776 \$1946 \$931 NWELL PWELL BULK DFF_X1
X$5126 \$I176453 \$2937 \$3310 \$931 NWELL PWELL BULK DFF_X1
X$5130 \$3576 \$3575 \$3708 \$931 NWELL PWELL BULK DFF_X1
X$5134 \$4436 \$3933 \$4426 \$931 NWELL PWELL BULK DFF_X1
X$5136 \$I177743 \$2298 \$2839 \$931 NWELL PWELL BULK DFF_X1
X$5139 \$2949 \$2482 \$1931 \$931 NWELL PWELL BULK DFF_X1
X$5141 \$I177748 \$2297 \$3307 \$931 NWELL PWELL BULK DFF_X1
X$5143 \$I177596 \$3570 \$3677 \$931 NWELL PWELL BULK DFF_X1
X$5146 \$5538 \$5842 \$5421 \$931 NWELL PWELL BULK DFF_X1
X$5148 \$5539 \$5419 \$5530 \$931 NWELL PWELL BULK DFF_X1
X$5150 \$6149 \$6035 \$6146 \$931 NWELL PWELL BULK DFF_X1
X$5152 \$I177693 \$7086 \$7083 \$931 NWELL PWELL BULK DFF_X1
X$5155 \$4314 \$4094 \$3943 \$931 NWELL PWELL BULK DFF_X1
X$5158 \$4440 \$3939 \$3938 \$931 NWELL PWELL BULK DFF_X1
X$5160 \$3740 \$3340 \$3336 \$931 NWELL PWELL BULK DFF_X1
X$5162 \$5136 \$4789 \$5135 \$931 NWELL PWELL BULK DFF_X1
X$5164 \$5124 \$4989 \$5536 \$931 NWELL PWELL BULK DFF_X1
X$5167 \$1930 \$1058 \$1055 \$931 NWELL PWELL BULK DFF_X1
X$5204 \$6894 \$6890 \$6889 \$936 NWELL PWELL BULK DFF_X1
X$5207 \$6036 \$6037 \$6158 \$936 NWELL PWELL BULK DFF_X1
X$5210 \$6910 \$6386 \$6551 \$936 NWELL PWELL BULK DFF_X1
X$5212 \$I178334 \$7241 \$7095 \$936 NWELL PWELL BULK DFF_X1
X$5214 \$6552 \$6039 \$6541 \$936 NWELL PWELL BULK DFF_X1
X$5216 \$I178336 \$7100 \$7256 \$936 NWELL PWELL BULK DFF_X1
X$5218 \$6908 \$6549 \$7253 \$936 NWELL PWELL BULK DFF_X1
X$5220 \$5863 \$5859 \$5567 \$936 NWELL PWELL BULK DFF_X1
X$5222 \$6382 \$5730 \$5853 \$936 NWELL PWELL BULK DFF_X1
X$5224 \$5554 \$5551 \$5556 \$936 NWELL PWELL BULK DFF_X1
X$5226 \$I175617 \$7568 \$7706 \$936 NWELL PWELL BULK DFF_X1
X$5229 \$I175580 \$7860 \$8049 \$936 NWELL PWELL BULK DFF_X1
X$5231 \$I175581 \$7570 \$7716 \$936 NWELL PWELL BULK DFF_X1
X$5234 \$2978 \$2314 \$2520 \$936 NWELL PWELL BULK DFF_X1
X$5237 \$2543 \$2316 \$2534 \$936 NWELL PWELL BULK DFF_X1
X$5242 \$2969 \$2515 \$1989 \$936 NWELL PWELL BULK DFF_X1
X$5245 \$1114 \$1110 \$1101 \$936 NWELL PWELL BULK DFF_X1
X$5248 \$6183 \$6561 \$6180 \$936 NWELL PWELL BULK DFF_X1
X$5253 \$4323 \$4324 \$4476 \$936 NWELL PWELL BULK DFF_X1
X$5255 \$5872 \$5577 \$5574 \$936 NWELL PWELL BULK DFF_X1
X$5257 \$5871 \$5866 \$5429 \$936 NWELL PWELL BULK DFF_X1
X$5259 \$3179 \$3346 \$2973 \$936 NWELL PWELL BULK DFF_X1
X$5262 \$4315 \$4454 \$4108 \$936 NWELL PWELL BULK DFF_X1
X$5264 \$2679 \$936 NWELL PWELL BULK BUF_X4
X$5266 \$4666 \$4469 \$4806 \$936 NWELL PWELL BULK DFF_X1
X$5268 \$3749 \$4119 \$4112 \$936 NWELL PWELL BULK DFF_X1
X$5270 \$5146 \$4663 \$4661 \$936 NWELL PWELL BULK DFF_X1
X$5272 \$4993 \$4994 \$5150 \$936 NWELL PWELL BULK DFF_X1
X$5275 \$4802 \$4318 \$4457 \$936 NWELL PWELL BULK DFF_X1
X$5305 \$1487 \$939 \$1295 \$2965 NWELL PWELL BULK MUX2_X1
X$5307 \$8341 \$939 \$8342 \$7851 NWELL PWELL BULK MUX2_X1
X$5309 \$2949 \$939 \$2303 \$2487 NWELL PWELL BULK MUX2_X1
X$5312 \$2959 \$939 \$2310 \$2962 NWELL PWELL BULK MUX2_X1
X$5315 \$5539 \$939 \$5538 \$5727 NWELL PWELL BULK MUX2_X1
X$5318 \$1930 \$939 \$1939 \$1775 NWELL PWELL BULK MUX2_X1
X$5320 \$6552 \$939 \$6183 \$6913 NWELL PWELL BULK MUX2_X1
X$5322 \$3733 \$939 \$4314 \$3739 NWELL PWELL BULK MUX2_X1
X$5325 \$4802 \$939 \$4666 \$3946 NWELL PWELL BULK MUX2_X1
X$5327 \$4315 \$939 \$3740 \$3581 NWELL PWELL BULK MUX2_X1
X$5330 \$5554 \$939 \$5146 \$5425 NWELL PWELL BULK MUX2_X1
X$5332 \$8344 \$939 \$8695 \$8498 NWELL PWELL BULK MUX2_X1
X$5334 \$3749 \$939 \$3179 \$4128 NWELL PWELL BULK MUX2_X1
X$5337 \$9356 \$939 \$9061 \$9523 NWELL PWELL BULK MUX2_X1
X$5339 \$7863 \$939 \$7864 \$8530 NWELL PWELL BULK MUX2_X1
X$5341 \$7106 \$939 \$7113 \$7277 NWELL PWELL BULK MUX2_X1
X$5343 \$6570 \$939 \$6392 \$6043 NWELL PWELL BULK MUX2_X1
X$5346 \$6745 \$939 \$7110 \$7111 NWELL PWELL BULK MUX2_X1
X$5349 \$4323 \$939 \$4670 \$4481 NWELL PWELL BULK MUX2_X1
X$5352 \$3764 \$939 \$3188 \$4325 NWELL PWELL BULK MUX2_X1
X$5355 \$2551 \$939 \$2034 \$2321 NWELL PWELL BULK MUX2_X1
X$5358 \$12914 \$939 \$12915 \$13148 NWELL PWELL BULK MUX2_X1
X$5360 \$10970 \$939 \$10971 \$11183 NWELL PWELL BULK MUX2_X1
X$5362 \$8854 \$939 NWELL PWELL BULK BUF_X16
X$5364 \$13777 \$939 \$13779 \$13971 NWELL PWELL BULK MUX2_X1
X$5366 \$14121 \$939 \$13773 \$14706 NWELL PWELL BULK MUX2_X1
X$5368 \$12014 \$939 \$12634 \$12919 NWELL PWELL BULK MUX2_X1
X$5370 \$12010 \$939 \$11718 \$12628 NWELL PWELL BULK MUX2_X1
X$5373 \$6382 \$939 \$6894 \$6895 NWELL PWELL BULK MUX2_X1
X$5376 \$7850 \$939 \$8038 \$8035 NWELL PWELL BULK MUX2_X1
X$5378 \$6036 \$939 \$6521 \$6534 NWELL PWELL BULK MUX2_X1
X$5381 \$6908 \$939 \$6910 \$6911 NWELL PWELL BULK MUX2_X1
X$5383 \$5863 \$939 \$4993 \$5869 NWELL PWELL BULK MUX2_X1
X$5386 \$6149 \$939 \$6507 \$5726 NWELL PWELL BULK MUX2_X1
X$5389 \$9351 \$939 \$9194 \$9353 NWELL PWELL BULK MUX2_X1
X$5391 \$11561 \$939 \$10610 \$11187 NWELL PWELL BULK MUX2_X1
X$5393 \$7241 \$939 \$7568 \$7718 NWELL PWELL BULK MUX2_X1
X$5396 \$7570 \$939 \$7100 \$7729 NWELL PWELL BULK MUX2_X1
X$5399 \$7860 \$939 \$8507 \$8513 NWELL PWELL BULK MUX2_X1
X$5401 \$9347 \$939 \$9694 \$9827 NWELL PWELL BULK MUX2_X1
X$5403 \$15576 \$939 \$14979 \$14978 NWELL PWELL BULK MUX2_X1
X$5406 \$2969 \$939 \$2978 \$2979 NWELL PWELL BULK MUX2_X1
X$5408 \$3576 \$939 \$3712 \$3174 NWELL PWELL BULK MUX2_X1
X$5410 \$6191 \$939 \$5737 \$6194 NWELL PWELL BULK MUX2_X1
X$5412 \$5871 \$939 \$5872 \$5874 NWELL PWELL BULK MUX2_X1
X$5415 \$3370 \$939 \$3008 \$3190 NWELL PWELL BULK MUX2_X1
X$5418 \$5600 \$939 \$5177 \$5181 NWELL PWELL BULK MUX2_X1
X$5420 \$2543 \$939 \$1788 \$2024 NWELL PWELL BULK MUX2_X1
X$5423 \$4494 \$939 \$4498 \$5179 NWELL PWELL BULK MUX2_X1
X$5426 \$4436 \$939 \$4440 \$3940 NWELL PWELL BULK MUX2_X1
X$5428 \$5124 \$939 \$5136 \$5553 NWELL PWELL BULK MUX2_X1
X$5469 \$2057 \$1168 \$1165 \$941 NWELL PWELL BULK DFF_X1
X$5473 \$2572 \$2326 \$2559 \$941 NWELL PWELL BULK DFF_X1
X$5475 \$3008 \$2851 \$3005 \$941 NWELL PWELL BULK DFF_X1
X$5478 \$1310 \$1172 \$1177 \$941 NWELL PWELL BULK DFF_X1
X$5481 \$1800 \$1572 \$1311 \$941 NWELL PWELL BULK DFF_X1
X$5485 \$2567 \$2323 \$2560 \$941 NWELL PWELL BULK DFF_X1
X$5489 \$3018 \$2855 \$3019 \$941 NWELL PWELL BULK DFF_X1
X$5491 \$4169 \$3954 \$4165 \$941 NWELL PWELL BULK DFF_X1
X$5493 \$5211 \$4838 \$4841 \$941 NWELL PWELL BULK DFF_X1
X$5496 \$5007 \$4854 \$4852 \$941 NWELL PWELL BULK DFF_X1
X$5499 \$2600 \$2598 \$2591 \$941 NWELL PWELL BULK DFF_X1
X$5502 \$4516 \$4155 \$4150 \$941 NWELL PWELL BULK DFF_X1
X$5504 \$5610 \$5608 \$5604 \$941 NWELL PWELL BULK DFF_X1
X$5506 \$5600 \$5595 \$5594 \$941 NWELL PWELL BULK DFF_X1
X$5508 \$4670 \$4818 \$4669 \$941 NWELL PWELL BULK DFF_X1
X$5511 \$3188 \$2992 \$2990 \$941 NWELL PWELL BULK DFF_X1
X$5513 \$3370 \$3777 \$3769 \$941 NWELL PWELL BULK DFF_X1
X$5516 \$3764 \$3184 \$3182 \$941 NWELL PWELL BULK DFF_X1
X$5518 \$4494 \$4489 \$3947 \$941 NWELL PWELL BULK DFF_X1
X$5520 \$5177 \$5176 \$5586 \$941 NWELL PWELL BULK DFF_X1
X$5523 \$4498 \$4329 \$4499 \$941 NWELL PWELL BULK DFF_X1
X$5526 \$1788 \$2317 \$2540 \$941 NWELL PWELL BULK DFF_X1
X$5528 \$2551 \$2036 \$2553 \$941 NWELL PWELL BULK DFF_X1
X$5530 \$5001 \$5190 \$5195 \$941 NWELL PWELL BULK DFF_X1
X$5532 \$4330 \$4512 \$4506 \$941 NWELL PWELL BULK DFF_X1
X$5535 \$3791 \$3790 \$4139 \$941 NWELL PWELL BULK DFF_X1
X$5537 \$3951 \$3952 \$4160 \$941 NWELL PWELL BULK DFF_X1
X$5539 \$2679 \$941 NWELL PWELL BULK BUF_X4
X$5564 \$6039 \$1785 \$942 \$6541 NWELL PWELL BULK MUX2_X1
X$5568 \$6561 \$2313 \$942 \$6180 NWELL PWELL BULK MUX2_X1
X$5578 \$944 \$1308 \$2323 \$2560 NWELL PWELL BULK MUX2_X1
X$5582 \$944 \$1242 \$2855 \$3019 NWELL PWELL BULK MUX2_X1
X$5597 \$947 \$1242 \$6946 \$6948 NWELL PWELL BULK MUX2_X1
X$5600 \$947 \$1308 \$6206 \$5904 NWELL PWELL BULK MUX2_X1
X$5606 \$4687 \$4900 \$4893 \$952 NWELL PWELL BULK DFF_X1
X$5608 \$I176949 \$6755 \$6591 \$952 NWELL PWELL BULK DFF_X1
X$5610 \$I177011 \$6046 \$6230 \$952 NWELL PWELL BULK DFF_X1
X$5613 \$I176520 \$5747 \$5920 \$952 NWELL PWELL BULK DFF_X1
X$5615 \$2857 \$3051 \$3050 \$952 NWELL PWELL BULK DFF_X1
X$5617 \$2338 \$2611 \$2337 \$952 NWELL PWELL BULK DFF_X1
X$5619 \$I175293 \$3960 \$4173 \$952 NWELL PWELL BULK DFF_X1
X$5622 \$I176236 \$5243 \$5239 \$952 NWELL PWELL BULK DFF_X1
X$5625 \$I177287 \$4341 \$3963 \$952 NWELL PWELL BULK DFF_X1
X$5627 \$5016 \$4882 \$4883 \$952 NWELL PWELL BULK DFF_X1
X$5629 \$I176249 \$4684 \$5013 \$952 NWELL PWELL BULK DFF_X1
X$5632 \$3597 \$3198 \$3830 \$952 NWELL PWELL BULK DFF_X1
X$5635 \$4532 \$3958 \$4533 \$952 NWELL PWELL BULK DFF_X1
X$5637 \$I176799 \$5008 \$5222 \$952 NWELL PWELL BULK DFF_X1
X$5640 \$I174440 \$4343 \$3966 \$952 NWELL PWELL BULK DFF_X1
X$5642 \$2679 \$952 NWELL PWELL BULK BUF_X4
X$5644 \$I176828 \$3826 \$3824 \$952 NWELL PWELL BULK DFF_X1
X$5647 \$I177035 \$5438 \$5632 \$952 NWELL PWELL BULK DFF_X1
X$5649 \$2644 \$2635 \$2342 \$952 NWELL PWELL BULK DFF_X1
X$5651 \$1325 \$2634 \$2148 \$952 NWELL PWELL BULK DFF_X1
X$5653 \$1329 \$1330 \$1327 \$952 NWELL PWELL BULK DFF_X1
X$5655 \$1630 \$957 \$1261 \$952 NWELL PWELL BULK DFF_X1
X$5657 \$2158 \$955 \$1245 \$952 NWELL PWELL BULK DFF_X1
X$5659 \$2633 \$2130 \$2627 \$952 NWELL PWELL BULK DFF_X1
X$5661 \$3074 \$3069 \$3404 \$952 NWELL PWELL BULK DFF_X1
X$5664 \$1320 \$1226 \$953 \$952 NWELL PWELL BULK DFF_X1
X$5669 \$3065 \$3060 \$3049 \$952 NWELL PWELL BULK DFF_X1
X$5672 \$2856 \$3386 \$3193 \$952 NWELL PWELL BULK DFF_X1
X$5674 \$1597 \$1317 \$1591 \$952 NWELL PWELL BULK DFF_X1
X$5707 \$18584 \$2301 \$954 \$18585 NWELL PWELL BULK MUX2_X1
X$5712 \$19298 \$1777 \$954 \$19102 NWELL PWELL BULK MUX2_X1
X$5724 \$3069 \$976 \$956 \$3404 NWELL PWELL BULK MUX2_X1
X$5727 \$3198 \$2348 \$956 \$3830 NWELL PWELL BULK MUX2_X1
X$5739 \$958 \$1242 \$8583 \$8712 NWELL PWELL BULK MUX2_X1
X$5741 \$8363 \$7143 \$958 \$8572 NWELL PWELL BULK MUX2_X1
X$5743 \$958 \$1308 \$8710 \$9564 NWELL PWELL BULK MUX2_X1
X$5751 \$2188 \$960 \$1281 \$961 NWELL PWELL BULK DFF_X1
X$5754 \$3438 \$3428 \$3089 \$961 NWELL PWELL BULK DFF_X1
X$5757 \$3853 \$3842 \$3844 \$961 NWELL PWELL BULK DFF_X1
X$5759 \$4209 \$4214 \$4215 \$961 NWELL PWELL BULK DFF_X1
X$5761 \$1650 \$2653 \$2180 \$961 NWELL PWELL BULK DFF_X1
X$5763 \$2646 \$2349 \$2652 \$961 NWELL PWELL BULK DFF_X1
X$5765 \$2671 \$1822 \$1331 \$961 NWELL PWELL BULK DFF_X1
X$5768 \$2863 \$2862 \$3413 \$961 NWELL PWELL BULK DFF_X1
X$5771 \$3443 \$3105 \$3100 \$961 NWELL PWELL BULK DFF_X1
X$5774 \$5266 \$5258 \$5253 \$961 NWELL PWELL BULK DFF_X1
X$5776 \$2867 \$3867 \$3864 \$961 NWELL PWELL BULK DFF_X1
X$5778 \$2224 \$1696 \$2234 \$961 NWELL PWELL BULK DFF_X1
X$5780 \$962 \$1334 \$1666 \$961 NWELL PWELL BULK DFF_X1
X$5785 \$2679 \$961 NWELL PWELL BULK BUF_X4
X$5791 \$1831 \$2676 \$2669 \$961 NWELL PWELL BULK DFF_X1
X$5793 \$2866 \$2359 \$2360 \$961 NWELL PWELL BULK DFF_X1
X$5795 \$2365 \$2687 \$2363 \$961 NWELL PWELL BULK DFF_X1
X$5797 \$I178069 \$4231 \$4227 \$961 NWELL PWELL BULK DFF_X1
X$5800 \$5751 \$5654 \$5645 \$961 NWELL PWELL BULK DFF_X1
X$5803 \$2371 \$3483 \$2369 \$961 NWELL PWELL BULK DFF_X1
X$5806 \$2874 \$3496 \$3218 \$961 NWELL PWELL BULK DFF_X1
X$5808 \$967 \$2236 \$1702 \$961 NWELL PWELL BULK DFF_X1
X$5810 \$I174855 \$5302 \$5297 \$961 NWELL PWELL BULK DFF_X1
X$5813 \$I177055 \$4705 \$4702 \$961 NWELL PWELL BULK DFF_X1
X$5815 \$2270 \$1344 \$1716 \$961 NWELL PWELL BULK DFF_X1
X$5818 \$2734 \$2275 \$1836 \$961 NWELL PWELL BULK DFF_X1
X$5821 \$1729 \$972 \$1236 \$961 NWELL PWELL BULK DFF_X1
X$5823 \$2296 \$1730 \$2293 \$961 NWELL PWELL BULK DFF_X1
X$5851 \$963 \$2219 \$1815 \$2685 NWELL PWELL BULK MUX2_X2
X$5854 \$3428 \$2348 \$964 \$3089 NWELL PWELL BULK MUX2_X1
X$5861 \$2359 \$976 \$964 \$2360 NWELL PWELL BULK MUX2_X1
X$5871 \$2697 \$968 \$1815 \$2380 NWELL PWELL BULK MUX2_X2
X$5876 \$970 \$1308 \$2275 \$1836 NWELL PWELL BULK MUX2_X1
X$5879 \$970 \$1242 \$1232 \$1736 NWELL PWELL BULK MUX2_X1
X$5885 \$974 \$1308 \$6333 \$6324 NWELL PWELL BULK MUX2_X1
X$5887 \$974 \$1242 \$7456 \$7447 NWELL PWELL BULK MUX2_X1
X$5891 \$6790 \$7143 \$974 \$7420 NWELL PWELL BULK MUX2_X1
X$5896 \$10300 \$976 \$1254 \$10530 NWELL PWELL BULK MUX2_X1
X$5903 \$5047 \$976 \$1737 \$5045 NWELL PWELL BULK MUX2_X1
X$5906 \$5399 \$976 \$2205 \$5400 NWELL PWELL BULK MUX2_X1
X$5909 \$6643 \$976 \$1341 \$6290 NWELL PWELL BULK MUX2_X1
X$5912 \$7890 \$976 \$1340 \$7594 NWELL PWELL BULK MUX2_X1
X$5914 \$6991 \$976 \$1823 \$6989 NWELL PWELL BULK MUX2_X1
X$5919 \$7497 \$976 \$1770 \$7506 NWELL PWELL BULK MUX2_X1
X$5921 \$8286 \$976 \$1174 \$8276 NWELL PWELL BULK MUX2_X1
X$5923 \$2808 \$976 \$983 \$2812 NWELL PWELL BULK MUX2_X1
X$5928 \$5258 \$976 \$2237 \$5253 NWELL PWELL BULK MUX2_X1
X$5932 \$976 \$9707 NWELL PWELL BULK BUF_X8
X$5938 \$8935 \$976 \$1679 \$9080 NWELL PWELL BULK MUX2_X1
X$5940 \$8164 \$976 \$2355 \$8585 NWELL PWELL BULK MUX2_X1
X$5942 \$7591 \$976 \$1817 \$7805 NWELL PWELL BULK MUX2_X1
X$5944 \$1227 \$976 \$1231 \$977 NWELL PWELL BULK MUX2_X1
X$5947 \$3842 \$976 \$2350 \$3844 NWELL PWELL BULK MUX2_X1
X$5950 \$7460 \$976 \$3500 \$7145 NWELL PWELL BULK MUX2_X1
X$5993 \$2248 \$1215 \$978 \$979 NWELL PWELL BULK DFF_X1
X$5995 \$1735 \$1186 \$1198 \$979 NWELL PWELL BULK DFF_X1
X$6000 \$2214 \$2223 \$1719 \$979 NWELL PWELL BULK DFF_X1
X$6002 \$1714 \$1166 \$1163 \$979 NWELL PWELL BULK DFF_X1
X$6005 \$3123 \$2808 \$2812 \$979 NWELL PWELL BULK DFF_X1
X$6007 \$1351 \$1761 \$1764 \$979 NWELL PWELL BULK DFF_X1
X$6010 \$I175203 \$4969 \$5778 \$979 NWELL PWELL BULK DFF_X1
X$6012 \$4006 \$4641 \$4647 \$979 NWELL PWELL BULK DFF_X1
X$6015 \$I175084 \$6803 \$7062 \$979 NWELL PWELL BULK DFF_X1
X$6017 \$I178620 \$6800 \$7467 \$979 NWELL PWELL BULK DFF_X1
X$6020 \$7146 \$7460 \$7145 \$979 NWELL PWELL BULK DFF_X1
X$6023 \$6361 \$6357 \$6354 \$979 NWELL PWELL BULK DFF_X1
X$6025 \$I175199 \$6798 \$6797 \$979 NWELL PWELL BULK DFF_X1
X$6027 \$I178840 \$5352 \$5458 \$979 NWELL PWELL BULK DFF_X1
X$6029 \$I175225 \$6072 \$6367 \$979 NWELL PWELL BULK DFF_X1
X$6032 \$I174941 \$6076 \$6426 \$979 NWELL PWELL BULK DFF_X1
X$6035 \$I175739 \$4289 \$4288 \$979 NWELL PWELL BULK DFF_X1
X$6037 \$2783 \$2773 \$2267 \$979 NWELL PWELL BULK DFF_X1
X$6039 \$I178951 \$3141 \$2881 \$979 NWELL PWELL BULK DFF_X1
X$6042 \$I175148 \$3545 \$3151 \$979 NWELL PWELL BULK DFF_X1
X$6044 \$4017 \$979 NWELL PWELL BULK BUF_X4
X$6047 \$5046 \$5047 \$5045 \$979 NWELL PWELL BULK DFF_X1
X$6050 \$3629 \$3882 \$4279 \$979 NWELL PWELL BULK DFF_X1
X$6052 \$I178942 \$3998 \$4363 \$979 NWELL PWELL BULK DFF_X1
X$6055 \$I178965 \$4293 \$4365 \$979 NWELL PWELL BULK DFF_X1
X$6058 \$I176122 \$5041 \$5720 \$979 NWELL PWELL BULK DFF_X1
X$6060 \$I175149 \$4719 \$4963 \$979 NWELL PWELL BULK DFF_X1
X$6062 \$I176143 \$4715 \$4977 \$979 NWELL PWELL BULK DFF_X1
X$6064 \$4283 \$3895 \$4285 \$979 NWELL PWELL BULK DFF_X1
X$6066 \$3243 \$3533 \$3543 \$979 NWELL PWELL BULK DFF_X1
X$6095 \$3533 \$1849 \$983 \$3543 NWELL PWELL BULK MUX2_X1
X$6098 \$7483 \$3964 \$7481 \$985 NWELL PWELL BULK MUX2_X1
X$6104 \$2196 \$1861 \$988 \$2397 NWELL PWELL BULK MUX2_X1
X$6106 \$1369 \$989 \$1139 \$991 NWELL PWELL BULK DFF_X1
X$6109 \$I178843 \$5704 \$5471 \$991 NWELL PWELL BULK DFF_X1
X$6111 \$I174830 \$5789 \$6083 \$991 NWELL PWELL BULK DFF_X1
X$6113 \$I174447 \$6816 \$7012 \$991 NWELL PWELL BULK DFF_X1
X$6115 \$I174448 \$7152 \$7800 \$991 NWELL PWELL BULK DFF_X1
X$6117 \$I178845 \$5065 \$5062 \$991 NWELL PWELL BULK DFF_X1
X$6119 \$I178485 \$6095 \$6292 \$991 NWELL PWELL BULK DFF_X1
X$6122 \$3118 \$2825 \$2823 \$991 NWELL PWELL BULK DFF_X1
X$6125 \$5050 \$5399 \$5400 \$991 NWELL PWELL BULK DFF_X1
X$6128 \$4633 \$4636 \$4368 \$991 NWELL PWELL BULK DFF_X1
X$6130 \$4007 \$4271 \$3862 \$991 NWELL PWELL BULK DFF_X1
X$6133 \$4017 \$991 NWELL PWELL BULK BUF_X4
X$6136 \$I177972 \$4729 \$4727 \$991 NWELL PWELL BULK DFF_X1
X$6139 \$I176379 \$5377 \$5066 \$991 NWELL PWELL BULK DFF_X1
X$6142 \$I176404 \$2896 \$3088 \$991 NWELL PWELL BULK DFF_X1
X$6145 \$I176386 \$4732 \$5368 \$991 NWELL PWELL BULK DFF_X1
X$6148 \$I177970 \$4898 \$4373 \$991 NWELL PWELL BULK DFF_X1
X$6151 \$I177969 \$4021 \$4601 \$991 NWELL PWELL BULK DFF_X1
X$6154 \$I176163 \$3650 \$3647 \$991 NWELL PWELL BULK DFF_X1
X$6156 \$I176402 \$3258 \$3255 \$991 NWELL PWELL BULK DFF_X1
X$6159 \$5392 \$4941 \$4948 \$991 NWELL PWELL BULK DFF_X1
X$6162 \$4933 \$4937 \$4939 \$991 NWELL PWELL BULK DFF_X1
X$6164 \$I176574 \$2403 \$2789 \$991 NWELL PWELL BULK DFF_X1
X$6166 \$I177973 \$2402 \$3079 \$991 NWELL PWELL BULK DFF_X1
X$6170 \$1366 \$1154 \$1150 \$991 NWELL PWELL BULK DFF_X1
X$6173 \$I178337 \$2160 \$1370 \$991 NWELL PWELL BULK DFF_X1
X$6176 \$I178300 \$1871 \$2807 \$991 NWELL PWELL BULK DFF_X1
X$6178 \$2172 \$1865 \$1867 \$991 NWELL PWELL BULK DFF_X1
X$6182 \$1863 \$2186 \$1860 \$991 NWELL PWELL BULK DFF_X1
X$6184 \$I177674 \$1375 \$1374 \$991 NWELL PWELL BULK DFF_X1
X$6210 \$I175405 \$4742 \$4740 \$996 NWELL PWELL BULK DFF_X1
X$6213 \$I178258 \$5080 \$5078 \$996 NWELL PWELL BULK DFF_X1
X$6215 \$I178262 \$4167 \$4381 \$996 NWELL PWELL BULK DFF_X1
X$6217 \$I178448 \$4734 \$5490 \$996 NWELL PWELL BULK DFF_X1
X$6219 \$I177986 \$1379 \$1661 \$996 NWELL PWELL BULK DFF_X1
X$6222 \$I176164 \$3279 \$3013 \$996 NWELL PWELL BULK DFF_X1
X$6224 \$I178439 \$4744 \$5277 \$996 NWELL PWELL BULK DFF_X1
X$6226 \$I178410 \$4145 \$3756 \$996 NWELL PWELL BULK DFF_X1
X$6229 \$I178437 \$4386 \$4564 \$996 NWELL PWELL BULK DFF_X1
X$6231 \$I176528 \$2406 \$2754 \$996 NWELL PWELL BULK DFF_X1
X$6234 \$I175442 \$3401 \$3795 \$996 NWELL PWELL BULK DFF_X1
X$6237 \$I177685 \$3271 \$3652 \$996 NWELL PWELL BULK DFF_X1
X$6239 \$I176511 \$4377 \$4211 \$996 NWELL PWELL BULK DFF_X1
X$6241 \$I177778 \$1383 \$2771 \$996 NWELL PWELL BULK DFF_X1
X$6243 \$I178408 \$3058 \$3063 \$996 NWELL PWELL BULK DFF_X1
X$6247 \$I175432 \$3395 \$2409 \$996 NWELL PWELL BULK DFF_X1
X$6250 \$I175394 \$3383 \$3275 \$996 NWELL PWELL BULK DFF_X1
X$6253 \$I178263 \$3657 \$4034 \$996 NWELL PWELL BULK DFF_X1
X$6256 \$4017 \$996 NWELL PWELL BULK BUF_X4
X$6259 \$I175694 \$3654 \$3656 \$996 NWELL PWELL BULK DFF_X1
X$6262 \$I176625 \$4378 \$4890 \$996 NWELL PWELL BULK DFF_X1
X$6264 \$I178414 \$1000 \$1099 \$996 NWELL PWELL BULK DFF_X1
X$6266 \$I175443 \$1388 \$1612 \$996 NWELL PWELL BULK DFF_X1
X$6272 \$I178409 \$2908 \$3273 \$996 NWELL PWELL BULK DFF_X1
X$6274 \$I176246 \$2411 \$2905 \$996 NWELL PWELL BULK DFF_X1
X$6276 \$I177925 \$1390 \$2724 \$996 NWELL PWELL BULK DFF_X1
X$6278 \$I177573 \$1889 \$1887 \$996 NWELL PWELL BULK DFF_X1
X$6281 \$I175366 \$2413 \$2714 \$996 NWELL PWELL BULK DFF_X1
X$6311 \$5921 \$2414 \$5918 \$1005 NWELL PWELL BULK MUX2_X1
X$6316 \$I178184 \$5814 \$5903 \$1007 NWELL PWELL BULK DFF_X1
X$6318 \$I178432 \$5627 \$5628 \$1007 NWELL PWELL BULK DFF_X1
X$6321 \$I178433 \$5263 \$5636 \$1007 NWELL PWELL BULK DFF_X1
X$6324 \$I178185 \$5083 \$5812 \$1007 NWELL PWELL BULK DFF_X1
X$6326 \$I175764 \$6470 \$6469 \$1007 NWELL PWELL BULK DFF_X1
X$6329 \$I175392 \$6111 \$6467 \$1007 NWELL PWELL BULK DFF_X1
X$6332 \$I178435 \$5237 \$5500 \$1007 NWELL PWELL BULK DFF_X1
X$6335 \$I178189 \$6463 \$6634 \$1007 NWELL PWELL BULK DFF_X1
X$6338 \$I176012 \$6840 \$7413 \$1007 NWELL PWELL BULK DFF_X1
X$6340 \$I178431 \$7389 \$7175 \$1007 NWELL PWELL BULK DFF_X1
X$6342 \$I177922 \$2419 \$2418 \$1007 NWELL PWELL BULK DFF_X1
X$6345 \$I177981 \$3280 \$2913 \$1007 NWELL PWELL BULK DFF_X1
X$6347 \$I179081 \$2420 \$1893 \$1007 NWELL PWELL BULK DFF_X1
X$6349 \$I177982 \$1540 \$1896 \$1007 NWELL PWELL BULK DFF_X1
X$6358 \$I176375 \$4048 \$4134 \$1007 NWELL PWELL BULK DFF_X1
X$6360 \$I176139 \$3284 \$2999 \$1007 NWELL PWELL BULK DFF_X1
X$6363 \$I175360 \$5089 \$5235 \$1007 NWELL PWELL BULK DFF_X1
X$6366 \$I176165 \$3282 \$3743 \$1007 NWELL PWELL BULK DFF_X1
X$6369 \$4017 \$1007 NWELL PWELL BULK BUF_X4
X$6372 \$I176130 \$4390 \$4043 \$1007 NWELL PWELL BULK DFF_X1
X$6374 \$I177860 \$4745 \$4746 \$1007 NWELL PWELL BULK DFF_X1
X$6377 \$I178913 \$1902 \$1901 \$1007 NWELL PWELL BULK DFF_X1
X$6380 \$I178991 \$1405 \$1897 \$1007 NWELL PWELL BULK DFF_X1
X$6383 \$I177923 \$2915 \$3003 \$1007 NWELL PWELL BULK DFF_X1
X$6386 \$I175371 \$5506 \$5618 \$1007 NWELL PWELL BULK DFF_X1
X$6389 \$I176133 \$4391 \$4834 \$1007 NWELL PWELL BULK DFF_X1
X$6391 \$I176381 \$4522 \$4531 \$1007 NWELL PWELL BULK DFF_X1
X$6420 \$1022 \$2545 NWELL PWELL BULK INV_X1
X$6427 \$1023 \$2450 \$2524 \$2527 NWELL PWELL BULK MUX2_X1
X$6429 \$1023 \$1912 \$2510 \$2518 NWELL PWELL BULK MUX2_X1
X$6431 \$3293 \$2963 \$1023 \$3327 NWELL PWELL BULK MUX2_X1
X$6433 \$1023 \$2925 \$3296 \$3716 NWELL PWELL BULK MUX2_X1
X$6439 \$6168 \$2963 \$1024 \$5831 NWELL PWELL BULK MUX2_X1
X$6441 \$1024 \$2925 \$6546 \$6129 NWELL PWELL BULK MUX2_X1
X$6444 \$1024 \$2450 \$6537 \$6490 NWELL PWELL BULK MUX2_X1
X$6447 \$1024 \$1912 \$6531 \$6535 NWELL PWELL BULK MUX2_X1
X$6456 \$1025 \$1912 \$2460 \$2462 NWELL PWELL BULK MUX2_X1
X$6459 \$1025 \$2450 \$2461 \$1422 NWELL PWELL BULK MUX2_X1
X$6462 \$1025 \$2925 \$2939 \$2457 NWELL PWELL BULK MUX2_X1
X$6465 \$3305 \$2963 \$1025 \$3306 NWELL PWELL BULK MUX2_X1
X$6470 AXI_CLK \$24703 NWELL PWELL BULK BUF_X4
X$6481 \$1029 \$2450 \$5534 \$5529 NWELL PWELL BULK MUX2_X1
X$6484 \$5541 \$2963 \$1029 \$5550 NWELL PWELL BULK MUX2_X1
X$6487 \$1029 \$1912 \$5526 \$5522 NWELL PWELL BULK MUX2_X1
X$6489 \$1029 \$2925 \$5103 \$5119 NWELL PWELL BULK MUX2_X1
X$6503 \$1400 \$1039 \$1484 NWELL PWELL BULK NAND2_X1
X$6516 \$1411 \$1047 \$2430 NWELL PWELL BULK NAND2_X4
X$6597 \$6035 \$2301 \$1104 \$6146 NWELL PWELL BULK MUX2_X1
X$6599 \$6509 \$1777 \$1104 \$6506 NWELL PWELL BULK MUX2_X1
X$6621 \$2792 \$1125 \$27477 NWELL PWELL BULK NAND2_X2
X$6634 \$13773 \$1777 \$1126 \$13959 NWELL PWELL BULK MUX2_X1
X$6637 \$14121 \$2301 \$1126 \$14699 NWELL PWELL BULK MUX2_X1
X$6646 \$17922 \$1777 \$1128 \$18168 NWELL PWELL BULK MUX2_X1
X$6652 \$17563 \$2301 \$1128 \$17768 NWELL PWELL BULK MUX2_X1
X$6667 \$23053 \$18371 \$1138 \$22927 NWELL PWELL BULK MUX2_X1
X$6672 \$24219 \$17204 \$1138 \$25165 NWELL PWELL BULK MUX2_X1
X$6687 \$4099 \$2301 \$1141 \$3724 NWELL PWELL BULK MUX2_X1
X$6690 \$4094 \$1777 \$1141 \$3943 NWELL PWELL BULK MUX2_X1
X$6711 \$5791 \$2782 \$5980 \$1155 NWELL PWELL BULK MUX2_X1
X$6718 \$20579 \$18371 \$1156 \$20576 NWELL PWELL BULK MUX2_X1
X$6723 \$20105 \$17204 \$1156 \$20569 NWELL PWELL BULK MUX2_X1
X$6748 \$21420 \$17204 \$1167 \$21626 NWELL PWELL BULK MUX2_X1
X$6751 \$21858 \$18371 \$1167 \$22089 NWELL PWELL BULK MUX2_X1
X$6768 \$15309 \$1777 \$1169 \$15592 NWELL PWELL BULK MUX2_X1
X$6771 \$15597 \$2301 \$1169 \$15847 NWELL PWELL BULK MUX2_X1
X$6790 \$8663 \$1849 \$1174 \$8656 NWELL PWELL BULK MUX2_X1
X$6808 \$18346 \$1777 \$1178 \$18579 NWELL PWELL BULK MUX2_X1
X$6811 \$18752 \$2301 \$1178 \$18971 NWELL PWELL BULK MUX2_X1
X$6824 \$19956 \$17204 \$1179 \$19959 NWELL PWELL BULK MUX2_X1
X$6828 \$19472 \$18371 \$1179 \$19409 NWELL PWELL BULK MUX2_X1
X$6835 \$2573 \$1183 \$18587 NWELL PWELL BULK NAND2_X4
X$6845 \$24210 \$17204 \$1184 \$24331 NWELL PWELL BULK MUX2_X1
X$6849 \$23709 \$18371 \$1184 \$23241 NWELL PWELL BULK MUX2_X1
X$6871 \$22788 \$18371 \$1208 \$22783 NWELL PWELL BULK MUX2_X1
X$6875 \$23686 \$17204 \$1208 \$24091 NWELL PWELL BULK MUX2_X1
X$6886 \$20543 \$18371 \$1210 \$20822 NWELL PWELL BULK MUX2_X1
X$6892 \$22799 \$17204 \$1210 \$22798 NWELL PWELL BULK MUX2_X1
X$6905 \$1222 \$54547 \$54082 \$55498 NWELL PWELL BULK OR3_X4
X$6907 \$1222 \$52568 \$51643 NWELL PWELL BULK NAND2_X1
X$6909 \$1222 \$52922 \$53068 NWELL PWELL BULK NAND2_X1
X$6911 \$1222 \$53254 \$53251 NWELL PWELL BULK NAND2_X1
X$6913 \$1222 \$51477 \$50195 \$I241572 NWELL PWELL BULK HA_X1
X$6916 \$1222 \$51641 NWELL PWELL BULK INV_X4
X$6918 \$1222 \$54082 \$53250 NWELL PWELL BULK NAND2_X1
X$6921 \$1222 \$54084 \$54086 NWELL PWELL BULK NAND2_X1
X$6923 \$54082 \$54084 \$1222 \$55501 NWELL PWELL BULK NOR3_X4
X$6942 \$1228 \$2620 \$1815 \$2628 NWELL PWELL BULK MUX2_X2
X$6950 \$2732 \$1849 \$1231 \$2743 NWELL PWELL BULK MUX2_X1
X$6961 \$17574 \$7143 \$1234 \$17419 NWELL PWELL BULK MUX2_X1
X$6964 \$18995 \$11378 \$1234 \$19315 NWELL PWELL BULK MUX2_X1
X$6967 \$1234 \$1308 \$17931 \$17929 NWELL PWELL BULK MUX2_X1
X$6969 \$1234 \$1242 \$19108 \$19320 NWELL PWELL BULK MUX2_X1
X$6980 \$21371 \$20336 \$1237 \$21629 NWELL PWELL BULK MUX2_X1
X$6985 \$20671 \$2301 \$1237 \$20669 NWELL PWELL BULK MUX2_X1
X$7002 \$18775 \$17204 \$1239 \$19068 NWELL PWELL BULK MUX2_X1
X$7006 \$18376 \$18371 \$1239 \$17950 NWELL PWELL BULK MUX2_X1
X$7014 \$1276 \$1242 \$17195 \$16647 NWELL PWELL BULK MUX2_X1
X$7017 \$33097 \$1242 \$33759 \$33891 NWELL PWELL BULK MUX2_X1
X$7020 \$30764 \$30762 \$31013 \$1242 NWELL PWELL BULK NAND3_X4
X$7022 \$2339 \$1242 \$6754 \$6957 NWELL PWELL BULK MUX2_X1
X$7025 \$1342 \$1242 \$1344 \$1716 NWELL PWELL BULK MUX2_X1
X$7028 \$2112 \$1242 \$8360 \$8553 NWELL PWELL BULK MUX2_X1
X$7035 \$1314 \$1242 \$3051 \$3050 NWELL PWELL BULK MUX2_X1
X$7038 \$4677 \$1242 \$4854 \$4852 NWELL PWELL BULK MUX2_X1
X$7041 \$1821 \$1242 \$5615 \$5202 NWELL PWELL BULK MUX2_X1
X$7047 \$2717 \$1242 \$6343 \$6068 NWELL PWELL BULK MUX2_X1
X$7050 \$1257 \$1242 \$16194 \$16645 NWELL PWELL BULK MUX2_X1
X$7053 \$1606 \$1242 \$14994 \$15319 NWELL PWELL BULK MUX2_X1
X$7056 \$33472 \$1242 \$34375 \$34374 NWELL PWELL BULK MUX2_X1
X$7059 \$31363 \$1242 \$32961 \$32950 NWELL PWELL BULK MUX2_X1
X$7062 \$2098 \$1242 \$11605 \$11723 NWELL PWELL BULK MUX2_X1
X$7064 \$2168 \$1242 \$12650 \$12930 NWELL PWELL BULK MUX2_X1
X$7067 \$2134 \$1242 \$13788 \$13450 NWELL PWELL BULK MUX2_X1
X$7070 \$33090 \$1242 \$32905 \$31760 NWELL PWELL BULK MUX2_X1
X$7072 \$30249 \$1242 \$30945 \$31309 NWELL PWELL BULK MUX2_X1
X$7077 \$22240 \$1242 \$22574 \$22242 NWELL PWELL BULK MUX2_X1
X$7079 \$33111 \$1242 \$34317 \$33900 NWELL PWELL BULK MUX2_X1
X$7082 \$30861 \$1242 \$33696 \$33480 NWELL PWELL BULK MUX2_X1
X$7085 \$33736 \$1242 \$33728 \$33732 NWELL PWELL BULK MUX2_X1
X$7087 \$1837 \$1242 \$3920 \$3990 NWELL PWELL BULK MUX2_X1
X$7089 \$1333 \$1242 \$2676 \$2669 NWELL PWELL BULK MUX2_X1
X$7092 \$9459 \$1242 \$11377 \$11722 NWELL PWELL BULK MUX2_X1
X$7095 \$2101 \$1242 \$18210 \$18352 NWELL PWELL BULK MUX2_X1
X$7098 \$2105 \$1242 \$15318 \$15853 NWELL PWELL BULK MUX2_X1
X$7101 \$2625 \$1242 \$3958 \$4533 NWELL PWELL BULK MUX2_X1
X$7104 \$1246 \$1242 \$9550 \$9548 NWELL PWELL BULK MUX2_X1
X$7108 \$2111 \$1242 \$3952 \$4160 NWELL PWELL BULK MUX2_X1
X$7111 \$2106 \$1242 \$8704 \$9063 NWELL PWELL BULK MUX2_X1
X$7116 \$1260 \$1242 \$19341 \$19657 NWELL PWELL BULK MUX2_X1
X$7119 \$3196 \$1242 \$10979 \$11232 NWELL PWELL BULK MUX2_X1
X$7121 \$2375 \$1242 \$8222 \$8226 NWELL PWELL BULK MUX2_X1
X$7124 \$2119 \$1242 \$12644 \$12923 NWELL PWELL BULK MUX2_X1
X$7168 \$27916 \$1242 \$29503 \$29138 NWELL PWELL BULK MUX2_X1
X$7207 \$17585 \$9707 \$1244 \$17855 NWELL PWELL BULK MUX2_X1
X$7210 \$18771 \$17204 \$1244 \$18769 NWELL PWELL BULK MUX2_X1
X$7223 \$8361 \$7143 \$1246 \$8561 NWELL PWELL BULK MUX2_X1
X$7226 \$1246 \$1308 \$7876 \$7875 NWELL PWELL BULK MUX2_X1
X$7234 \$18768 \$18371 \$1251 \$19359 NWELL PWELL BULK MUX2_X1
X$7237 \$19706 \$17204 \$1251 \$20003 NWELL PWELL BULK MUX2_X1
X$7251 \$10990 \$1849 \$1254 \$11276 NWELL PWELL BULK MUX2_X1
X$7266 \$16193 \$11378 \$1257 \$16494 NWELL PWELL BULK MUX2_X1
X$7269 \$16947 \$7143 \$1257 \$18232 NWELL PWELL BULK MUX2_X1
X$7271 \$1257 \$1308 \$16643 \$17425 NWELL PWELL BULK MUX2_X1
X$7282 \$20928 \$9707 \$1259 \$21656 NWELL PWELL BULK MUX2_X1
X$7289 \$22582 \$2348 \$1259 \$22107 NWELL PWELL BULK MUX2_X1
X$7303 \$18762 \$11378 \$1260 \$19014 NWELL PWELL BULK MUX2_X1
X$7307 \$20070 \$7143 \$1260 \$19988 NWELL PWELL BULK MUX2_X1
X$7310 \$1260 \$1308 \$20071 \$19997 NWELL PWELL BULK MUX2_X1
X$7330 \$14995 \$9707 \$1268 \$15635 NWELL PWELL BULK MUX2_X1
X$7333 \$14418 \$2348 \$1268 \$14748 NWELL PWELL BULK MUX2_X1
X$7347 \$19643 \$9707 \$1270 \$19110 NWELL PWELL BULK MUX2_X1
X$7349 \$20065 \$2348 \$1270 \$20403 NWELL PWELL BULK MUX2_X1
X$7360 \$13226 \$2348 \$1275 \$13224 NWELL PWELL BULK MUX2_X1
X$7363 \$14423 \$9707 \$1275 \$14353 NWELL PWELL BULK MUX2_X1
X$7377 \$1276 \$1308 \$15323 \$15646 NWELL PWELL BULK MUX2_X1
X$7379 \$16195 \$7143 \$1276 \$16502 NWELL PWELL BULK MUX2_X1
X$7381 \$17194 \$11378 \$1276 \$18240 NWELL PWELL BULK MUX2_X1
X$7417 \$16042 \$9693 \$15537 \$1297 NWELL PWELL BULK MUX2_X1
X$7431 \$2851 \$2313 \$1305 \$3005 NWELL PWELL BULK MUX2_X1
X$7436 \$3777 \$1785 \$1305 \$3769 NWELL PWELL BULK MUX2_X1
X$7443 \$22240 \$1308 \$21790 \$21791 NWELL PWELL BULK MUX2_X1
X$7446 \$27916 \$1308 \$29049 \$29045 NWELL PWELL BULK MUX2_X1
X$7449 \$30764 \$31012 \$31013 \$1308 NWELL PWELL BULK NAND3_X4
X$7453 \$30249 \$1308 \$32048 \$31674 NWELL PWELL BULK MUX2_X1
X$7455 \$2717 \$1308 \$5333 \$5326 NWELL PWELL BULK MUX2_X1
X$7460 \$1821 \$1308 \$5608 \$5604 NWELL PWELL BULK MUX2_X1
X$7463 \$1333 \$1308 \$1334 \$1666 NWELL PWELL BULK MUX2_X1
X$7466 \$2168 \$1308 \$12026 \$11947 NWELL PWELL BULK MUX2_X1
X$7469 \$3196 \$1308 \$9705 \$9858 NWELL PWELL BULK MUX2_X1
X$7474 \$4677 \$1308 \$6225 \$6221 NWELL PWELL BULK MUX2_X1
X$7477 \$2375 \$1308 \$7435 \$7440 NWELL PWELL BULK MUX2_X1
X$7485 \$1314 \$1308 \$1317 \$1591 NWELL PWELL BULK MUX2_X1
X$7489 \$1606 \$1308 \$16191 \$17421 NWELL PWELL BULK MUX2_X1
X$7492 \$33736 \$1308 \$33735 \$33743 NWELL PWELL BULK MUX2_X1
X$7495 \$33472 \$1308 \$33748 \$33752 NWELL PWELL BULK MUX2_X1
X$7498 \$9459 \$1308 \$11208 \$11587 NWELL PWELL BULK MUX2_X1
X$7501 \$2119 \$1308 \$13784 \$13447 NWELL PWELL BULK MUX2_X1
X$7503 \$2134 \$1308 \$12367 \$12645 NWELL PWELL BULK MUX2_X1
X$7505 \$33090 \$1308 \$33787 \$33465 NWELL PWELL BULK MUX2_X1
X$7507 \$33097 \$1308 \$33314 \$33316 NWELL PWELL BULK MUX2_X1
X$7509 \$31363 \$1308 \$31367 \$31369 NWELL PWELL BULK MUX2_X1
X$7513 \$30861 \$1308 \$32998 \$31776 NWELL PWELL BULK MUX2_X1
X$7522 \$2101 \$1308 \$16476 \$16186 NWELL PWELL BULK MUX2_X1
X$7525 \$1342 \$1308 \$3496 \$3218 NWELL PWELL BULK MUX2_X1
X$7527 \$1837 \$1308 \$2740 \$2735 NWELL PWELL BULK MUX2_X1
X$7532 \$2625 \$1308 \$3386 \$3193 NWELL PWELL BULK MUX2_X1
X$7536 \$2112 \$1308 \$9230 \$9228 NWELL PWELL BULK MUX2_X1
X$7540 \$2339 \$1308 \$8108 \$7870 NWELL PWELL BULK MUX2_X1
X$7543 \$2106 \$1308 \$8092 \$8088 NWELL PWELL BULK MUX2_X1
X$7545 \$2111 \$1308 \$4512 \$4506 NWELL PWELL BULK MUX2_X1
X$7547 \$2098 \$1308 \$10496 \$10616 NWELL PWELL BULK MUX2_X1
X$7549 \$2105 \$1308 \$14131 \$14410 NWELL PWELL BULK MUX2_X1
X$7614 \$33111 \$1308 \$33705 \$33109 NWELL PWELL BULK MUX2_X1
X$7652 \$5010 \$3964 \$5234 \$1321 NWELL PWELL BULK MUX2_X1
X$7662 \$1329 \$1365 \$1630 \$2650 NWELL PWELL BULK MUX2_X1
X$7690 \$8601 \$1849 \$1340 \$8936 NWELL PWELL BULK MUX2_X1
X$7699 \$6767 \$1849 \$1341 \$7005 NWELL PWELL BULK MUX2_X1
X$7727 \$8240 \$3964 \$7814 \$1349 NWELL PWELL BULK MUX2_X1
X$7731 \$2783 \$1365 \$1351 \$2387 NWELL PWELL BULK MUX2_X1
X$7733 \$3977 \$3894 \$2366 \$1353 NWELL PWELL BULK MUX2_X2
X$7736 \$1353 \$1400 \$1540 \$1896 NWELL PWELL BULK MUX2_X1
X$7751 \$5781 \$2782 \$6713 \$1354 NWELL PWELL BULK MUX2_X1
X$7756 \$9886 \$1365 \$9892 \$9983 NWELL PWELL BULK MUX2_X1
X$7758 \$12857 \$1365 \$12657 \$12406 NWELL PWELL BULK MUX2_X1
X$7760 \$10301 \$1365 NWELL PWELL BULK BUF_X16
X$7762 \$12029 \$1365 \$12393 \$12402 NWELL PWELL BULK MUX2_X1
X$7765 \$2248 \$1365 \$1735 \$1852 NWELL PWELL BULK MUX2_X1
X$7767 \$2214 \$1365 \$1714 \$2196 NWELL PWELL BULK MUX2_X1
X$7769 \$3074 \$1365 \$2644 \$2860 NWELL PWELL BULK MUX2_X1
X$7772 \$8290 \$1365 \$8390 \$8301 NWELL PWELL BULK MUX2_X1
X$7775 \$3853 \$1365 \$4209 \$3422 NWELL PWELL BULK MUX2_X1
X$7777 \$2646 \$1365 \$2863 \$2864 NWELL PWELL BULK MUX2_X1
X$7780 \$8384 \$1365 \$8274 \$8293 NWELL PWELL BULK MUX2_X1
X$7782 \$2866 \$1365 \$2867 \$3110 NWELL PWELL BULK MUX2_X1
X$7785 \$1650 \$1365 \$2188 \$1819 NWELL PWELL BULK MUX2_X1
X$7787 \$5050 \$1365 \$4933 \$5415 NWELL PWELL BULK MUX2_X1
X$7790 \$4283 \$1365 \$4006 \$5466 NWELL PWELL BULK MUX2_X1
X$7792 \$6033 \$1365 \$6361 \$5776 NWELL PWELL BULK MUX2_X1
X$7794 \$6645 \$1365 \$6302 \$7025 NWELL PWELL BULK MUX2_X1
X$7796 \$5016 \$1365 \$4687 \$5256 NWELL PWELL BULK MUX2_X1
X$7799 \$1756 \$1365 \$2283 \$1847 NWELL PWELL BULK MUX2_X1
X$7801 \$7131 \$1365 \$7593 \$8169 NWELL PWELL BULK MUX2_X1
X$7803 \$8601 \$1365 \$8369 \$8944 NWELL PWELL BULK MUX2_X1
X$7807 \$7028 \$1365 \$6740 \$7016 NWELL PWELL BULK MUX2_X1
X$7809 \$7519 \$1365 \$7515 \$6813 NWELL PWELL BULK MUX2_X1
X$7812 \$3123 \$1365 \$3118 \$3117 NWELL PWELL BULK MUX2_X1
X$7814 \$4007 \$1365 \$4633 \$4725 NWELL PWELL BULK MUX2_X1
X$7816 \$7146 \$1365 \$7074 \$6708 NWELL PWELL BULK MUX2_X1
X$7820 \$5046 \$1365 \$5392 \$5717 NWELL PWELL BULK MUX2_X1
X$7823 \$3243 \$1365 \$3629 \$3878 NWELL PWELL BULK MUX2_X1
X$7825 \$2172 \$1365 \$1369 \$2174 NWELL PWELL BULK MUX2_X1
X$7828 \$1863 \$1365 \$1366 \$1368 NWELL PWELL BULK MUX2_X1
X$7832 \$3438 \$1365 \$3443 \$3445 NWELL PWELL BULK MUX2_X1
X$7834 \$5266 \$1365 \$5019 \$5443 NWELL PWELL BULK MUX2_X1
X$7837 \$7890 \$1365 \$7830 \$7893 NWELL PWELL BULK MUX2_X1
X$7839 \$8164 \$1365 \$7886 \$8177 NWELL PWELL BULK MUX2_X1
X$7841 \$7877 \$1365 \$7878 \$8157 NWELL PWELL BULK MUX2_X1
X$7844 \$8935 \$1365 \$9372 \$9373 NWELL PWELL BULK MUX2_X1
X$7846 \$7018 \$1365 \$6771 \$6772 NWELL PWELL BULK MUX2_X1
X$7849 \$9709 \$1365 \$9078 \$9906 NWELL PWELL BULK MUX2_X1
X$7851 \$10987 \$1365 \$10526 \$11651 NWELL PWELL BULK MUX2_X1
X$7853 \$11387 \$1365 \$11648 \$11653 NWELL PWELL BULK MUX2_X1
X$7855 \$10621 \$1365 \$10986 \$10296 NWELL PWELL BULK MUX2_X1
X$7857 \$7591 \$1365 \$7353 \$8160 NWELL PWELL BULK MUX2_X1
X$7860 \$6401 \$1365 \$5751 \$6615 NWELL PWELL BULK MUX2_X1
X$7862 \$6051 \$1365 \$6258 \$6261 NWELL PWELL BULK MUX2_X1
X$7864 \$2752 \$1365 \$1845 \$2755 NWELL PWELL BULK MUX2_X1
X$7867 \$3597 \$1365 \$3065 \$3410 NWELL PWELL BULK MUX2_X1
X$7869 \$7388 \$1365 \$8204 \$8620 NWELL PWELL BULK MUX2_X1
X$7871 \$7414 \$1365 \$7897 \$8622 NWELL PWELL BULK MUX2_X1
X$7927 \$1368 \$1861 \$2174 \$1868 NWELL PWELL BULK MUX2_X1
X$7932 \$2167 \$1371 \$1870 \$1370 NWELL PWELL BULK OAI21_X1
X$7935 \$27864 \$27475 \$28518 \$1371 NWELL PWELL BULK NAND3_X4
X$7937 \$11763 \$1371 \$11766 \$12590 NWELL PWELL BULK MUX2_X1
X$7939 \$26447 \$1371 \$27849 \$28396 NWELL PWELL BULK MUX2_X1
X$7941 \$9396 \$1371 \$9405 \$9736 NWELL PWELL BULK MUX2_X1
X$7943 \$11280 \$1371 \$11412 \$11411 NWELL PWELL BULK MUX2_X1
X$7945 \$14468 \$1371 \$14474 \$14177 NWELL PWELL BULK MUX2_X1
X$7947 \$24990 \$1371 \$24995 \$25159 NWELL PWELL BULK MUX2_X1
X$7949 \$16245 \$1371 \$15882 \$17105 NWELL PWELL BULK MUX2_X1
X$7952 \$24976 \$1371 \$26976 \$26971 NWELL PWELL BULK MUX2_X1
X$7954 \$22298 \$1371 \$22313 \$22933 NWELL PWELL BULK MUX2_X1
X$7957 \$19729 \$1371 \$19940 \$19478 NWELL PWELL BULK MUX2_X1
X$7959 \$17970 \$1371 \$18677 \$18235 NWELL PWELL BULK MUX2_X1
X$7962 \$26452 \$1371 \$26456 \$26454 NWELL PWELL BULK MUX2_X1
X$7965 \$10016 \$1371 \$10252 \$10017 NWELL PWELL BULK MUX2_X1
X$7967 \$19397 \$1371 \$20706 \$21271 NWELL PWELL BULK MUX2_X1
X$7970 \$13668 \$1371 \$13484 \$13485 NWELL PWELL BULK MUX2_X1
X$7972 \$9115 \$1371 \$10023 \$10230 NWELL PWELL BULK MUX2_X1
X$7975 \$12072 \$1371 \$12532 \$12530 NWELL PWELL BULK MUX2_X1
X$7978 \$24528 \$1371 \$25982 \$26144 NWELL PWELL BULK MUX2_X1
X$7981 \$13467 \$1371 \$13818 \$14063 NWELL PWELL BULK MUX2_X1
X$7984 \$1371 \$5377 \$5483 NWELL PWELL BULK NAND2_X1
X$7987 \$5048 \$1371 \$5483 \$5066 NWELL PWELL BULK OAI21_X1
X$7990 \$1371 \$6446 \$6285 NWELL PWELL BULK NAND2_X1
X$7992 \$5957 \$1371 \$6285 \$6097 NWELL PWELL BULK OAI21_X1
X$7994 \$10338 \$1371 \$10652 \$11277 NWELL PWELL BULK MUX2_X1
X$7996 \$12960 \$1371 \$12681 \$12831 NWELL PWELL BULK MUX2_X1
X$7999 \$9402 \$1371 \$9744 \$9410 NWELL PWELL BULK MUX2_X1
X$8001 \$1371 \$8397 \$8396 NWELL PWELL BULK NAND2_X1
X$8004 \$6787 \$1371 \$8396 \$8393 NWELL PWELL BULK OAI21_X1
X$8006 \$11904 \$1371 \$10871 \$11268 NWELL PWELL BULK MUX2_X1
X$8008 \$3610 \$1371 \$5408 \$5471 NWELL PWELL BULK OAI21_X1
X$8010 \$1371 \$5704 \$5408 NWELL PWELL BULK NAND2_X1
X$8012 \$3645 \$1371 \$3800 \$3647 NWELL PWELL BULK OAI21_X1
X$8014 \$1371 \$3650 \$3800 NWELL PWELL BULK NAND2_X1
X$8016 \$1371 \$6076 \$6074 NWELL PWELL BULK NAND2_X1
X$8018 \$6070 \$1371 \$6074 \$6426 NWELL PWELL BULK OAI21_X1
X$8021 \$3624 \$1371 \$5036 \$4977 NWELL PWELL BULK OAI21_X1
X$8024 \$3620 \$1371 \$4298 \$4363 NWELL PWELL BULK OAI21_X1
X$8027 \$1371 \$3998 \$4298 NWELL PWELL BULK NAND2_X1
X$8030 \$1371 \$4715 \$5036 NWELL PWELL BULK NAND2_X1
X$8033 \$16686 \$1371 \$17151 \$17149 NWELL PWELL BULK MUX2_X1
X$8035 \$17221 \$1371 \$17227 \$17977 NWELL PWELL BULK MUX2_X1
X$8038 \$15872 \$1371 \$16123 \$15873 NWELL PWELL BULK MUX2_X1
X$8040 \$11021 \$1371 \$11026 \$10648 NWELL PWELL BULK MUX2_X1
X$8042 \$16589 \$1371 \$17094 \$17093 NWELL PWELL BULK MUX2_X1
X$8044 \$7158 \$1371 \$7510 \$7532 NWELL PWELL BULK OAI21_X1
X$8046 \$1371 \$6827 \$7510 NWELL PWELL BULK NAND2_X1
X$8048 \$1371 \$8409 \$8628 NWELL PWELL BULK NAND2_X1
X$8051 \$8285 \$1371 \$8628 \$8407 NWELL PWELL BULK OAI21_X1
X$8054 \$5492 \$1371 \$5493 \$5646 NWELL PWELL BULK OAI21_X1
X$8056 \$1371 \$4736 \$5493 NWELL PWELL BULK NAND2_X1
X$8058 \$1371 \$6460 \$6459 NWELL PWELL BULK NAND2_X1
X$8061 \$5482 \$1371 \$6459 \$6651 NWELL PWELL BULK OAI21_X1
X$8065 \$1371 \$2160 \$1870 NWELL PWELL BULK NAND2_X1
X$8070 \$1377 \$1371 \$1378 \$1661 NWELL PWELL BULK OAI21_X1
X$8072 \$3071 \$1371 \$3270 \$3652 NWELL PWELL BULK OAI21_X1
X$8075 \$1371 \$3271 \$3270 NWELL PWELL BULK NAND2_X1
X$8077 \$1371 \$1881 \$2754 NWELL PWELL BULK NAND2_X1
X$8079 \$4380 \$1371 \$4035 \$4034 NWELL PWELL BULK OAI21_X1
X$8082 \$1371 \$3657 \$4035 NWELL PWELL BULK NAND2_X1
X$8085 \$1371 \$2908 \$3391 NWELL PWELL BULK NAND2_X1
X$8087 \$3044 \$1371 \$3391 \$3273 NWELL PWELL BULK OAI21_X1
X$8089 \$26485 \$1371 \$27874 \$27560 NWELL PWELL BULK MUX2_X1
X$8091 \$23806 \$1371 \$23965 \$23966 NWELL PWELL BULK MUX2_X1
X$8093 \$20990 \$1371 \$21429 \$21609 NWELL PWELL BULK MUX2_X1
X$8095 \$25975 \$1371 \$25426 \$26170 NWELL PWELL BULK MUX2_X1
X$8098 \$27230 \$1371 \$27126 \$28426 NWELL PWELL BULK MUX2_X1
X$8100 \$20992 \$1371 \$21435 \$22827 NWELL PWELL BULK MUX2_X1
X$8181 \$1371 \$1379 \$1378 NWELL PWELL BULK NAND2_X1
X$8185 \$3654 \$1372 \$3395 \$3775 NWELL PWELL BULK MUX2_X1
X$8187 \$2411 \$1372 \$2908 \$2699 NWELL PWELL BULK MUX2_X1
X$8189 \$3383 \$1372 \$2413 \$2691 NWELL PWELL BULK MUX2_X1
X$8192 \$5801 \$1372 \$6105 \$5642 NWELL PWELL BULK MUX2_X1
X$8194 \$4167 \$1372 \$3657 \$4162 NWELL PWELL BULK MUX2_X1
X$8197 \$5075 \$1372 \$4736 \$5076 NWELL PWELL BULK MUX2_X1
X$8200 \$16688 \$1372 \$17151 \$15892 NWELL PWELL BULK MUX2_X1
X$8203 \$3058 \$1372 \$2406 \$3057 NWELL PWELL BULK MUX2_X1
X$8206 \$5065 \$1372 \$5377 \$5068 NWELL PWELL BULK MUX2_X1
X$8209 \$4729 \$1372 \$4021 \$4219 NWELL PWELL BULK MUX2_X1
X$8211 \$6453 \$1372 \$6455 \$6672 NWELL PWELL BULK MUX2_X1
X$8214 \$26486 \$1372 \$27134 \$27486 NWELL PWELL BULK MUX2_X1
X$8216 \$2896 \$1372 \$3258 \$2800 NWELL PWELL BULK MUX2_X1
X$8219 \$24713 \$1372 \$25143 \$24229 NWELL PWELL BULK MUX2_X1
X$8221 \$1375 \$1372 \$1379 \$2786 NWELL PWELL BULK MUX2_X1
X$8224 \$5071 \$1372 \$4732 \$4896 NWELL PWELL BULK MUX2_X1
X$8227 \$4898 \$1372 \$3650 \$3805 NWELL PWELL BULK MUX2_X1
X$8229 \$16691 \$1372 \$17140 \$15893 NWELL PWELL BULK MUX2_X1
X$8232 \$7930 \$1372 \$8409 \$7931 NWELL PWELL BULK MUX2_X1
X$8234 \$8311 \$1372 \$7758 \$7512 NWELL PWELL BULK MUX2_X1
X$8236 \$8764 \$1372 \$8766 \$8263 NWELL PWELL BULK MUX2_X1
X$8238 \$5497 \$1372 \$6107 \$5918 NWELL PWELL BULK MUX2_X1
X$8241 \$4742 \$1372 \$5080 \$4037 NWELL PWELL BULK MUX2_X1
X$8243 \$7157 \$1372 \$6827 \$7535 NWELL PWELL BULK MUX2_X1
X$8245 \$5808 \$1372 \$6460 \$5921 NWELL PWELL BULK MUX2_X1
X$8248 \$2402 \$1372 \$2403 \$1877 NWELL PWELL BULK MUX2_X1
X$8250 \$1871 \$1372 \$2160 \$2798 NWELL PWELL BULK MUX2_X1
X$8252 \$3401 \$1372 \$3271 \$2407 NWELL PWELL BULK MUX2_X1
X$8254 \$4031 \$1372 \$4032 \$2408 NWELL PWELL BULK MUX2_X1
X$8256 \$23258 \$1372 \$23965 \$23260 NWELL PWELL BULK MUX2_X1
X$8259 \$20097 \$1372 NWELL PWELL BULK BUF_X16
X$8262 \$27485 \$1372 \$27874 \$28234 NWELL PWELL BULK MUX2_X1
X$8265 \$6823 \$1372 \$6446 \$6099 NWELL PWELL BULK MUX2_X1
X$8295 \$1873 \$1377 \$2147 \$1374 NWELL PWELL BULK AOI21_X1
X$8303 \$2147 \$1375 \$1873 NWELL PWELL BULK NOR2_X1
X$8306 \$10343 \$2782 \$10344 \$1376 NWELL PWELL BULK MUX2_X1
X$8311 \$3231 \$2892 \$3541 \$1377 NWELL PWELL BULK AOI21_X2
X$8313 \$3434 \$1377 \$3085 \$3079 NWELL PWELL BULK AOI21_X1
X$8315 \$2880 \$1377 \$2900 \$2789 NWELL PWELL BULK OAI21_X1
X$8336 \$20117 \$17136 \$20118 \$1382 NWELL PWELL BULK MUX2_X1
X$8348 \$2407 \$2414 \$2408 \$1385 NWELL PWELL BULK MUX2_X1
X$8362 \$1396 \$1400 \$2426 \$2599 NWELL PWELL BULK MUX2_X1
X$8366 \$1834 \$2708 \$2366 \$1396 NWELL PWELL BULK MUX2_X2
X$8381 \$15349 \$1400 \$16249 \$16087 NWELL PWELL BULK MUX2_X1
X$8384 \$17808 \$1400 \$17980 \$18207 NWELL PWELL BULK MUX2_X1
X$8387 \$11769 \$1400 \$13346 \$13835 NWELL PWELL BULK MUX2_X1
X$8392 \$19486 \$1400 \$21009 \$21555 NWELL PWELL BULK MUX2_X1
X$8394 \$4018 \$1400 \$4745 \$4746 NWELL PWELL BULK MUX2_X1
X$8397 \$2912 \$1400 \$3279 \$3013 NWELL PWELL BULK MUX2_X1
X$8401 \$18369 \$1400 \$18795 \$18981 NWELL PWELL BULK MUX2_X1
X$8403 \$6666 \$1400 \$7163 \$7486 NWELL PWELL BULK MUX2_X1
X$8408 \$16257 \$1400 \$17233 \$17610 NWELL PWELL BULK MUX2_X1
X$8410 \$16697 \$1400 \$17236 \$17477 NWELL PWELL BULK MUX2_X1
X$8412 \$4402 \$1400 \$3664 \$4053 NWELL PWELL BULK MUX2_X1
X$8414 \$14181 \$1400 \$15036 \$15355 NWELL PWELL BULK MUX2_X1
X$8417 \$14189 \$1400 \$15039 \$15357 NWELL PWELL BULK MUX2_X1
X$8420 \$13832 \$1400 \$14490 \$14182 NWELL PWELL BULK MUX2_X1
X$8423 \$2916 \$1400 \$2989 \$2917 NWELL PWELL BULK MUX2_X1
X$8426 \$23930 \$1400 \$23933 \$24695 NWELL PWELL BULK MUX2_X1
X$8429 \$23276 \$23911 \$22338 \$1400 NWELL PWELL BULK NAND3_X4
X$8432 \$23586 \$1400 \$23808 \$23958 NWELL PWELL BULK MUX2_X1
X$8437 \$11032 \$1400 \$11247 \$11590 NWELL PWELL BULK MUX2_X1
X$8439 \$19137 \$1400 \$19138 \$19896 NWELL PWELL BULK MUX2_X1
X$8442 \$21872 \$1400 \$21871 \$22028 NWELL PWELL BULK MUX2_X1
X$8444 \$23797 \$1400 \$23802 \$24524 NWELL PWELL BULK MUX2_X1
X$8446 \$11424 \$1400 \$11537 \$11770 NWELL PWELL BULK MUX2_X1
X$8449 \$11321 \$1400 \$12551 \$11427 NWELL PWELL BULK MUX2_X1
X$8452 \$6669 \$1400 \$6837 \$7458 NWELL PWELL BULK MUX2_X1
X$8454 \$9124 \$1400 \$8757 \$8977 NWELL PWELL BULK MUX2_X1
X$8456 \$7408 \$1400 \$7641 \$7740 NWELL PWELL BULK MUX2_X1
X$8458 \$6201 \$1400 \$6116 \$6213 NWELL PWELL BULK MUX2_X1
X$8460 \$5032 \$1400 \$5093 \$5583 NWELL PWELL BULK MUX2_X1
X$8462 \$12690 \$1400 \$12817 \$12818 NWELL PWELL BULK MUX2_X1
X$8464 \$13827 \$1400 \$14485 \$14947 NWELL PWELL BULK MUX2_X1
X$8466 \$9728 \$1400 \$10163 \$9748 NWELL PWELL BULK MUX2_X1
X$8468 \$9745 \$1400 \$10865 \$11261 NWELL PWELL BULK MUX2_X1
X$8470 \$17231 \$1400 \$18410 \$18588 NWELL PWELL BULK MUX2_X1
X$8472 \$19735 \$1400 \$20115 \$20596 NWELL PWELL BULK MUX2_X1
X$8474 \$20123 \$1400 \$20612 \$20619 NWELL PWELL BULK MUX2_X1
X$8476 \$18404 \$1400 \$18406 \$18608 NWELL PWELL BULK MUX2_X1
X$8478 \$20602 \$1400 \$20590 \$20725 NWELL PWELL BULK MUX2_X1
X$8481 \$2432 \$1400 \$2434 \$2564 NWELL PWELL BULK MUX2_X1
X$8485 \$10352 \$1400 \$10356 \$10034 NWELL PWELL BULK MUX2_X1
X$8487 \$8253 \$1400 \$7935 \$8411 NWELL PWELL BULK MUX2_X1
X$8489 \$6734 \$1400 \$6845 \$7178 NWELL PWELL BULK MUX2_X1
X$8492 \$8238 \$1400 \$8414 \$7940 NWELL PWELL BULK MUX2_X1
X$8494 \$5082 \$1400 \$5263 \$5636 NWELL PWELL BULK MUX2_X1
X$8496 \$22324 \$1400 \$22325 \$22936 NWELL PWELL BULK MUX2_X1
X$8498 \$22942 \$1400 \$23529 \$22335 NWELL PWELL BULK MUX2_X1
X$8501 \$20726 \$1400 \$21013 \$21012 NWELL PWELL BULK MUX2_X1
X$8585 \$3290 \$1411 NWELL PWELL BULK INV_X1
X$8597 \$1885 \$2545 \$1417 NWELL PWELL BULK NAND2_X1
X$8600 \$3324 \$3293 \$3327 \$1420 NWELL PWELL BULK DFF_X1
X$8602 \$I178078 \$3290 \$3665 \$1420 NWELL PWELL BULK DFF_X1
X$8605 \$5833 \$6168 \$5831 \$1420 NWELL PWELL BULK DFF_X1
X$8607 \$I176211 \$5830 \$6556 \$1420 NWELL PWELL BULK DFF_X1
X$8609 \$I176206 \$6855 \$6906 \$1420 NWELL PWELL BULK DFF_X1
X$8612 \$I175482 \$6857 \$6858 \$1420 NWELL PWELL BULK DFF_X1
X$8615 \$5857 \$1420 \$I245627 \$6123 NWELL PWELL BULK DFF_X2
X$8617 \$I177673 \$5829 \$6176 \$1420 NWELL PWELL BULK DFF_X1
X$8620 \$5521 \$5534 \$5529 \$1420 NWELL PWELL BULK DFF_X1
X$8623 \$1920 \$1913 \$1922 \$1420 NWELL PWELL BULK DFF_X1
X$8625 \$2447 \$2510 \$2518 \$1420 NWELL PWELL BULK DFF_X1
X$8627 \$2531 \$2524 \$2527 \$1420 NWELL PWELL BULK DFF_X1
X$8630 \$1918 \$2461 \$1422 \$1420 NWELL PWELL BULK DFF_X1
X$8632 \$1421 \$2484 \$2492 \$1420 NWELL PWELL BULK DFF_X1
X$8634 \$2936 \$2939 \$2457 \$1420 NWELL PWELL BULK DFF_X1
X$8636 \$1423 \$2460 \$2462 \$1420 NWELL PWELL BULK DFF_X1
X$8639 \$4434 \$4084 \$3670 \$1420 NWELL PWELL BULK DFF_X1
X$8641 \$2926 \$3318 \$3297 \$1420 NWELL PWELL BULK DFF_X1
X$8644 \$3713 \$3296 \$3716 \$1420 NWELL PWELL BULK DFF_X1
X$8647 \$2952 \$2955 \$2957 \$1420 NWELL PWELL BULK DFF_X1
X$8649 \$2938 \$3305 \$3306 \$1420 NWELL PWELL BULK DFF_X1
X$8652 \$5120 \$5541 \$5550 \$1420 NWELL PWELL BULK DFF_X1
X$8654 \$I177167 \$4093 \$4096 \$1420 NWELL PWELL BULK DFF_X1
X$8656 \$I177168 \$4450 \$4452 \$1420 NWELL PWELL BULK DFF_X1
X$8658 \$4063 \$4071 \$3673 \$1420 NWELL PWELL BULK DFF_X1
X$8660 \$I177172 \$4771 \$4770 \$1420 NWELL PWELL BULK DFF_X1
X$8663 \$5158 \$1420 \$I245701 \$4791 NWELL PWELL BULK DFF_X2
X$8666 \$4418 \$1420 NWELL PWELL BULK BUF_X4
X$8669 \$I176162 \$4414 \$4780 \$1420 NWELL PWELL BULK DFF_X1
X$8672 \$5116 \$5103 \$5119 \$1420 NWELL PWELL BULK DFF_X1
X$8674 \$4424 \$4062 \$4430 \$1420 NWELL PWELL BULK DFF_X1
X$8702 \$1920 \$1914 \$1421 \$1915 NWELL PWELL BULK MUX2_X1
X$8707 \$1918 \$1914 \$1423 \$1916 NWELL PWELL BULK MUX2_X1
X$8716 \$13756 \$10084 \$14388 \$1431 NWELL PWELL BULK MUX2_X1
X$8735 \$4093 \$2963 \$1452 \$4096 NWELL PWELL BULK MUX2_X1
X$8738 \$1452 \$2450 \$4450 \$4452 NWELL PWELL BULK MUX2_X1
X$8741 \$1452 \$1912 \$4414 \$4780 NWELL PWELL BULK MUX2_X1
X$8743 \$1452 \$2925 \$4771 \$4770 NWELL PWELL BULK MUX2_X1
X$8754 \$3699 \$1463 \$3701 \$3170 NWELL PWELL BULK OAI21_X2
X$8788 \$9347 \$2301 \$1524 \$9487 NWELL PWELL BULK MUX2_X1
X$8791 \$9694 \$1777 \$1524 \$10100 NWELL PWELL BULK MUX2_X1
X$8812 \$22326 \$17136 \$22011 \$1571 NWELL PWELL BULK MUX2_X1
X$8829 \$7325 \$3964 \$7783 \$1604 NWELL PWELL BULK MUX2_X1
X$8838 \$14133 \$11378 \$1606 \$14414 NWELL PWELL BULK MUX2_X1
X$8841 \$16190 \$7143 \$1606 \$16487 NWELL PWELL BULK MUX2_X1
X$8850 \$18620 \$17136 \$18400 \$1611 NWELL PWELL BULK MUX2_X1
X$8869 \$18615 \$2348 \$1643 \$18356 NWELL PWELL BULK MUX2_X1
X$8872 \$18756 \$18371 \$1643 \$19004 NWELL PWELL BULK MUX2_X1
X$8901 \$9709 \$2348 \$1679 \$9582 NWELL PWELL BULK MUX2_X1
X$8914 \$12939 \$9707 \$1693 \$13713 NWELL PWELL BULK MUX2_X1
X$8916 \$12041 \$1849 \$1693 \$11938 NWELL PWELL BULK MUX2_X1
X$8935 \$15860 \$9707 \$1698 \$15861 NWELL PWELL BULK MUX2_X1
X$8937 \$15328 \$1849 \$1698 \$15666 NWELL PWELL BULK MUX2_X1
X$8961 \$14465 \$3964 \$14467 \$1722 NWELL PWELL BULK MUX2_X1
X$8988 \$3895 \$1849 \$1737 \$4285 NWELL PWELL BULK MUX2_X1
X$9000 \$16668 \$17204 \$1749 \$16223 NWELL PWELL BULK MUX2_X1
X$9003 \$18280 \$18371 \$1749 \$17953 NWELL PWELL BULK MUX2_X1
X$9015 \$10328 \$3964 \$9732 \$1760 NWELL PWELL BULK MUX2_X1
X$9033 \$6808 \$1849 \$1770 \$6811 NWELL PWELL BULK MUX2_X1
X$9047 \$2487 \$1775 \$2306 \$2312 NWELL PWELL BULK MUX2_X2
X$9051 \$7091 \$1777 \$1987 \$7696 NWELL PWELL BULK MUX2_X1
X$9053 \$4789 \$1777 \$2558 \$5135 NWELL PWELL BULK MUX2_X1
X$9057 \$19613 \$1777 \$18748 \$18961 NWELL PWELL BULK MUX2_X1
X$9061 \$18179 \$1777 \$2033 \$17778 NWELL PWELL BULK MUX2_X1
X$9066 \$12921 \$1777 \$2328 \$13159 NWELL PWELL BULK MUX2_X1
X$9068 \$12915 \$1777 \$2007 \$13149 NWELL PWELL BULK MUX2_X1
X$9072 \$13779 \$1777 \$2030 \$13778 NWELL PWELL BULK MUX2_X1
X$9075 \$1777 \$20336 NWELL PWELL BULK BUF_X8
X$9078 \$6890 \$1777 \$2027 \$6889 NWELL PWELL BULK MUX2_X1
X$9080 \$10971 \$1777 \$2025 \$10808 NWELL PWELL BULK MUX2_X1
X$9083 \$8695 \$1777 \$2320 \$8826 NWELL PWELL BULK MUX2_X1
X$9085 \$17569 \$1777 \$2074 \$18186 NWELL PWELL BULK MUX2_X1
X$9088 \$2313 \$1777 NWELL PWELL BULK BUF_X8
X$9094 \$3718 \$1777 \$1783 \$3707 NWELL PWELL BULK MUX2_X1
X$9132 \$3575 \$2301 \$1783 \$3708 NWELL PWELL BULK MUX2_X1
X$9143 \$5730 \$1785 \$2027 \$5853 NWELL PWELL BULK MUX2_X1
X$9145 \$5859 \$1785 \$4996 \$5567 NWELL PWELL BULK MUX2_X1
X$9148 \$5595 \$1785 \$3033 \$5594 NWELL PWELL BULK MUX2_X1
X$9153 \$4324 \$1785 \$1797 \$4476 NWELL PWELL BULK MUX2_X1
X$9156 \$1785 \$2301 NWELL PWELL BULK BUF_X8
X$9158 \$13647 \$1785 \$2328 \$13975 NWELL PWELL BULK MUX2_X1
X$9160 \$9356 \$1785 \$2051 \$9516 NWELL PWELL BULK MUX2_X1
X$9162 \$10288 \$1785 \$2082 \$10471 NWELL PWELL BULK MUX2_X1
X$9165 \$9968 \$1785 \$1796 \$10105 NWELL PWELL BULK MUX2_X1
X$9167 \$7570 \$1785 \$2063 \$7716 NWELL PWELL BULK MUX2_X1
X$9171 \$5885 \$1785 \$4334 \$5734 NWELL PWELL BULK MUX2_X1
X$9173 \$6745 \$1785 \$3589 \$7269 NWELL PWELL BULK MUX2_X1
X$9175 \$4318 \$1785 \$1789 \$4457 NWELL PWELL BULK MUX2_X1
X$9201 \$4469 \$2313 \$1789 \$4806 NWELL PWELL BULK MUX2_X1
X$9213 \$10110 \$2313 \$1796 \$9699 NWELL PWELL BULK MUX2_X1
X$9224 \$4818 \$2313 \$1797 \$4669 NWELL PWELL BULK MUX2_X1
X$9238 \$2578 \$1802 \$1815 \$2604 NWELL PWELL BULK MUX2_X2
X$9240 \$16196 \$17196 \$1815 \$15330 NWELL PWELL BULK MUX2_X2
X$9242 \$17191 \$16644 \$1815 \$13790 NWELL PWELL BULK MUX2_X2
X$9244 \$20677 \$1815 NWELL PWELL BULK BUF_X16
X$9247 \$3511 \$1815 \$3928 \$3225 NWELL PWELL BULK MUX2_X1
X$9249 \$8353 \$8539 \$1815 \$9537 NWELL PWELL BULK MUX2_X2
X$9253 \$9070 \$9071 \$1815 \$9076 NWELL PWELL BULK MUX2_X2
X$9257 \$9974 \$10293 \$1815 \$10521 NWELL PWELL BULK MUX2_X2
X$9259 \$10852 \$10851 \$1815 \$10631 NWELL PWELL BULK MUX2_X2
X$9262 \$5622 \$5434 \$1815 \$5661 NWELL PWELL BULK MUX2_X2
X$9265 \$6586 \$6950 \$1815 \$6752 NWELL PWELL BULK MUX2_X2
X$9269 \$5436 \$5626 \$1815 \$5444 NWELL PWELL BULK MUX2_X2
X$9272 \$9233 \$9236 \$1815 \$9269 NWELL PWELL BULK MUX2_X2
X$9275 \$3497 \$2374 \$1815 \$3158 NWELL PWELL BULK MUX2_X2
X$9279 \$2742 \$1842 \$1815 \$2381 NWELL PWELL BULK MUX2_X2
X$9281 \$8110 \$8116 \$1815 \$8134 NWELL PWELL BULK MUX2_X2
X$9283 \$6067 \$1815 \$7070 \$6416 NWELL PWELL BULK MUX2_X1
X$9285 \$2154 \$2159 \$1815 \$2356 NWELL PWELL BULK MUX2_X2
X$9289 \$2602 \$3594 \$1815 \$3598 NWELL PWELL BULK MUX2_X2
X$9294 \$3804 \$3590 \$1815 \$3898 NWELL PWELL BULK MUX2_X2
X$9297 \$2579 \$2329 \$1815 \$2588 NWELL PWELL BULK MUX2_X2
X$9299 \$5695 \$1815 \$6026 \$5472 NWELL PWELL BULK MUX2_X1
X$9301 \$9260 \$9261 \$1815 \$9288 NWELL PWELL BULK MUX2_X2
X$9303 \$20063 \$20397 \$1815 \$19457 NWELL PWELL BULK MUX2_X2
X$9305 \$17928 \$18217 \$1815 \$16970 NWELL PWELL BULK MUX2_X2
X$9307 \$17932 \$18355 \$1815 \$16216 NWELL PWELL BULK MUX2_X2
X$9310 \$16485 \$15320 \$1815 \$12947 NWELL PWELL BULK MUX2_X2
X$9312 \$14737 \$14990 \$1815 \$14424 NWELL PWELL BULK MUX2_X2
X$9314 \$11943 \$12017 \$1815 \$11736 NWELL PWELL BULK MUX2_X2
X$9316 \$11222 \$11608 \$1815 \$11385 NWELL PWELL BULK MUX2_X2
X$9319 \$12927 \$12928 \$1815 \$13284 NWELL PWELL BULK MUX2_X2
X$9321 \$13996 \$12924 \$1815 \$14155 NWELL PWELL BULK MUX2_X2
X$9323 \$12380 \$12929 \$1815 \$12392 NWELL PWELL BULK MUX2_X2
X$9325 \$7827 \$1815 \$7604 \$7490 NWELL PWELL BULK MUX2_X1
X$9370 \$7877 \$2348 \$1817 \$8142 NWELL PWELL BULK MUX2_X1
X$9378 \$1819 \$1861 \$2650 \$3859 NWELL PWELL BULK MUX2_X1
X$9399 \$6050 \$2348 \$1823 \$6248 NWELL PWELL BULK MUX2_X1
X$9409 \$14427 \$1849 \$1829 \$14786 NWELL PWELL BULK MUX2_X1
X$9413 \$15652 \$9707 \$1829 \$15325 NWELL PWELL BULK MUX2_X1
X$9423 \$3210 \$2367 \$1834 NWELL PWELL BULK NOR2_X1
X$9443 \$2755 \$1861 \$1847 \$2384 NWELL PWELL BULK MUX2_X1
X$9445 \$4362 \$3964 \$4713 \$1848 NWELL PWELL BULK MUX2_X1
X$9465 \$4271 \$1849 \$2205 \$3862 NWELL PWELL BULK MUX2_X1
X$9467 \$6031 \$1849 \$3500 \$5700 NWELL PWELL BULK MUX2_X1
X$9474 \$1849 \$17204 NWELL PWELL BULK BUF_X8
X$9508 \$2387 \$1861 \$1852 \$2389 NWELL PWELL BULK MUX2_X1
X$9510 \$17828 \$3964 \$18238 \$1855 NWELL PWELL BULK MUX2_X1
X$9515 \$12076 \$2782 \$12077 \$1858 NWELL PWELL BULK MUX2_X1
X$9524 \$14768 \$15223 \$1861 \$14431 NWELL PWELL BULK MUX2_X2
X$9526 \$12661 \$13278 \$1861 \$12044 NWELL PWELL BULK MUX2_X2
X$9528 \$14026 \$1861 \$14140 \$14146 NWELL PWELL BULK MUX2_X1
X$9531 \$12402 \$12406 \$1861 \$11746 NWELL PWELL BULK MUX2_X2
X$9534 \$10296 \$9983 \$1861 \$9386 NWELL PWELL BULK MUX2_X2
X$9536 \$11651 \$11653 \$1861 \$10994 NWELL PWELL BULK MUX2_X2
X$9538 \$2864 \$1861 \$3422 \$3606 NWELL PWELL BULK MUX2_X1
X$9542 \$5466 \$1861 \$5717 \$5718 NWELL PWELL BULK MUX2_X1
X$9545 \$8620 \$8622 \$1861 \$8728 NWELL PWELL BULK MUX2_X2
X$9548 \$5256 \$1861 \$5443 \$5445 NWELL PWELL BULK MUX2_X1
X$9550 \$8169 \$1861 \$8177 \$7888 NWELL PWELL BULK MUX2_X1
X$9552 \$8944 \$7893 \$1861 \$8947 NWELL PWELL BULK MUX2_X2
X$9554 \$6261 \$1861 \$6615 \$6317 NWELL PWELL BULK MUX2_X1
X$9557 \$11290 \$10626 \$1861 \$11003 NWELL PWELL BULK MUX2_X2
X$9564 \$7016 \$1861 \$6813 \$6436 NWELL PWELL BULK MUX2_X1
X$9568 \$8293 \$1861 \$8301 \$7613 NWELL PWELL BULK MUX2_X1
X$9571 \$4725 \$1861 \$5415 \$5056 NWELL PWELL BULK MUX2_X1
X$9573 \$3878 \$1861 \$3117 \$3244 NWELL PWELL BULK MUX2_X1
X$9575 \$5776 \$1861 \$6708 \$5664 NWELL PWELL BULK MUX2_X1
X$9577 \$3410 \$1861 \$2860 \$3457 NWELL PWELL BULK MUX2_X1
X$9580 \$9906 \$1861 \$9373 \$9915 NWELL PWELL BULK MUX2_X1
X$9582 \$3445 \$1861 \$3110 \$3210 NWELL PWELL BULK MUX2_X1
X$9584 \$8157 \$1861 \$8160 \$8725 NWELL PWELL BULK MUX2_X1
X$9587 \$15253 \$1861 NWELL PWELL BULK BUF_X16
X$9614 \$6772 \$1861 \$7025 \$6773 NWELL PWELL BULK MUX2_X1
X$9638 \$1868 \$2367 \$4016 NWELL PWELL BULK NOR2_X1
X$9641 \$1868 \$2885 \$4243 NWELL PWELL BULK NOR2_X1
X$9644 \$2884 \$3158 \$3247 \$1868 \$3103 \$4009 \$4213 NWELL PWELL BULK
+ OAI222_X2
X$9650 \$2147 \$1871 \$2161 NWELL PWELL BULK NOR2_X1
X$9658 \$2786 \$2782 \$1877 \$2776 NWELL PWELL BULK MUX2_X1
X$9660 \$4206 \$3964 \$4023 \$1878 NWELL PWELL BULK MUX2_X1
X$9665 \$2406 \$1881 NWELL PWELL BULK INV_X1
X$9668 \$3057 \$2414 \$3775 \$1882 NWELL PWELL BULK MUX2_X1
X$9672 \$19735 \$1885 \$19738 \$20121 NWELL PWELL BULK MUX2_X1
X$9675 \$22324 \$1885 \$22328 \$22715 NWELL PWELL BULK MUX2_X1
X$9677 \$11032 \$1885 \$11041 \$11043 NWELL PWELL BULK MUX2_X1
X$9679 \$17808 \$1885 \$18786 \$19393 NWELL PWELL BULK MUX2_X1
X$9681 \$18369 \$1885 \$18797 \$18796 NWELL PWELL BULK MUX2_X1
X$9684 \$9728 \$1885 \$10349 \$10477 NWELL PWELL BULK MUX2_X1
X$9687 \$2432 \$1885 \$2923 \$2924 NWELL PWELL BULK MUX2_X1
X$9689 \$23930 \$1885 \$23921 \$24238 NWELL PWELL BULK MUX2_X1
X$9691 \$23276 \$23482 \$22338 \$1885 NWELL PWELL BULK NAND3_X4
X$9694 \$2916 \$1885 \$3286 \$3738 NWELL PWELL BULK MUX2_X1
X$9697 \$16697 \$1885 \$16263 \$17092 NWELL PWELL BULK MUX2_X1
X$9700 \$12690 \$1885 \$12096 \$12692 NWELL PWELL BULK MUX2_X1
X$9704 \$2912 \$1885 \$3282 \$3743 NWELL PWELL BULK MUX2_X1
X$9707 \$15349 \$1885 \$15351 \$15889 NWELL PWELL BULK MUX2_X1
X$9711 \$20726 \$1885 \$21018 \$21452 NWELL PWELL BULK MUX2_X1
X$9713 \$6666 \$1885 \$7165 \$7629 NWELL PWELL BULK MUX2_X1
X$9715 \$8253 \$1885 \$8767 \$9235 NWELL PWELL BULK MUX2_X1
X$9718 \$21872 \$1885 \$22756 \$22777 NWELL PWELL BULK MUX2_X1
X$9720 \$23797 \$1885 \$23805 \$24734 NWELL PWELL BULK MUX2_X1
X$9722 \$6734 \$1885 \$6471 \$6929 NWELL PWELL BULK MUX2_X1
X$9725 \$5082 \$1885 \$5627 \$5628 NWELL PWELL BULK MUX2_X1
X$9727 \$11769 \$1885 \$12106 \$13341 NWELL PWELL BULK MUX2_X1
X$9730 \$11424 \$1885 \$12695 \$12970 NWELL PWELL BULK MUX2_X1
X$9733 \$14181 \$1885 \$14004 \$14005 NWELL PWELL BULK MUX2_X1
X$9735 \$20123 \$1885 \$21440 \$22015 NWELL PWELL BULK MUX2_X1
X$9738 \$4402 \$1885 \$4405 \$4473 NWELL PWELL BULK MUX2_X1
X$9740 \$6201 \$1885 \$6477 \$6478 NWELL PWELL BULK MUX2_X1
X$9742 \$5032 \$1885 \$5096 \$5097 NWELL PWELL BULK MUX2_X1
X$9744 \$7408 \$1885 \$7184 \$7734 NWELL PWELL BULK MUX2_X1
X$9746 \$13827 \$1885 \$13486 \$13828 NWELL PWELL BULK MUX2_X1
X$9749 \$17231 \$1885 \$16694 \$16693 NWELL PWELL BULK MUX2_X1
X$9751 \$13832 \$1885 \$15796 \$15798 NWELL PWELL BULK MUX2_X1
X$9753 \$9745 \$1885 \$10345 \$10500 NWELL PWELL BULK MUX2_X1
X$9755 \$16257 \$1885 \$16537 \$16260 NWELL PWELL BULK MUX2_X1
X$9758 \$14189 \$1885 \$14498 \$15771 NWELL PWELL BULK MUX2_X1
X$9760 \$19486 \$1885 \$19489 \$19913 NWELL PWELL BULK MUX2_X1
X$9762 \$18404 \$1885 \$17983 \$18599 NWELL PWELL BULK MUX2_X1
X$9765 \$8238 \$1885 \$9138 \$9873 NWELL PWELL BULK MUX2_X1
X$9768 \$11321 \$1885 \$12974 \$13640 NWELL PWELL BULK MUX2_X1
X$9770 \$10352 \$1885 \$10668 \$11213 NWELL PWELL BULK MUX2_X1
X$9772 \$19137 \$1885 \$19893 \$19139 NWELL PWELL BULK MUX2_X1
X$9775 \$9124 \$1885 \$8961 \$9126 NWELL PWELL BULK MUX2_X1
X$9777 \$6669 \$1885 \$7173 \$7439 NWELL PWELL BULK MUX2_X1
X$9780 \$4018 \$1885 \$4386 \$4564 NWELL PWELL BULK MUX2_X1
X$9787 \$23586 \$1885 \$23572 \$23265 NWELL PWELL BULK MUX2_X1
X$9789 \$20602 \$1885 \$21444 \$22013 NWELL PWELL BULK MUX2_X1
X$9791 \$22942 \$1885 \$23501 \$23506 NWELL PWELL BULK MUX2_X1
X$9896 \$2451 \$1912 \$2484 \$2492 NWELL PWELL BULK MUX2_X1
X$9898 \$6123 \$4791 \$4760 \$1912 NWELL PWELL BULK NAND3_X4
X$9901 \$4406 \$1912 \$6857 \$6858 NWELL PWELL BULK MUX2_X1
X$9908 \$1921 \$1912 \$4419 \$4420 NWELL PWELL BULK MUX2_X1
X$9921 \$2451 \$2450 \$1913 \$1922 NWELL PWELL BULK MUX2_X1
X$9926 \$2531 \$1914 \$2447 \$2448 NWELL PWELL BULK MUX2_X1
X$9928 \$4093 \$1914 \$4771 \$4410 NWELL PWELL BULK MUX2_X1
X$9931 \$2938 \$1914 \$2936 \$2933 NWELL PWELL BULK MUX2_X1
X$9935 \$2952 \$1914 \$2926 \$2495 NWELL PWELL BULK MUX2_X1
X$9938 \$4434 \$1914 \$4424 \$4421 NWELL PWELL BULK MUX2_X1
X$9941 \$5829 \$1914 \$5830 \$5847 NWELL PWELL BULK MUX2_X1
X$9943 \$5521 \$1914 \$5838 \$5106 NWELL PWELL BULK MUX2_X1
X$9946 \$6859 \$1914 \$6536 \$6155 NWELL PWELL BULK MUX2_X1
X$9948 \$6855 \$1914 \$6857 \$6487 NWELL PWELL BULK MUX2_X1
X$9950 \$5833 \$1914 \$6164 \$6156 NWELL PWELL BULK MUX2_X1
X$9952 \$6852 \$6472 \$I245677 \$1914 NWELL PWELL BULK DFF_X2
X$9955 \$3324 \$1914 \$3713 \$3714 NWELL PWELL BULK MUX2_X1
X$9957 \$5120 \$1914 \$5116 \$5112 NWELL PWELL BULK MUX2_X1
X$9959 \$4063 \$1914 \$4067 \$4064 NWELL PWELL BULK MUX2_X1
X$9962 \$4450 \$1914 \$4414 \$5141 NWELL PWELL BULK MUX2_X1
X$9979 \$2495 \$1915 \$2927 \$2931 NWELL PWELL BULK MUX2_X2
X$9982 \$2933 \$1916 \$2927 \$9434 NWELL PWELL BULK MUX2_X2
X$9993 \$4084 \$2963 \$1921 \$3670 NWELL PWELL BULK MUX2_X1
X$9996 \$1921 \$2925 \$4062 \$4430 NWELL PWELL BULK MUX2_X1
X$9998 \$1921 \$2450 \$4071 \$3673 NWELL PWELL BULK MUX2_X1
X$10049 \$7849 \$2301 \$1987 \$7566 NWELL PWELL BULK MUX2_X1
X$10062 \$13936 \$9693 \$13614 \$1991 NWELL PWELL BULK MUX2_X1
X$10069 \$6617 \$4044 \$7177 \$2001 NWELL PWELL BULK MUX2_X1
X$10076 \$19432 \$9693 \$18949 \$2005 NWELL PWELL BULK MUX2_X1
X$10085 \$12914 \$2301 \$2007 \$13137 NWELL PWELL BULK MUX2_X1
X$10109 \$2024 \$2547 \$2306 \$2332 NWELL PWELL BULK MUX2_X2
X$10112 \$10970 \$2301 \$2025 \$11547 NWELL PWELL BULK MUX2_X1
X$10147 \$13777 \$2301 \$2030 \$13966 NWELL PWELL BULK MUX2_X1
X$10161 \$17924 \$2301 \$2033 \$18176 NWELL PWELL BULK MUX2_X1
X$10170 \$15566 \$9693 \$16059 \$2035 NWELL PWELL BULK MUX2_X1
X$10182 \$19743 \$17136 \$19488 \$2040 NWELL PWELL BULK MUX2_X1
X$10194 \$20130 \$17136 \$20575 \$2042 NWELL PWELL BULK MUX2_X1
X$10200 \$9061 \$2313 \$2051 \$9203 NWELL PWELL BULK MUX2_X1
X$10211 \$23260 \$2414 \$24229 \$2052 NWELL PWELL BULK MUX2_X1
X$10216 \$15892 \$2414 \$15893 \$2056 NWELL PWELL BULK MUX2_X1
X$10227 \$7100 \$2313 \$2063 \$7256 NWELL PWELL BULK MUX2_X1
X$10250 \$17181 \$2301 \$2074 \$17396 NWELL PWELL BULK MUX2_X1
X$10267 \$10828 \$2313 \$2082 \$10976 NWELL PWELL BULK MUX2_X1
X$10281 \$22022 \$17136 \$21876 \$2090 NWELL PWELL BULK MUX2_X1
X$10292 \$11380 \$11378 \$2098 \$11600 NWELL PWELL BULK MUX2_X1
X$10306 \$18206 \$11378 \$2101 \$18208 NWELL PWELL BULK MUX2_X1
X$10308 \$16635 \$7143 \$2101 \$17408 NWELL PWELL BULK MUX2_X1
X$10314 \$7535 \$2782 \$7512 \$2104 NWELL PWELL BULK MUX2_X1
X$10324 \$14988 \$11378 \$2105 \$15622 NWELL PWELL BULK MUX2_X1
X$10327 \$14408 \$7143 \$2105 \$14128 NWELL PWELL BULK MUX2_X1
X$10376 \$21868 \$2782 \$21869 \$2113 NWELL PWELL BULK MUX2_X1
X$10386 \$12643 \$11378 \$2119 \$12855 NWELL PWELL BULK MUX2_X1
X$10398 \$25717 \$2782 \$25711 \$2121 NWELL PWELL BULK MUX2_X1
X$10405 \$17515 \$2782 \$17226 \$2124 NWELL PWELL BULK MUX2_X1
X$10422 \$11725 \$7143 \$2134 \$11953 NWELL PWELL BULK MUX2_X1
X$10427 \$13787 \$11378 \$2134 \$14006 NWELL PWELL BULK MUX2_X1
X$10436 \$2147 \$12088 NWELL PWELL BULK BUF_X8
X$10438 \$5984 \$3610 \$2147 \$6083 NWELL PWELL BULK AOI21_X1
X$10441 \$2147 \$5789 \$5984 NWELL PWELL BULK NOR2_X1
X$10444 \$2147 \$6823 \$6987 NWELL PWELL BULK NOR2_X1
X$10446 \$6987 \$5957 \$2147 \$6821 NWELL PWELL BULK AOI21_X1
X$10448 \$8646 \$6787 \$2147 \$8392 NWELL PWELL BULK AOI21_X1
X$10450 \$2147 \$8645 \$8646 NWELL PWELL BULK NOR2_X1
X$10452 \$9742 \$2147 \$9402 \$9646 NWELL PWELL BULK MUX2_X1
X$10454 \$10659 \$2147 \$11904 \$11272 NWELL PWELL BULK MUX2_X1
X$10456 \$2147 \$5065 \$5390 NWELL PWELL BULK NOR2_X1
X$10458 \$4589 \$3645 \$2147 \$4373 NWELL PWELL BULK AOI21_X1
X$10460 \$5390 \$5048 \$2147 \$5062 NWELL PWELL BULK AOI21_X1
X$10462 \$2147 \$4898 \$4589 NWELL PWELL BULK NOR2_X1
X$10464 \$2147 \$7930 \$7929 NWELL PWELL BULK NOR2_X1
X$10466 \$7929 \$8285 \$2147 \$8282 NWELL PWELL BULK AOI21_X1
X$10468 \$2147 \$7157 \$7785 NWELL PWELL BULK NOR2_X1
X$10472 \$5806 \$5482 \$2147 \$5805 NWELL PWELL BULK AOI21_X1
X$10474 \$2147 \$5808 \$5806 NWELL PWELL BULK NOR2_X1
X$10476 \$2147 \$4167 \$4869 NWELL PWELL BULK NOR2_X1
X$10480 \$2161 \$2167 \$2147 \$2807 NWELL PWELL BULK AOI21_X1
X$10486 \$3788 \$3071 \$2147 \$3795 NWELL PWELL BULK AOI21_X1
X$10488 \$2147 \$3401 \$3788 NWELL PWELL BULK NOR2_X1
X$10490 \$3058 \$2147 \$3063 NWELL PWELL BULK OR2_X1
X$10493 \$4869 \$4380 \$2147 \$4381 NWELL PWELL BULK AOI21_X1
X$10496 \$5318 \$5492 \$2147 \$5323 NWELL PWELL BULK AOI21_X1
X$10499 \$2147 \$5075 \$5318 NWELL PWELL BULK NOR2_X1
X$10502 \$2147 \$2411 \$3040 NWELL PWELL BULK NOR2_X1
X$10504 \$3040 \$3044 \$2147 \$2905 NWELL PWELL BULK AOI21_X1
X$10507 \$7785 \$7158 \$2147 \$7552 NWELL PWELL BULK AOI21_X1
X$10541 \$23253 \$3964 \$22930 \$2151 NWELL PWELL BULK MUX2_X1
X$10548 \$2798 \$2782 \$2800 \$2152 NWELL PWELL BULK MUX2_X1
X$10570 \$3981 \$2892 \$4616 \$2167 NWELL PWELL BULK AOI21_X2
X$10572 \$2880 \$2167 \$3813 \$3255 NWELL PWELL BULK OAI21_X1
X$10579 \$3087 \$2167 \$3085 \$3088 NWELL PWELL BULK AOI21_X1
X$10588 \$11384 \$7143 \$2168 \$11618 NWELL PWELL BULK MUX2_X1
X$10592 \$12648 \$11378 \$2168 \$13215 NWELL PWELL BULK MUX2_X1
X$10634 \$16202 \$9707 \$2206 \$16977 NWELL PWELL BULK MUX2_X1
X$10638 \$17937 \$17204 \$2206 \$18247 NWELL PWELL BULK MUX2_X1
X$10676 \$4882 \$2348 \$2237 \$4883 NWELL PWELL BULK MUX2_X1
X$10688 \$4347 \$3964 \$4928 \$2245 NWELL PWELL BULK MUX2_X1
X$10709 \$9013 \$3964 \$9322 \$2271 NWELL PWELL BULK MUX2_X1
X$10716 \$4973 \$3964 \$5029 \$2273 NWELL PWELL BULK MUX2_X1
X$10745 \$2297 \$2838 NWELL PWELL BULK INV_X1
X$10750 \$2298 \$2299 NWELL PWELL BULK INV_X1
X$10758 \$3173 \$3168 \$2299 \$3170 \$2839 NWELL PWELL BULK OAI22_X1
X$10763 \$4989 \$2301 \$2558 \$5536 NWELL PWELL BULK MUX2_X1
X$10766 \$8344 \$2301 \$2320 \$8494 NWELL PWELL BULK MUX2_X1
X$10773 \$2301 \$20046 NWELL PWELL BULK BUF_X8
X$10786 \$16185 \$2301 \$3194 \$16464 NWELL PWELL BULK MUX2_X1
X$10789 \$19281 \$2301 \$18748 \$19286 NWELL PWELL BULK MUX2_X1
X$10827 \$3174 \$3940 \$2306 \$3984 NWELL PWELL BULK MUX2_X2
X$10829 \$5726 \$5727 \$2306 \$5794 NWELL PWELL BULK MUX2_X2
X$10831 \$6895 \$6534 \$2306 \$6781 NWELL PWELL BULK MUX2_X2
X$10833 \$8035 \$7851 \$2306 \$7913 NWELL PWELL BULK MUX2_X2
X$10836 \$5553 \$5425 \$2306 \$5446 NWELL PWELL BULK MUX2_X2
X$10839 \$3739 \$3581 \$2306 \$3251 NWELL PWELL BULK MUX2_X2
X$10841 \$2979 \$2848 \$2306 \$2868 NWELL PWELL BULK MUX2_X2
X$10843 \$2962 \$2965 \$2306 \$3114 NWELL PWELL BULK MUX2_X2
X$10845 \$3946 \$4128 \$2306 \$3885 NWELL PWELL BULK MUX2_X2
X$10847 \$8498 \$7718 \$2306 \$8606 NWELL PWELL BULK MUX2_X2
X$10849 \$7729 \$8513 \$2306 \$8865 NWELL PWELL BULK MUX2_X2
X$10851 \$9523 \$9524 \$2306 \$9527 NWELL PWELL BULK MUX2_X2
X$10853 \$8530 \$8348 \$2306 \$8701 NWELL PWELL BULK MUX2_X2
X$10855 \$6194 \$6043 \$2306 \$6078 NWELL PWELL BULK MUX2_X2
X$10858 \$7111 \$7277 \$2306 \$7282 NWELL PWELL BULK MUX2_X2
X$10860 \$5869 \$5874 \$2306 \$5762 NWELL PWELL BULK MUX2_X2
X$10863 \$6913 \$6911 \$2306 \$6415 NWELL PWELL BULK MUX2_X2
X$10866 \$4481 \$4325 \$2306 \$4009 NWELL PWELL BULK MUX2_X2
X$10868 \$5181 \$5179 \$2306 \$5057 NWELL PWELL BULK MUX2_X2
X$10870 \$3190 \$2321 \$2306 \$2888 NWELL PWELL BULK MUX2_X2
X$10872 \$16633 \$2306 NWELL PWELL BULK BUF_X16
X$10874 \$14706 \$14978 \$2306 \$13282 NWELL PWELL BULK MUX2_X2
X$10876 \$9827 \$9353 \$2306 \$9376 NWELL PWELL BULK MUX2_X2
X$10878 \$10613 \$11204 \$2306 \$10290 NWELL PWELL BULK MUX2_X2
X$10880 \$10483 \$10486 \$2306 \$10489 NWELL PWELL BULK MUX2_X2
X$10882 \$11183 \$11187 \$2306 \$10982 NWELL PWELL BULK MUX2_X2
X$10884 \$13148 \$12628 \$2306 \$13261 NWELL PWELL BULK MUX2_X2
X$10886 \$17565 \$17375 \$2306 \$16208 NWELL PWELL BULK MUX2_X2
X$10889 \$13971 \$12919 \$2306 \$13791 NWELL PWELL BULK MUX2_X2
X$10891 \$15604 \$15310 \$2306 \$16082 NWELL PWELL BULK MUX2_X2
X$10893 \$17782 \$17393 \$2306 \$16666 NWELL PWELL BULK MUX2_X2
X$10897 \$13660 \$13444 \$2306 \$13452 NWELL PWELL BULK MUX2_X2
X$10944 \$2604 \$2883 \$2312 \$2869 \$2392 NWELL PWELL BULK OAI22_X1
X$10946 \$2764 \$2312 \$2873 \$2604 \$3625 NWELL PWELL BULK OAI22_X1
X$10948 \$2884 \$2604 \$3247 \$2389 \$3103 \$2312 \$4275 NWELL PWELL BULK
+ OAI222_X2
X$10963 \$5739 \$2313 \$4334 \$5896 NWELL PWELL BULK MUX2_X1
X$10966 \$5176 \$2313 \$3033 \$5586 NWELL PWELL BULK MUX2_X1
X$10973 \$15190 \$2313 \$3194 \$15607 NWELL PWELL BULK MUX2_X1
X$10982 \$7110 \$2313 \$3589 \$7108 NWELL PWELL BULK MUX2_X1
X$10985 \$4994 \$2313 \$4996 \$5150 NWELL PWELL BULK MUX2_X1
X$11056 \$2869 \$2332 \$2883 \$3225 \$2766 NWELL PWELL BULK OAI22_X1
X$11058 \$2764 \$2332 \$2873 \$3225 \$3541 NWELL PWELL BULK OAI22_X1
X$11060 \$2884 \$3225 \$3247 \$2384 \$3103 \$2332 \$3926 NWELL PWELL BULK
+ OAI222_X2
X$11091 \$10987 \$2348 \$2361 \$11265 NWELL PWELL BULK MUX2_X1
X$11094 \$2349 \$2348 \$2350 \$2652 NWELL PWELL BULK MUX2_X1
X$11101 \$24167 \$24168 \$24450 \$2348 NWELL PWELL BULK NOR3_X4
X$11110 \$7131 \$2348 \$2355 \$7360 NWELL PWELL BULK MUX2_X1
X$11118 \$17204 \$2348 NWELL PWELL BULK BUF_X8
X$11181 \$2884 \$2356 \$3247 \$3210 \$3103 \$2868 \$3871 NWELL PWELL BULK
+ OAI222_X2
X$11183 \$2869 \$2868 \$2883 \$2356 \$2708 NWELL PWELL BULK OAI22_X1
X$11185 \$2764 \$2868 \$2356 \$2873 \$3135 NWELL PWELL BULK OAI22_X2
X$11201 \$11387 \$9707 \$2361 \$11642 NWELL PWELL BULK MUX2_X1
X$11213 \$26181 \$2366 \$26186 \$23586 NWELL PWELL BULK MUX2_X1
X$11215 \$3988 \$4264 \$2366 \$2912 NWELL PWELL BULK MUX2_X2
X$11218 \$25408 \$26228 \$2366 \$23930 NWELL PWELL BULK MUX2_X2
X$11221 \$7612 \$8306 \$2366 \$6201 NWELL PWELL BULK MUX2_X2
X$11227 \$6062 \$6677 \$2366 \$6666 NWELL PWELL BULK MUX2_X2
X$11229 \$6776 \$7139 \$2366 \$7408 NWELL PWELL BULK MUX2_X2
X$11231 \$6411 \$6059 \$2366 \$6669 NWELL PWELL BULK MUX2_X2
X$11233 \$5993 \$5675 \$2366 \$5032 NWELL PWELL BULK MUX2_X2
X$11235 \$6427 \$6353 \$2366 \$6734 NWELL PWELL BULK MUX2_X2
X$11240 \$25965 \$2366 \$26219 \$22324 NWELL PWELL BULK MUX2_X1
X$11242 \$23251 \$2366 \$24309 \$21872 NWELL PWELL BULK MUX2_X1
X$11244 \$6094 \$5795 \$2366 \$4402 NWELL PWELL BULK MUX2_X2
X$11247 \$2895 \$3096 \$2366 \$2432 NWELL PWELL BULK MUX2_X2
X$11249 \$5059 \$2366 \$5671 \$5082 NWELL PWELL BULK MUX2_X1
X$11254 \$3632 \$2366 \$3506 \$2916 NWELL PWELL BULK MUX2_X1
X$11256 \$4016 \$2366 \$3638 \$4018 NWELL PWELL BULK MUX2_X1
X$11258 \$2366 \$20083 \$24129 NWELL PWELL BULK NAND2_X1
X$11260 \$24968 \$2366 \$25386 \$23797 NWELL PWELL BULK MUX2_X1
X$11262 \$27093 \$2366 \$26420 \$26418 \$26882 NWELL PWELL BULK NOR4_X1
X$11264 \$24476 \$24194 \$2366 NWELL PWELL BULK NOR2_X4
X$11272 \$2367 \$2366 \$9383 NWELL PWELL BULK OR2_X4
X$11320 \$7613 \$2367 \$7612 NWELL PWELL BULK NOR2_X1
X$11322 \$6436 \$2367 \$6094 NWELL PWELL BULK NOR2_X1
X$11324 \$2389 \$2367 \$2391 NWELL PWELL BULK NOR2_X1
X$11327 \$2384 \$2367 \$2386 NWELL PWELL BULK NOR2_X1
X$11330 \$5056 \$2367 \$5059 NWELL PWELL BULK NOR2_X1
X$11334 \$3244 \$2367 \$3632 NWELL PWELL BULK NOR2_X1
X$11337 \$5718 \$2367 \$6427 NWELL PWELL BULK NOR2_X1
X$11339 \$20104 \$2367 \$20718 NWELL PWELL BULK NOR2_X1
X$11341 \$2397 \$2367 \$2895 NWELL PWELL BULK NOR2_X1
X$11344 \$20701 \$2367 \$21652 NWELL PWELL BULK NOR2_X1
X$11346 \$22301 \$2367 \$24040 NWELL PWELL BULK NOR2_X1
X$11348 \$3859 \$2367 \$3988 NWELL PWELL BULK NOR2_X1
X$11350 \$3457 \$2367 \$3977 NWELL PWELL BULK NOR2_X1
X$11354 \$3606 \$2367 \$3475 NWELL PWELL BULK NOR2_X1
X$11356 \$22248 \$2367 \$24862 NWELL PWELL BULK NOR2_X1
X$11359 \$23671 \$2367 \$23251 NWELL PWELL BULK NOR2_X1
X$11362 \$19455 \$20083 \$2367 NWELL PWELL BULK OR2_X4
X$11367 \$25409 \$2367 \$25965 NWELL PWELL BULK NOR2_X1
X$11369 \$24954 \$2367 \$9381 \$25927 \$24182 NWELL PWELL BULK OAI22_X4
X$11372 \$2367 \$9381 \$24480 NWELL PWELL BULK NOR2_X1
X$11374 \$24954 \$2367 \$3932 \$26869 NWELL PWELL BULK NOR3_X1
X$11376 \$24982 \$2367 \$25408 NWELL PWELL BULK NOR2_X1
X$11379 \$24986 \$2367 \$26181 NWELL PWELL BULK NOR2_X1
X$11381 \$22830 \$2367 \$25171 NWELL PWELL BULK NOR2_X1
X$11384 \$23238 \$2367 \$24315 NWELL PWELL BULK NOR2_X1
X$11387 \$24875 \$2367 \$24502 NWELL PWELL BULK NOR2_X1
X$11390 \$23540 \$2367 \$24968 NWELL PWELL BULK NOR2_X1
X$11393 \$6317 \$2367 \$6062 NWELL PWELL BULK NOR2_X1
X$11396 \$5445 \$2367 \$5993 NWELL PWELL BULK NOR2_X1
X$11398 \$5664 \$2367 \$6411 NWELL PWELL BULK NOR2_X1
X$11400 \$6773 \$2367 \$6776 NWELL PWELL BULK NOR2_X1
X$11470 \$8215 \$7143 \$2375 \$7601 NWELL PWELL BULK MUX2_X1
X$11482 \$2869 \$2888 \$2883 \$2380 \$3506 NWELL PWELL BULK OAI22_X1
X$11484 \$2884 \$2380 \$3247 \$3244 \$3103 \$2888 \$3858 NWELL PWELL BULK
+ OAI222_X2
X$11486 \$2764 \$2888 \$2873 \$2380 \$3104 NWELL PWELL BULK OAI22_X1
X$11495 \$2764 \$5794 \$2873 \$2381 \$6329 NWELL PWELL BULK OAI22_X1
X$11497 \$2869 \$5794 \$2883 \$2381 \$5795 NWELL PWELL BULK OAI22_X1
X$11499 \$2884 \$2381 \$3247 \$6436 \$3103 \$5794 \$6439 NWELL PWELL BULK
+ OAI222_X2
X$11510 \$2384 \$2885 \$3231 NWELL PWELL BULK NOR2_X1
X$11524 \$2389 \$2885 \$3238 NWELL PWELL BULK NOR2_X1
X$11537 \$2397 \$2885 \$3643 NWELL PWELL BULK NOR2_X1
X$11539 \$2884 \$2588 \$3247 \$2397 \$3103 \$3251 \$3256 NWELL PWELL BULK
+ OAI222_X2
X$11546 \$3085 \$2402 \$3434 NWELL PWELL BULK NOR2_X1
X$11552 \$2880 \$2403 \$2900 NWELL PWELL BULK NAND2_X1
X$11563 \$2880 \$3054 \$2409 NWELL PWELL BULK NAND2_X1
X$11571 \$2880 \$2413 \$3032 NWELL PWELL BULK NAND2_X1
X$11575 \$2699 \$2414 \$2691 \$2415 NWELL PWELL BULK MUX2_X1
X$11585 \$28234 \$27486 \$2414 \$28130 NWELL PWELL BULK MUX2_X2
X$11588 \$7931 \$2414 \$8263 \$2716 NWELL PWELL BULK MUX2_X1
X$11594 \$2414 \$2782 NWELL PWELL BULK BUF_X16
X$11598 \$27130 \$21000 \$I245654 \$2414 NWELL PWELL BULK DFF_X2
X$11650 \$2430 \$8426 \$7652 \$I241583 NWELL PWELL BULK HA_X1
X$11653 \$2430 \$8431 \$8430 NWELL PWELL BULK NAND2_X1
X$11656 \$2430 \$7970 NWELL PWELL BULK INV_X4
X$11659 \$2430 \$9533 \$9437 NWELL PWELL BULK NAND2_X1
X$11661 \$10365 \$10099 \$2430 \$10787 NWELL PWELL BULK NOR3_X4
X$11664 \$10365 \$10772 \$2430 \$11800 NWELL PWELL BULK NOR3_X4
X$11667 \$2430 \$10365 \$10053 NWELL PWELL BULK NAND2_X1
X$11670 \$2430 \$10099 \$10049 NWELL PWELL BULK NAND2_X1
X$11673 \$2430 \$9436 \$9763 NWELL PWELL BULK NAND2_X1
X$11713 \$3714 \$2448 \$2927 \$3668 NWELL PWELL BULK MUX2_X2
X$11721 \$4406 \$2450 \$6855 \$6906 NWELL PWELL BULK MUX2_X1
X$11725 \$6124 \$4791 \$4760 \$2450 NWELL PWELL BULK NAND3_X4
X$11740 \$2955 \$2963 \$2451 \$2957 NWELL PWELL BULK MUX2_X1
X$11744 \$2451 \$2925 \$3318 \$3297 NWELL PWELL BULK MUX2_X1
X$11764 \$10076 \$10084 \$10413 \$2470 NWELL PWELL BULK MUX2_X1
X$11769 \$12246 \$10084 \$12245 \$2473 NWELL PWELL BULK MUX2_X1
X$11780 \$15522 \$9693 \$14393 \$2485 NWELL PWELL BULK MUX2_X1
X$11791 \$16164 \$9693 \$17174 \$2489 NWELL PWELL BULK MUX2_X1
X$11814 \$12907 \$9693 \$13114 \$2507 NWELL PWELL BULK MUX2_X1
X$11827 \$11114 \$9693 \$10962 \$2513 NWELL PWELL BULK MUX2_X1
X$11846 \$9813 \$9693 \$9815 \$2522 NWELL PWELL BULK MUX2_X1
X$11926 \$19098 \$2573 NWELL PWELL BULK INV_X2
X$11945 \$2764 \$3251 \$2873 \$2588 \$3822 NWELL PWELL BULK OAI22_X1
X$11948 \$2869 \$3251 \$2883 \$2588 \$3096 NWELL PWELL BULK OAI22_X1
X$12019 \$2884 \$2628 \$3247 \$3606 \$3103 \$3114 \$3973 NWELL PWELL BULK
+ OAI222_X2
X$12021 \$2869 \$3114 \$2883 \$2628 \$3132 NWELL PWELL BULK OAI22_X1
X$12023 \$2764 \$3114 \$2873 \$2628 \$3480 NWELL PWELL BULK OAI22_X1
X$12079 \$2679 \$10601 NWELL PWELL BULK BUF_X4
X$12084 \$2679 \$9967 NWELL PWELL BULK BUF_X4
X$12087 \$2679 \$10620 NWELL PWELL BULK BUF_X4
X$12092 \$2679 \$6058 NWELL PWELL BULK BUF_X4
X$12095 \$2679 \$4693 NWELL PWELL BULK BUF_X4
X$12098 \$2679 \$14411 NWELL PWELL BULK BUF_X4
X$12100 \$7318 \$2679 NWELL PWELL BULK BUF_X4
X$12103 \$2679 \$7118 NWELL PWELL BULK BUF_X4
X$12107 \$2679 \$5004 NWELL PWELL BULK BUF_X4
X$12112 \$2679 \$13438 NWELL PWELL BULK BUF_X4
X$12135 \$2679 \$10636 NWELL PWELL BULK BUF_X4
X$12143 \$2884 \$2685 \$3247 \$5718 \$3103 \$6078 \$6802 NWELL PWELL BULK
+ OAI222_X2
X$12145 \$2764 \$6078 \$2873 \$2685 \$6013 NWELL PWELL BULK OAI22_X1
X$12147 \$2869 \$6078 \$2883 \$2685 \$6353 NWELL PWELL BULK OAI22_X1
X$12191 \$2880 \$3044 \$3032 \$2714 NWELL PWELL BULK OAI21_X1
X$12213 \$12953 \$3964 \$13327 \$2723 NWELL PWELL BULK MUX2_X1
X$12224 \$14316 \$3964 \$14082 \$2729 NWELL PWELL BULK MUX2_X1
X$12233 \$15716 \$3964 \$15720 \$2730 NWELL PWELL BULK MUX2_X1
X$12254 \$11416 \$2782 \$12594 \$2741 NWELL PWELL BULK MUX2_X1
X$12269 \$16251 \$17136 \$17139 \$2748 NWELL PWELL BULK MUX2_X1
X$12296 \$14454 \$3964 \$14170 \$2762 NWELL PWELL BULK MUX2_X1
X$12303 \$23228 \$22755 \$2764 NWELL PWELL BULK NAND2_X4
X$12306 \$2764 \$5057 \$2873 \$5472 \$5965 NWELL PWELL BULK OAI22_X1
X$12309 \$2764 \$7913 \$2873 \$7490 \$8650 NWELL PWELL BULK OAI22_X1
X$12313 \$2764 \$4009 \$2873 \$3158 \$4919 NWELL PWELL BULK OAI22_X1
X$12320 \$2873 \$21666 \$2764 \$20839 \$20976 NWELL PWELL BULK OAI22_X1
X$12324 \$2764 \$3984 \$2873 \$3898 \$3613 NWELL PWELL BULK OAI22_X1
X$12326 \$2764 \$3885 \$2873 \$3598 \$4616 NWELL PWELL BULK OAI22_X1
X$12329 \$2873 \$25403 \$2764 \$20829 \$25953 NWELL PWELL BULK OAI22_X1
X$12332 \$2873 \$25957 \$2764 \$22250 \$27021 NWELL PWELL BULK OAI22_X1
X$12335 \$2764 \$26200 \$2873 \$26467 \$27022 NWELL PWELL BULK OAI22_X1
X$12338 \$2764 \$25415 \$2873 \$25417 \$25747 NWELL PWELL BULK OAI22_X1
X$12340 \$2764 \$23969 \$2873 \$26469 \$26984 NWELL PWELL BULK OAI22_X1
X$12343 \$2873 \$24969 \$2764 \$22527 \$26276 NWELL PWELL BULK OAI22_X1
X$12346 \$2873 \$25390 \$2764 \$23169 \$26445 NWELL PWELL BULK OAI22_X1
X$12348 \$2873 \$24212 \$2764 \$24214 \$23795 NWELL PWELL BULK OAI22_X1
X$12350 \$2764 \$25940 \$2873 \$25972 \$26966 NWELL PWELL BULK OAI22_X1
X$12352 \$2764 \$25384 \$2873 \$26281 \$26279 NWELL PWELL BULK OAI22_X1
X$12354 \$2764 \$5446 \$2873 \$5444 \$6008 NWELL PWELL BULK OAI22_X1
X$12356 \$2764 \$5762 \$2873 \$5661 \$6007 NWELL PWELL BULK OAI22_X1
X$12358 \$2764 \$6415 \$6416 \$2873 \$7421 NWELL PWELL BULK OAI22_X2
X$12361 \$2764 \$6781 \$2873 \$6752 \$6676 NWELL PWELL BULK OAI22_X1
X$12364 \$2873 \$20987 \$2764 \$21418 \$21624 NWELL PWELL BULK OAI22_X1
X$12420 \$6099 \$2782 \$6672 \$2767 NWELL PWELL BULK MUX2_X1
X$12437 \$17961 \$3964 \$18252 \$2779 NWELL PWELL BULK MUX2_X1
X$12444 \$26458 \$27251 \$2782 \$2821 NWELL PWELL BULK MUX2_X2
X$12452 \$14475 \$2782 \$14932 \$2817 NWELL PWELL BULK MUX2_X1
X$12455 \$5068 \$2782 \$4896 \$3259 NWELL PWELL BULK MUX2_X1
X$12459 \$11284 \$2782 \$10889 \$2831 NWELL PWELL BULK MUX2_X1
X$12474 \$18231 \$2782 \$18224 \$2830 NWELL PWELL BULK MUX2_X1
X$12477 \$13825 \$2782 \$14294 \$3263 NWELL PWELL BULK MUX2_X1
X$12482 \$16231 \$2782 \$16585 \$2794 NWELL PWELL BULK MUX2_X1
X$12489 \$13819 \$2782 \$14056 \$2828 NWELL PWELL BULK MUX2_X1
X$12492 \$3805 \$2782 \$4219 \$3810 NWELL PWELL BULK MUX2_X1
X$12496 \$11624 \$2782 \$12071 \$3546 NWELL PWELL BULK MUX2_X1
X$12568 \$10643 \$3964 \$11639 \$2787 NWELL PWELL BULK MUX2_X1
X$12581 \$29502 \$28317 \$28529 \$2792 NWELL PWELL BULK NAND3_X4
X$12601 \$9295 \$3964 \$9113 \$2799 NWELL PWELL BULK MUX2_X1
X$12668 \$15881 \$3964 \$15345 \$2834 NWELL PWELL BULK MUX2_X1
X$12675 \$2937 \$2837 NWELL PWELL BULK INV_X1
X$12677 \$3308 \$3168 \$2837 \$3170 \$3310 NWELL PWELL BULK OAI22_X1
X$12680 \$3931 \$3168 \$2838 \$3170 \$3307 NWELL PWELL BULK OAI22_X1
X$12725 \$19455 \$19709 \$2869 NWELL PWELL BULK NAND2_X4
X$12728 \$2869 \$5057 \$2883 \$5472 \$5671 NWELL PWELL BULK OAI22_X1
X$12732 \$2869 \$7913 \$2883 \$7490 \$8306 NWELL PWELL BULK OAI22_X1
X$12738 \$2869 \$4009 \$2883 \$3158 \$3638 NWELL PWELL BULK OAI22_X1
X$12744 \$21666 \$2883 \$20839 \$2869 \$20979 NWELL PWELL BULK OAI22_X1
X$12749 \$24212 \$2883 \$24214 \$2869 \$24511 NWELL PWELL BULK OAI22_X1
X$12751 \$25403 \$2883 \$20829 \$2869 \$23793 NWELL PWELL BULK OAI22_X1
X$12753 \$2869 \$3984 \$2883 \$3898 \$4264 NWELL PWELL BULK OAI22_X1
X$12757 \$2869 \$3885 \$2883 \$3598 \$3894 NWELL PWELL BULK OAI22_X1
X$12759 \$25390 \$2883 \$23169 \$2869 \$25204 NWELL PWELL BULK OAI22_X1
X$12761 \$24969 \$2883 \$22527 \$2869 \$24501 NWELL PWELL BULK OAI22_X1
X$12763 \$2869 \$25415 \$2883 \$25417 \$24309 NWELL PWELL BULK OAI22_X1
X$12766 \$2869 \$25940 \$2883 \$25972 \$26186 NWELL PWELL BULK OAI22_X1
X$12769 \$2869 \$26200 \$2883 \$26467 \$26228 NWELL PWELL BULK OAI22_X1
X$12772 \$2869 \$23969 \$2883 \$26469 \$26219 NWELL PWELL BULK OAI22_X1
X$12775 \$2869 \$25384 \$2883 \$26281 \$25386 NWELL PWELL BULK OAI22_X1
X$12777 \$25957 \$2883 \$22250 \$2869 \$24512 NWELL PWELL BULK OAI22_X1
X$12779 \$2869 \$5446 \$2883 \$5444 \$6059 NWELL PWELL BULK OAI22_X1
X$12783 \$2869 \$5762 \$2883 \$5661 \$5675 NWELL PWELL BULK OAI22_X1
X$12785 \$2869 \$6415 \$2883 \$6416 \$6677 NWELL PWELL BULK OAI22_X1
X$12787 \$2869 \$6781 \$2883 \$6752 \$7139 NWELL PWELL BULK OAI22_X1
X$12791 \$20987 \$2883 \$21418 \$2869 \$20716 NWELL PWELL BULK OAI22_X1
X$12852 \$24493 \$23783 \$2873 NWELL PWELL BULK NAND2_X4
X$12946 \$11763 \$2880 \$12093 \$13405 NWELL PWELL BULK MUX2_X1
X$12949 \$16686 \$2880 \$17140 \$17609 NWELL PWELL BULK MUX2_X1
X$12952 \$27864 \$27860 \$28518 \$2880 NWELL PWELL BULK NAND3_X4
X$12954 \$9402 \$2880 \$10029 \$10508 NWELL PWELL BULK MUX2_X1
X$12956 \$13467 \$2880 \$14048 \$14051 NWELL PWELL BULK MUX2_X1
X$12958 \$12072 \$2880 \$12079 \$12679 NWELL PWELL BULK MUX2_X1
X$12960 \$20990 \$2880 \$23055 \$22926 NWELL PWELL BULK MUX2_X1
X$12962 \$20992 \$2880 \$21217 \$20996 NWELL PWELL BULK MUX2_X1
X$12965 \$9115 \$2880 \$8747 \$9116 NWELL PWELL BULK MUX2_X1
X$12968 \$16245 \$2880 \$16248 \$16572 NWELL PWELL BULK MUX2_X1
X$12970 \$13668 \$2880 \$14482 \$15783 NWELL PWELL BULK MUX2_X1
X$12973 \$19397 \$2880 \$19964 \$18779 NWELL PWELL BULK MUX2_X1
X$12976 \$22298 \$2880 \$21438 \$20997 NWELL PWELL BULK MUX2_X1
X$12978 \$16589 \$2880 \$18393 \$18392 NWELL PWELL BULK MUX2_X1
X$12980 \$15872 \$2880 \$15878 \$16234 NWELL PWELL BULK MUX2_X1
X$12983 \$25975 \$2880 \$26854 \$26482 NWELL PWELL BULK MUX2_X1
X$12986 \$24528 \$2880 \$24529 \$24723 NWELL PWELL BULK MUX2_X1
X$12988 \$2880 \$3610 \$5470 \$5468 NWELL PWELL BULK OAI21_X1
X$12991 \$2880 \$5787 \$5470 NWELL PWELL BULK NAND2_X1
X$12994 \$10338 \$2880 \$10656 \$10655 NWELL PWELL BULK MUX2_X1
X$12996 \$11904 \$2880 \$11761 \$11891 NWELL PWELL BULK MUX2_X1
X$12999 \$12960 \$2880 \$12962 \$13396 NWELL PWELL BULK MUX2_X1
X$13001 \$2880 \$7618 \$8328 NWELL PWELL BULK NAND2_X1
X$13003 \$2880 \$6787 \$8328 \$7923 NWELL PWELL BULK OAI21_X1
X$13005 \$9396 \$2880 \$9740 \$9917 NWELL PWELL BULK MUX2_X1
X$13008 \$11280 \$2880 \$11609 \$11892 NWELL PWELL BULK MUX2_X1
X$13010 \$2880 \$3545 \$3146 NWELL PWELL BULK NAND2_X1
X$13012 \$2880 \$3620 \$3146 \$3151 NWELL PWELL BULK OAI21_X1
X$13014 \$2880 \$3258 \$3813 NWELL PWELL BULK NAND2_X1
X$13016 \$2880 \$3645 \$4020 \$4601 NWELL PWELL BULK OAI21_X1
X$13018 \$2880 \$4021 \$4020 NWELL PWELL BULK NAND2_X1
X$13021 \$2880 \$4732 \$5070 NWELL PWELL BULK NAND2_X1
X$13024 \$2880 \$5048 \$5070 \$5368 NWELL PWELL BULK OAI21_X1
X$13027 \$2880 \$3624 \$4002 \$4963 NWELL PWELL BULK OAI21_X1
X$13029 \$2880 \$6070 \$6799 \$7467 NWELL PWELL BULK OAI21_X1
X$13032 \$2880 \$6800 \$6799 NWELL PWELL BULK NAND2_X1
X$13035 \$2880 \$4719 \$4002 NWELL PWELL BULK NAND2_X1
X$13037 \$17221 \$2880 \$17976 \$18784 NWELL PWELL BULK MUX2_X1
X$13039 \$10016 \$2880 \$10021 \$10020 NWELL PWELL BULK MUX2_X1
X$13041 \$11021 \$2880 \$13365 \$13473 NWELL PWELL BULK MUX2_X1
X$13044 \$19729 \$2880 \$19623 \$19626 NWELL PWELL BULK MUX2_X1
X$13046 \$14468 \$2880 \$14478 \$15777 NWELL PWELL BULK MUX2_X1
X$13049 \$17970 \$2880 \$18226 \$18388 NWELL PWELL BULK MUX2_X1
X$13051 \$2880 \$7758 \$7627 NWELL PWELL BULK NAND2_X1
X$13053 \$2880 \$7158 \$7627 \$7628 NWELL PWELL BULK OAI21_X1
X$13055 \$2880 \$8766 \$9129 NWELL PWELL BULK NAND2_X1
X$13058 \$2880 \$8285 \$9129 \$9128 NWELL PWELL BULK OAI21_X1
X$13061 \$2880 \$6105 \$6253 NWELL PWELL BULK NAND2_X1
X$13064 \$2880 \$5080 \$5294 NWELL PWELL BULK NAND2_X1
X$13066 \$2880 \$5482 \$6236 \$6106 NWELL PWELL BULK OAI21_X1
X$13069 \$2880 \$6107 \$6236 NWELL PWELL BULK NAND2_X1
X$13071 \$2880 \$4380 \$5294 \$5078 NWELL PWELL BULK OAI21_X1
X$13073 \$2880 \$5957 \$6451 \$6978 NWELL PWELL BULK OAI21_X1
X$13075 \$2880 \$6455 \$6451 NWELL PWELL BULK NAND2_X1
X$13077 \$2880 \$5492 \$6253 \$5951 NWELL PWELL BULK OAI21_X1
X$13083 \$2880 \$3071 \$4028 \$4027 NWELL PWELL BULK OAI21_X1
X$13085 \$2880 \$4032 \$4028 NWELL PWELL BULK NAND2_X1
X$13093 \$26447 \$2880 \$28400 \$27850 NWELL PWELL BULK MUX2_X1
X$13095 \$26452 \$2880 \$28412 \$27854 NWELL PWELL BULK MUX2_X1
X$13097 \$26485 \$2880 \$27134 \$27133 NWELL PWELL BULK MUX2_X1
X$13099 \$23806 \$2880 \$25143 \$24711 NWELL PWELL BULK MUX2_X1
X$13101 \$24976 \$2880 \$24506 \$24851 NWELL PWELL BULK MUX2_X1
X$13103 \$27230 \$2880 \$26925 \$27567 NWELL PWELL BULK MUX2_X1
X$13105 \$24990 \$2880 \$25420 \$25419 NWELL PWELL BULK MUX2_X1
X$13211 \$3622 \$3620 \$3623 \$2881 NWELL PWELL BULK AOI21_X1
X$13247 \$19455 \$19709 \$2883 NWELL PWELL BULK OR2_X4
X$13318 \$28507 \$27824 \$27091 \$2884 NWELL PWELL BULK OR3_X4
X$13323 \$2884 \$7490 \$3247 \$7613 \$3103 \$7913 \$8330 NWELL PWELL BULK
+ OAI222_X2
X$13327 \$2884 \$3247 \$10350 NWELL PWELL BULK NAND2_X1
X$13335 \$2884 \$5472 \$3247 \$5056 \$3103 \$5057 \$5230 NWELL PWELL BULK
+ OAI222_X2
X$13341 \$3247 \$24875 \$24969 \$2884 \$3103 \$22527 \$27450 NWELL PWELL BULK
+ OAI222_X2
X$13344 \$3247 \$22248 \$25390 \$2884 \$3103 \$23169 \$28371 NWELL PWELL BULK
+ OAI222_X2
X$13346 \$3247 \$20701 \$21666 \$2884 \$3103 \$20839 \$28776 NWELL PWELL BULK
+ OAI222_X2
X$13348 \$2884 \$3598 \$3247 \$3457 \$3103 \$3885 \$4348 NWELL PWELL BULK
+ OAI222_X2
X$13352 \$2884 \$6752 \$3247 \$6773 \$3103 \$6781 \$7123 NWELL PWELL BULK
+ OAI222_X2
X$13355 \$2884 \$5661 \$3247 \$5445 \$3103 \$5762 \$5748 NWELL PWELL BULK
+ OAI222_X2
X$13357 \$2884 \$5444 \$3247 \$5664 \$3103 \$5446 \$4680 NWELL PWELL BULK
+ OAI222_X2
X$13359 \$2884 \$3898 \$3247 \$3859 \$3103 \$3984 \$4357 NWELL PWELL BULK
+ OAI222_X2
X$13362 \$3247 \$22301 \$25403 \$2884 \$3103 \$20829 \$25439 NWELL PWELL BULK
+ OAI222_X2
X$13366 \$3247 \$23238 \$24212 \$2884 \$3103 \$24214 \$26825 NWELL PWELL BULK
+ OAI222_X2
X$13368 \$21311 \$3103 \$2884 \$20970 \$19714 \$3247 \$19463 NWELL PWELL BULK
+ OAI222_X2
X$13372 \$3247 \$22830 \$25957 \$2884 \$3103 \$22250 \$28783 NWELL PWELL BULK
+ OAI222_X2
X$13374 \$2884 \$26467 \$3247 \$24982 \$3103 \$26200 \$27595 NWELL PWELL BULK
+ OAI222_X2
X$13376 \$2884 \$25417 \$3247 \$23671 \$3103 \$25415 \$27137 NWELL PWELL BULK
+ OAI222_X2
X$13379 \$2884 \$26469 \$3247 \$25409 \$3103 \$23969 \$27862 NWELL PWELL BULK
+ OAI222_X2
X$13381 \$2884 \$25972 \$3247 \$24986 \$3103 \$25940 \$26487 NWELL PWELL BULK
+ OAI222_X2
X$13383 \$2884 \$26281 \$3247 \$23540 \$3103 \$25384 \$27101 NWELL PWELL BULK
+ OAI222_X2
X$13385 \$3247 \$20104 \$20987 \$2884 \$3103 \$21418 \$21436 NWELL PWELL BULK
+ OAI222_X2
X$13388 \$2884 \$6416 \$3247 \$6317 \$3103 \$6415 \$6758 NWELL PWELL BULK
+ OAI222_X2
X$13441 \$9718 \$14438 \$2885 \$13668 \$15257 NWELL PWELL BULK OAI22_X4
X$13443 \$20084 \$19712 \$2885 \$19729 \$19714 NWELL PWELL BULK OAI22_X4
X$13445 \$9718 \$17495 \$2885 \$17221 \$17949 NWELL PWELL BULK OAI22_X4
X$13447 \$9718 \$17012 \$2885 \$16245 \$16663 NWELL PWELL BULK OAI22_X4
X$13450 \$23783 \$20084 \$23228 \$2885 NWELL PWELL BULK NAND3_X4
X$13454 \$9718 \$11665 \$2885 \$11904 \$11741 NWELL PWELL BULK OAI22_X4
X$13457 \$9718 \$10900 \$2885 \$11000 \$11021 NWELL PWELL BULK OAI22_X2
X$13459 \$9718 \$13462 \$2885 \$12960 \$13464 NWELL PWELL BULK OAI22_X4
X$13461 \$9718 \$12666 \$2885 \$11763 \$13309 NWELL PWELL BULK OAI22_X4
X$13463 \$9718 \$10927 \$2885 \$11011 \$11280 NWELL PWELL BULK OAI22_X2
X$13465 \$9718 \$9947 \$2885 \$9402 \$9729 NWELL PWELL BULK OAI22_X4
X$13468 \$9718 \$9922 \$2885 \$9304 \$9115 NWELL PWELL BULK OAI22_X2
X$13470 \$9718 \$10540 \$2885 \$10003 \$10338 NWELL PWELL BULK OAI22_X2
X$13472 \$9718 \$10215 \$2885 \$9724 \$9396 NWELL PWELL BULK OAI22_X2
X$13474 \$6436 \$2885 \$6089 NWELL PWELL BULK NOR2_X1
X$13476 \$7613 \$2885 \$7920 NWELL PWELL BULK NOR2_X1
X$13481 \$3244 \$2885 \$2891 NWELL PWELL BULK NOR2_X1
X$13483 \$5056 \$2885 \$5684 NWELL PWELL BULK NOR2_X1
X$13485 \$5718 \$2885 \$5783 NWELL PWELL BULK NOR2_X1
X$13490 \$2885 \$20701 \$21279 \$19397 NWELL PWELL BULK OAI21_X1
X$13492 \$9718 \$14334 \$2885 \$14156 \$13467 NWELL PWELL BULK OAI22_X2
X$13494 \$9718 \$12456 \$2885 \$12059 \$12072 NWELL PWELL BULK OAI22_X2
X$13496 \$9718 \$10313 \$2885 \$10246 \$10016 NWELL PWELL BULK OAI22_X2
X$13498 \$3859 \$2885 \$4261 NWELL PWELL BULK NOR2_X1
X$13500 \$2885 \$22301 \$27015 \$25975 NWELL PWELL BULK OAI21_X1
X$13502 \$3457 \$2885 \$3981 NWELL PWELL BULK NOR2_X1
X$13504 \$3606 \$2885 \$3608 NWELL PWELL BULK NOR2_X1
X$13506 \$3210 \$2885 \$3216 NWELL PWELL BULK NOR2_X1
X$13509 \$2885 \$25409 \$27237 \$27230 NWELL PWELL BULK OAI21_X1
X$13511 \$9718 \$16142 \$2885 \$15866 \$15872 NWELL PWELL BULK OAI22_X2
X$13513 \$2885 \$23238 \$23796 \$20990 NWELL PWELL BULK OAI21_X1
X$13515 \$9718 \$15709 \$2885 \$15011 \$14468 NWELL PWELL BULK OAI22_X2
X$13517 \$9718 \$16215 \$2885 \$16222 \$16589 NWELL PWELL BULK OAI22_X2
X$13519 \$9718 \$20489 \$2885 \$19717 \$17970 NWELL PWELL BULK OAI22_X2
X$13521 \$25410 \$2885 \$24982 \$23806 NWELL PWELL BULK OAI21_X2
X$13523 \$26232 \$2885 \$22830 \$24528 NWELL PWELL BULK OAI21_X2
X$13526 \$2885 \$23540 \$25939 \$26452 NWELL PWELL BULK OAI21_X1
X$13529 \$26941 \$2885 \$24986 \$26485 NWELL PWELL BULK OAI21_X2
X$13531 \$2885 \$22248 \$26263 \$24976 NWELL PWELL BULK OAI21_X1
X$13533 \$2885 \$23671 \$26470 \$24990 NWELL PWELL BULK OAI21_X1
X$13535 \$2885 \$24875 \$26441 \$26447 NWELL PWELL BULK OAI21_X1
X$13538 \$5664 \$2885 \$5771 NWELL PWELL BULK NOR2_X1
X$13540 \$5445 \$2885 \$5769 NWELL PWELL BULK NOR2_X1
X$13542 \$6773 \$2885 \$6786 NWELL PWELL BULK NOR2_X1
X$13545 \$6317 \$2885 \$6789 NWELL PWELL BULK NOR2_X1
X$13547 \$2885 \$20104 \$21617 \$20992 NWELL PWELL BULK OAI21_X1
X$13637 \$2891 \$2892 \$3104 \$3071 NWELL PWELL BULK AOI21_X2
X$13639 \$20978 \$2892 NWELL PWELL BULK BUF_X16
X$13645 \$3608 \$2892 \$3480 \$3610 NWELL PWELL BULK AOI21_X2
X$13650 \$7158 \$6789 \$2892 \$7421 NWELL PWELL BULK AOI21_X4
X$13655 \$5771 \$2892 \$6008 \$5048 NWELL PWELL BULK AOI21_X2
X$13657 \$5684 \$2892 \$5965 \$5482 NWELL PWELL BULK AOI21_X2
X$13659 \$6089 \$2892 \$6329 \$5492 NWELL PWELL BULK AOI21_X2
X$13661 \$7920 \$2892 \$8650 \$8285 NWELL PWELL BULK AOI21_X2
X$13663 \$4243 \$2892 \$4919 \$4380 NWELL PWELL BULK AOI21_X2
X$13667 \$5783 \$2892 \$6013 \$5957 NWELL PWELL BULK AOI21_X2
X$13670 \$3238 \$2892 \$3625 \$3624 NWELL PWELL BULK AOI21_X2
X$13672 \$3643 \$2892 \$3822 \$3645 NWELL PWELL BULK AOI21_X2
X$13676 \$3044 \$3216 \$2892 \$3135 NWELL PWELL BULK AOI21_X4
X$13678 \$4261 \$2892 \$3613 \$3620 NWELL PWELL BULK AOI21_X2
X$13680 \$6786 \$2892 \$6676 \$6787 NWELL PWELL BULK AOI21_X2
X$13683 \$5769 \$2892 \$6007 \$6070 NWELL PWELL BULK AOI21_X2
X$13708 \$3085 \$2896 \$3087 NWELL PWELL BULK NOR2_X1
X$13775 \$5098 \$6124 \$4791 \$2925 NWELL PWELL BULK OR3_X4
X$13779 \$4406 \$2925 \$5830 \$6556 NWELL PWELL BULK MUX2_X1
X$13797 \$6156 \$6155 \$2927 \$6525 NWELL PWELL BULK MUX2_X2
X$13799 \$4421 \$4064 \$2927 \$4777 NWELL PWELL BULK MUX2_X2
X$13801 \$5112 \$5106 \$2927 \$5108 NWELL PWELL BULK MUX2_X2
X$13807 \$4410 \$5141 \$2927 \$5139 NWELL PWELL BULK MUX2_X2
X$13811 \$5847 \$6487 \$2927 \$9559 NWELL PWELL BULK MUX2_X2
X$13813 \$7651 \$6472 \$I245635 \$2927 NWELL PWELL BULK DFF_X2
X$13815 \$2927 \$9147 NWELL PWELL BULK INV_X1
X$13817 \$5847 \$2927 \$9756 NWELL PWELL BULK NOR2_X1
X$13827 \$16397 \$16313 \$2931 \$15926 \$17680 \$18042 NWELL PWELL BULK
+ OAI221_X2
X$13831 \$16397 \$15941 \$2931 \$16297 \$15943 \$10062 NWELL PWELL BULK
+ OAI221_X2
X$13833 \$2931 \$18088 NWELL PWELL BULK INV_X1
X$13890 \$5829 \$2963 \$4406 \$6176 NWELL PWELL BULK MUX2_X1
X$13895 \$4791 \$6123 \$5098 \$2963 NWELL PWELL BULK NOR3_X4
X$13989 \$3759 \$3044 \$3655 \$3275 NWELL PWELL BULK AOI21_X1
X$14016 \$3395 \$3054 NWELL PWELL BULK INV_X1
X$14050 \$4191 \$3071 \$3655 \$4026 NWELL PWELL BULK AOI21_X1
X$14066 \$17121 \$3085 \$16245 \$17112 NWELL PWELL BULK MUX2_X1
X$14068 \$12083 \$3085 \$11280 \$12564 NWELL PWELL BULK MUX2_X1
X$14070 \$12086 \$3085 \$11904 \$12688 NWELL PWELL BULK MUX2_X1
X$14072 \$10196 \$3085 \$9402 \$10513 NWELL PWELL BULK MUX2_X1
X$14075 \$10024 \$3085 \$9396 \$10341 NWELL PWELL BULK MUX2_X1
X$14078 \$14480 \$3085 \$13668 \$15026 NWELL PWELL BULK MUX2_X1
X$14081 \$19481 \$3085 \$19729 \$19731 NWELL PWELL BULK MUX2_X1
X$14083 \$17603 \$3085 \$16589 \$17602 NWELL PWELL BULK MUX2_X1
X$14086 \$12686 \$3085 \$12960 \$13389 NWELL PWELL BULK MUX2_X1
X$14088 \$3085 \$7152 \$7538 NWELL PWELL BULK NOR2_X1
X$14091 \$7538 \$6787 \$3085 \$7800 NWELL PWELL BULK AOI21_X1
X$14094 \$13820 \$3085 \$13467 \$14913 NWELL PWELL BULK MUX2_X1
X$14097 \$12542 \$3085 \$12072 \$12959 NWELL PWELL BULK MUX2_X1
X$14100 \$10336 \$3085 \$10338 \$10337 NWELL PWELL BULK MUX2_X1
X$14102 \$3085 \$4729 \$4912 NWELL PWELL BULK NOR2_X1
X$14105 \$4912 \$3645 \$3085 \$4727 NWELL PWELL BULK AOI21_X1
X$14112 \$16691 \$3085 \$16686 \$17145 NWELL PWELL BULK MUX2_X1
X$14114 \$17975 \$3085 \$17221 \$19015 NWELL PWELL BULK MUX2_X1
X$14116 \$14476 \$3085 \$14468 \$15770 NWELL PWELL BULK MUX2_X1
X$14122 \$3085 \$3623 NWELL PWELL BULK BUF_X8
X$14125 \$3655 \$3085 NWELL PWELL BULK BUF_X8
X$14172 \$28763 \$28507 \$3103 NWELL PWELL BULK OR2_X4
X$14194 \$3247 \$3103 \$9121 NWELL PWELL BULK NAND2_X1
X$14203 \$12047 \$3103 \$12048 \$10646 NWELL PWELL BULK OAI21_X1
X$14205 \$14080 \$3103 \$14448 \$14313 NWELL PWELL BULK OAI21_X1
X$14208 \$14074 \$3103 \$14075 \$14163 NWELL PWELL BULK OAI21_X1
X$14211 \$12476 \$3103 \$12454 \$12063 NWELL PWELL BULK OAI21_X1
X$14214 \$10920 \$3103 \$11317 \$10637 NWELL PWELL BULK OAI21_X1
X$14218 \$14047 \$3103 \$13795 \$12957 NWELL PWELL BULK OAI21_X1
X$14220 \$13461 \$3103 \$12940 \$12062 NWELL PWELL BULK OAI21_X1
X$14223 \$10627 \$3103 \$10996 \$10557 NWELL PWELL BULK OAI21_X1
X$14227 \$16138 \$3103 \$16139 \$15865 NWELL PWELL BULK OAI21_X1
X$14231 \$23648 \$23104 \$3103 \$23239 NWELL PWELL BULK OAI21_X2
X$14235 \$17866 \$3103 \$18672 \$17595 NWELL PWELL BULK OAI21_X1
X$14238 \$16210 \$17017 \$3103 \$16218 NWELL PWELL BULK OAI21_X2
X$14242 \$17944 \$3103 \$18279 \$17826 NWELL PWELL BULK OAI21_X1
X$14245 \$14824 \$14825 \$3103 \$14464 NWELL PWELL BULK OAI21_X2
X$14248 \$9600 \$3103 \$9992 \$8734 NWELL PWELL BULK OAI21_X1
X$14250 \$8952 \$3103 \$9082 \$5757 NWELL PWELL BULK OAI21_X1
X$14252 \$8970 \$3103 \$8967 \$7606 NWELL PWELL BULK OAI21_X1
X$14254 \$9631 \$3103 \$9637 \$8730 NWELL PWELL BULK OAI21_X1
X$14256 \$9092 \$3103 \$9324 \$8741 NWELL PWELL BULK OAI21_X1
X$14377 \$3623 \$3141 \$3622 NWELL PWELL BULK NOR2_X1
X$14379 \$3141 \$3997 \$3545 \$3906 NWELL PWELL BULK MUX2_X1
X$14404 \$3680 \$3168 \$4069 \$3170 \$3930 NWELL PWELL BULK OAI22_X1
X$14408 \$3595 \$3168 \$3695 \$3170 \$3572 NWELL PWELL BULK OAI22_X1
X$14412 \$3571 \$3168 \$3688 \$3170 \$3677 NWELL PWELL BULK OAI22_X1
X$14434 \$24448 \$21738 \$24940 \$3173 NWELL PWELL BULK OAI21_X4
X$14437 \$3173 \$26766 \$28179 \$27403 NWELL PWELL BULK OAI21_X1
X$14439 \$3173 \$27319 \$27081 \$27079 \$26400 \$27422 NWELL PWELL BULK
+ OAI221_X2
X$14443 \$3173 \$3595 \$27067 NWELL PWELL BULK NAND2_X1
X$14465 \$11716 \$9693 \$11167 \$3183 NWELL PWELL BULK MUX2_X1
X$14542 \$27665 \$27823 \$27091 \$3247 NWELL PWELL BULK OR3_X4
X$14648 \$3256 \$4398 \$4052 \$4131 NWELL PWELL BULK MUX2_X1
X$14650 \$3256 \$4338 \$4399 \$4511 NWELL PWELL BULK MUX2_X1
X$14655 \$4048 \$4375 \$3256 \$4134 NWELL PWELL BULK MUX2_X1
X$14657 \$4522 \$4537 \$3256 \$4531 NWELL PWELL BULK MUX2_X1
X$14730 \$3290 \$4057 \$4102 NWELL PWELL BULK XNOR2_X1
X$14752 \$27654 \$3308 NWELL PWELL BULK BUF_X2
X$14807 \$3655 \$3383 \$3759 NWELL PWELL BULK NOR2_X1
X$14949 \$3570 \$3688 NWELL PWELL BULK INV_X1
X$14956 \$34273 \$33872 \$33869 \$3571 NWELL PWELL BULK OAI21_X4
X$14959 \$32517 \$25879 \$3571 \$33075 NWELL PWELL BULK OAI21_X1
X$14962 \$3571 \$25879 \$32520 NWELL PWELL BULK AND2_X1
X$14964 \$33444 \$34465 \$3571 \$34769 NWELL PWELL BULK AOI21_X2
X$15004 \$27406 \$26262 \$3595 \$28179 NWELL PWELL BULK OAI21_X1
X$15008 \$28185 \$3595 \$3931 \$27795 NWELL PWELL BULK NAND3_X1
X$15012 \$3595 \$25899 \$26768 NWELL PWELL BULK NOR2_X1
X$15014 \$25897 \$26262 \$25901 \$3595 \$26242 NWELL PWELL BULK OAI22_X1
X$15017 \$25243 \$21317 \$26812 \$3595 NWELL PWELL BULK OAI21_X4
X$15054 \$5994 \$3610 \$3623 \$5784 NWELL PWELL BULK AOI21_X1
X$15074 \$4000 \$3620 \$3999 \$4365 NWELL PWELL BULK AOI21_X1
X$15084 \$24992 \$3623 \$24990 \$24521 NWELL PWELL BULK MUX2_X1
X$15086 \$21867 \$3623 \$22298 \$22050 NWELL PWELL BULK MUX2_X1
X$15088 \$9049 \$3623 \$9115 \$9286 NWELL PWELL BULK MUX2_X1
X$15090 \$10249 \$3623 \$10016 \$10332 NWELL PWELL BULK MUX2_X1
X$15092 \$17072 \$3623 \$15872 \$16232 NWELL PWELL BULK MUX2_X1
X$15094 \$12527 \$3623 \$11021 \$12673 NWELL PWELL BULK MUX2_X1
X$15097 \$3623 \$5786 \$5994 NWELL PWELL BULK NOR2_X1
X$15100 \$5464 \$3624 \$3623 \$5720 NWELL PWELL BULK AOI21_X1
X$15103 \$7068 \$6070 \$3623 \$6797 NWELL PWELL BULK AOI21_X1
X$15105 \$3623 \$6798 \$7068 NWELL PWELL BULK NOR2_X1
X$15111 \$3623 \$5041 \$5464 NWELL PWELL BULK NOR2_X1
X$15113 \$18783 \$3623 \$17970 \$18782 NWELL PWELL BULK MUX2_X1
X$15116 \$3623 \$24504 NWELL PWELL BULK BUF_X8
X$15118 \$23248 \$3623 \$20990 \$23687 NWELL PWELL BULK MUX2_X1
X$15120 \$21224 \$3623 \$20992 \$21227 NWELL PWELL BULK MUX2_X1
X$15151 \$5461 \$3624 \$3999 \$5778 NWELL PWELL BULK AOI21_X1
X$15191 \$3654 \$3655 \$3656 NWELL PWELL BULK OR2_X1
X$15196 \$12091 \$3655 \$11763 \$12585 NWELL PWELL BULK MUX2_X1
X$15199 \$3655 \$5071 \$5488 NWELL PWELL BULK NOR2_X1
X$15202 \$5488 \$5048 \$3655 \$5487 NWELL PWELL BULK AOI21_X1
X$15206 \$3655 \$8311 \$7775 NWELL PWELL BULK NOR2_X1
X$15208 \$7775 \$7158 \$3655 \$7926 NWELL PWELL BULK AOI21_X1
X$15210 \$8763 \$8285 \$3655 \$8945 NWELL PWELL BULK AOI21_X1
X$15213 \$3655 \$8764 \$8763 NWELL PWELL BULK NOR2_X1
X$15216 \$5809 \$5482 \$3655 \$5929 NWELL PWELL BULK AOI21_X1
X$15219 \$3655 \$5497 \$5809 NWELL PWELL BULK NOR2_X1
X$15222 \$3655 \$4742 \$5289 NWELL PWELL BULK NOR2_X1
X$15224 \$5289 \$4380 \$3655 \$4740 NWELL PWELL BULK AOI21_X1
X$15226 \$6100 \$5957 \$3655 \$6278 NWELL PWELL BULK AOI21_X1
X$15229 \$3655 \$6453 \$6100 NWELL PWELL BULK NOR2_X1
X$15232 \$3655 \$5801 \$6103 NWELL PWELL BULK NOR2_X1
X$15234 \$6103 \$5492 \$3655 \$5798 NWELL PWELL BULK AOI21_X1
X$15236 \$3655 \$4031 \$4191 NWELL PWELL BULK NOR2_X1
X$15275 \$4102 \$4056 \$3665 NWELL PWELL BULK NOR2_X1
X$15279 \$16735 \$15941 \$3668 \$16297 \$16862 \$9501 NWELL PWELL BULK OAI221_X2
X$15282 \$3668 \$18106 NWELL PWELL BULK INV_X1
X$15284 \$16735 \$16313 \$3668 \$15926 \$17708 \$16768 NWELL PWELL BULK
+ OAI221_X2
X$15302 \$25879 \$3680 NWELL PWELL BULK BUF_X2
X$15317 \$4407 \$4460 \$3699 \$4465 NWELL PWELL BULK NAND3_X1
X$15319 \$53729 \$53732 \$3699 \$54045 \$52480 NWELL PWELL BULK NAND4_X4
X$15322 \$53723 \$53548 \$3699 \$53722 NWELL PWELL BULK NAND3_X1
X$15325 \$56664 \$3699 \$53579 NWELL PWELL BULK NAND2_X1
X$15329 \$58882 \$3699 \$59752 NWELL PWELL BULK NAND2_X1
X$15332 \$57273 \$3699 \$55804 NWELL PWELL BULK NAND2_X1
X$15334 \$57276 \$3699 \$55708 NWELL PWELL BULK NAND2_X1
X$15338 \$3699 \$54365 \$54965 \$52917 NWELL PWELL BULK OAI21_X2
X$15340 \$54077 \$54536 \$3699 \$52916 NWELL PWELL BULK NAND3_X2
X$15343 \$3699 \$61664 \$61055 \$61838 NWELL PWELL BULK OAI21_X2
X$15345 \$60693 \$3699 \$61835 NWELL PWELL BULK NAND2_X1
X$15347 \$59758 \$59973 \$3699 \$60227 NWELL PWELL BULK OAI21_X1
X$15350 \$3699 \$61536 \$62556 NWELL PWELL BULK AND2_X1
X$15353 \$3699 \$62559 \$62555 NWELL PWELL BULK AND2_X1
X$15355 \$59754 \$3699 \$58878 NWELL PWELL BULK NAND2_X1
X$15357 \$60693 \$59871 \$3699 \$61831 NWELL PWELL BULK NAND3_X1
X$15359 \$3699 \$7201 \$7279 NWELL PWELL BULK AND2_X1
X$15361 \$3699 \$8093 \$8101 NWELL PWELL BULK AND2_X1
X$15363 \$74817 \$74575 \$3699 \$74571 NWELL PWELL BULK NAND3_X1
X$15365 \$3699 \$75318 \$75170 NWELL PWELL BULK AND2_X1
X$15367 \$3699 \$75312 \$75540 NWELL PWELL BULK AND2_X1
X$15369 \$3699 \$8127 \$7651 NWELL PWELL BULK AND2_X1
X$15371 \$8575 \$8140 \$3699 \$7953 NWELL PWELL BULK OAI21_X1
X$15373 \$3699 \$7646 \$7950 NWELL PWELL BULK AND2_X1
X$15375 \$3699 \$35274 \$35591 NWELL PWELL BULK AND2_X1
X$15378 \$3699 \$34356 \$34474 NWELL PWELL BULK AND2_X1
X$15380 \$33076 \$33077 \$3699 \$33785 NWELL PWELL BULK NAND3_X1
X$15383 \$3699 \$35183 \$36386 NWELL PWELL BULK AND2_X1
X$15385 \$3699 \$36112 \$37035 NWELL PWELL BULK AND2_X1
X$15388 \$3699 \$37632 \$37132 NWELL PWELL BULK AND2_X1
X$15390 \$32522 \$32876 \$3699 \$31756 NWELL PWELL BULK OAI21_X1
X$15392 \$32431 \$32128 \$3699 \$32885 NWELL PWELL BULK NAND3_X1
X$15395 \$32125 \$3699 \$31754 NWELL PWELL BULK NAND2_X1
X$15397 \$32519 \$3699 \$32869 NWELL PWELL BULK NAND2_X1
X$15399 \$31002 \$3699 \$31503 NWELL PWELL BULK NAND2_X1
X$15401 \$3699 \$27791 \$29073 NWELL PWELL BULK AND2_X1
X$15404 \$3699 \$28156 \$27400 NWELL PWELL BULK AND2_X1
X$15406 \$3699 \$27062 \$28151 NWELL PWELL BULK AND2_X1
X$15408 \$3699 \$30759 \$31001 \$31004 NWELL PWELL BULK AND3_X1
X$15410 \$3699 \$29128 \$29460 NWELL PWELL BULK AND2_X1
X$15412 \$3699 \$30532 \$30246 NWELL PWELL BULK AND2_X1
X$15415 \$32126 \$32520 \$3699 \$32522 NWELL PWELL BULK NAND3_X2
X$15417 \$31692 \$31276 \$3699 \$31279 NWELL PWELL BULK NAND3_X1
X$15419 \$3699 \$30244 \$30514 NWELL PWELL BULK AND2_X1
X$15421 \$3699 \$30536 \$30181 NWELL PWELL BULK AND2_X1
X$15423 \$31670 \$31762 \$3699 \$32054 NWELL PWELL BULK NAND3_X1
X$15425 \$3699 \$30259 \$31342 NWELL PWELL BULK AND2_X1
X$15428 \$3699 \$30563 \$30254 NWELL PWELL BULK AND2_X1
X$15430 \$3699 \$30053 \$29704 NWELL PWELL BULK AND2_X1
X$15433 \$3699 \$27397 \$26387 NWELL PWELL BULK AND2_X1
X$15435 \$3699 \$27283 \$28145 NWELL PWELL BULK AND2_X1
X$15437 \$3699 \$29965 \$29701 NWELL PWELL BULK AND2_X1
X$15439 \$3699 \$40041 \$40039 NWELL PWELL BULK AND2_X1
X$15441 \$3699 \$39094 \$39747 NWELL PWELL BULK AND2_X1
X$15443 \$43190 \$43193 \$3699 \$42887 NWELL PWELL BULK NAND3_X1
X$15445 \$3699 \$40600 \$40727 NWELL PWELL BULK AND2_X1
X$15447 \$3699 \$41779 \$41165 NWELL PWELL BULK AND2_X1
X$15449 \$3699 \$41518 \$41877 NWELL PWELL BULK AND2_X1
X$15452 \$3699 \$41522 \$41523 NWELL PWELL BULK AND2_X1
X$15455 \$3699 \$41812 \$44271 \$41885 NWELL PWELL BULK AND3_X1
X$15458 \$3699 \$40207 \$40618 NWELL PWELL BULK AND2_X1
X$15461 \$3699 \$40634 \$41123 \$40209 NWELL PWELL BULK AND3_X1
X$15463 \$42201 \$42468 \$3699 \$42835 NWELL PWELL BULK NAND3_X1
X$15465 \$3699 \$41179 \$41801 NWELL PWELL BULK AND2_X1
X$15468 \$3699 \$41173 \$41458 NWELL PWELL BULK AND2_X1
X$15470 \$3699 \$36110 \$37124 NWELL PWELL BULK AND2_X1
X$15472 \$3699 \$35250 \$36568 \$37486 NWELL PWELL BULK AND3_X1
X$15475 \$3699 \$38278 \$38281 NWELL PWELL BULK AND2_X1
X$15477 \$3699 \$38259 \$36588 NWELL PWELL BULK AND2_X1
X$15480 \$36104 \$34771 \$3699 \$33879 NWELL PWELL BULK NAND3_X1
X$15482 \$36580 \$3699 \$37012 NWELL PWELL BULK NAND2_X1
X$15484 \$38259 \$3699 \$38432 NWELL PWELL BULK NAND2_X1
X$15487 \$36097 \$36081 \$3699 \$35251 NWELL PWELL BULK NAND3_X1
X$15490 \$3699 \$37000 \$36995 NWELL PWELL BULK AND2_X1
X$15494 \$38814 \$3699 \$39198 NWELL PWELL BULK NAND2_X1
X$15497 \$38415 \$3699 \$38417 NWELL PWELL BULK NAND2_X1
X$15501 \$3699 \$38437 \$38282 NWELL PWELL BULK AND2_X1
X$15503 \$3699 \$41171 \$41513 NWELL PWELL BULK AND2_X1
X$15505 \$38433 \$3699 \$39149 NWELL PWELL BULK NAND2_X1
X$15507 \$9182 \$9437 \$3699 \$9155 NWELL PWELL BULK NAND3_X1
X$15510 \$27822 \$27678 \$3699 \$30778 NWELL PWELL BULK NAND3_X1
X$15513 \$8435 \$8848 \$3699 \$7975 NWELL PWELL BULK OAI21_X1
X$15518 \$31017 \$3699 \$31344 NWELL PWELL BULK NAND2_X1
X$15521 \$27066 \$27067 \$3699 \$27717 NWELL PWELL BULK OAI21_X1
X$15524 \$3699 \$8054 \$7672 NWELL PWELL BULK AND2_X1
X$15526 \$26879 \$25925 \$3699 \$29956 NWELL PWELL BULK OAI21_X1
X$15528 \$3699 \$31647 \$31771 NWELL PWELL BULK AND2_X1
X$15531 \$3699 \$9441 \$9512 NWELL PWELL BULK AND2_X1
X$15534 \$30932 \$3699 \$30933 NWELL PWELL BULK NAND2_X1
X$15536 \$23112 \$23765 \$3699 \$23764 NWELL PWELL BULK NAND3_X1
X$15539 \$24174 \$3699 \$24466 NWELL PWELL BULK NAND2_X1
X$15541 \$6135 \$6140 \$3699 \$6136 NWELL PWELL BULK NAND3_X1
X$15543 \$21802 \$22643 \$21384 \$3699 \$22257 NWELL PWELL BULK NAND4_X1
X$15545 \$22126 \$3699 \$21798 NWELL PWELL BULK NAND2_X1
X$15547 \$24045 \$22260 \$3699 \$23759 \$24046 NWELL PWELL BULK AOI22_X1
X$15549 \$27432 \$23579 \$3699 \$30010 NWELL PWELL BULK NAND3_X1
X$15551 \$3699 \$6150 \$6130 NWELL PWELL BULK AND2_X1
X$15553 \$21367 \$21618 \$3699 \$22071 NWELL PWELL BULK NAND3_X1
X$15555 \$3699 \$25892 \$26742 NWELL PWELL BULK AND2_X1
X$15557 \$3699 \$26748 \$25893 NWELL PWELL BULK AND2_X1
X$15559 \$3699 \$26242 \$26241 NWELL PWELL BULK AND2_X1
X$15561 \$3699 \$24928 \$24442 NWELL PWELL BULK AND2_X1
X$15563 \$3699 \$26718 \$26381 NWELL PWELL BULK AND2_X1
X$15565 \$3699 \$28677 \$28679 NWELL PWELL BULK AND2_X1
X$15568 \$3699 \$29486 \$29480 NWELL PWELL BULK AND2_X1
X$15570 \$3699 \$25214 \$24157 NWELL PWELL BULK AND2_X1
X$15574 AXI_RSTn \$3699 NWELL PWELL BULK BUF_X32
X$15577 \$3699 \$9156 \$9508 NWELL PWELL BULK AND2_X1
X$15580 \$3699 \$28764 \$25925 \$26419 \$26879 NWELL PWELL BULK OAI211_X4
X$15583 \$30283 \$30281 \$3699 \$29967 \$31409 NWELL PWELL BULK AOI22_X1
X$15585 \$3699 \$24005 \$24007 NWELL PWELL BULK AND2_X1
X$15588 \$24023 \$23752 \$3699 \$23185 NWELL PWELL BULK NAND3_X1
X$15590 \$3699 \$49013 \$48226 \$48621 NWELL PWELL BULK AND3_X1
X$15592 \$3699 \$49444 \$49806 \$49812 NWELL PWELL BULK AND3_X1
X$15594 \$3699 \$50494 \$50176 \$50495 NWELL PWELL BULK AND3_X1
X$15596 \$3699 \$49163 \$49523 NWELL PWELL BULK AND2_X1
X$15598 \$3699 \$49026 \$48623 NWELL PWELL BULK AND2_X1
X$15600 \$3699 \$58759 \$58064 NWELL PWELL BULK AND2_X1
X$15603 \$3699 \$57004 \$57272 NWELL PWELL BULK AND2_X1
X$15605 \$3699 \$57708 \$58443 NWELL PWELL BULK AND2_X1
X$15607 \$3699 \$58873 \$59400 NWELL PWELL BULK AND2_X1
X$15609 \$56978 \$57265 \$3699 \$57264 NWELL PWELL BULK NAND3_X1
X$15611 \$3699 \$48617 \$49376 \$49435 NWELL PWELL BULK AND3_X1
X$15614 \$3699 \$49430 \$49415 \$49000 NWELL PWELL BULK AND3_X1
X$15617 \$3699 \$50075 \$50087 \$50078 NWELL PWELL BULK AND3_X1
X$15619 \$74231 \$73494 \$3699 \$74236 NWELL PWELL BULK NAND3_X1
X$15622 \$3699 \$62208 \$62207 NWELL PWELL BULK AND2_X1
X$15625 \$3699 \$64219 \$63925 NWELL PWELL BULK AND2_X1
X$15627 \$3699 \$62531 \$62202 NWELL PWELL BULK AND2_X1
X$15630 \$3699 \$62526 \$61493 NWELL PWELL BULK AND2_X1
X$15632 \$3699 \$60595 \$60594 NWELL PWELL BULK AND2_X1
X$15634 \$3699 \$55706 \$55497 NWELL PWELL BULK AND2_X1
X$15636 \$3699 \$54990 \$54541 NWELL PWELL BULK AND2_X1
X$15638 \$63093 \$3699 \$63331 NWELL PWELL BULK NAND2_X1
X$15640 \$3699 \$63329 \$63383 NWELL PWELL BULK AND2_X1
X$15642 \$3699 \$74480 \$74481 NWELL PWELL BULK AND2_X1
X$15644 \$41079 \$40216 \$3699 \$40577 NWELL PWELL BULK NAND3_X1
X$15646 \$3699 \$39083 \$38841 NWELL PWELL BULK AND2_X1
X$15649 \$40592 \$39331 \$3699 \$39861 NWELL PWELL BULK NAND3_X1
X$15651 \$39855 \$39329 \$3699 \$39697 NWELL PWELL BULK NAND3_X1
X$15653 \$41773 \$41768 \$3699 \$41538 NWELL PWELL BULK NAND3_X1
X$15656 \$3699 \$42489 \$42146 NWELL PWELL BULK AND2_X1
X$15659 \$3699 \$39848 \$40646 NWELL PWELL BULK AND2_X1
X$15662 \$3699 \$47093 \$46697 \$46759 NWELL PWELL BULK AND3_X1
X$15664 \$3699 \$46395 \$46465 NWELL PWELL BULK AND2_X1
X$15666 \$3699 \$47840 \$47556 \$47557 NWELL PWELL BULK AND3_X1
X$15668 \$3699 \$47204 \$47205 NWELL PWELL BULK AND2_X1
X$15670 \$27889 \$3699 \$47209 NWELL PWELL BULK NAND2_X1
X$15673 \$3699 \$47100 \$47200 NWELL PWELL BULK AND2_X1
X$15675 \$3699 \$44863 \$44544 NWELL PWELL BULK AND2_X1
X$15677 \$3699 \$45202 \$45155 \$45196 NWELL PWELL BULK AND3_X1
X$15679 \$3699 \$45618 \$45619 NWELL PWELL BULK AND2_X1
X$15681 \$45974 \$45277 \$3699 \$45693 NWELL PWELL BULK NAND3_X1
X$15683 \$52897 \$53551 \$3699 \$53558 NWELL PWELL BULK NAND3_X1
X$15685 \$52547 \$3699 \$52898 NWELL PWELL BULK NAND2_X1
X$15687 \$53196 \$53197 \$3699 \$53728 NWELL PWELL BULK NAND3_X1
X$15689 \$52480 \$52482 \$3699 \$52477 NWELL PWELL BULK OAI21_X1
X$15691 \$52840 \$52556 \$3699 \$52834 NWELL PWELL BULK NAND3_X1
X$15693 \$52047 \$3699 \$52046 NWELL PWELL BULK NAND2_X1
X$15695 \$53230 \$3699 \$53214 NWELL PWELL BULK NAND2_X1
X$15697 \$3699 \$45285 \$44925 NWELL PWELL BULK AND2_X1
X$15699 \$3699 \$52043 \$52434 NWELL PWELL BULK AND2_X1
X$15703 \$3699 \$45281 \$45271 \$45958 NWELL PWELL BULK AND3_X1
X$15705 \$52565 \$3699 \$52439 NWELL PWELL BULK NAND2_X1
X$15708 \$3699 \$52804 \$53670 NWELL PWELL BULK AND2_X1
X$15711 \$3699 \$50507 \$50193 NWELL PWELL BULK AND2_X1
X$15713 \$3699 \$16528 \$16265 NWELL PWELL BULK AND2_X1
X$15715 \$16702 \$3699 \$17086 NWELL PWELL BULK NAND2_X1
X$15717 \$14515 \$3699 \$16270 NWELL PWELL BULK NAND2_X1
X$15719 \$17246 \$13490 \$17050 \$3699 \$17059 NWELL PWELL BULK NAND4_X1
X$15721 \$12118 \$3699 \$11871 NWELL PWELL BULK NAND2_X1
X$15723 \$12117 \$10449 \$3699 \$11846 NWELL PWELL BULK NAND3_X1
X$15725 \$11172 \$3699 \$10804 NWELL PWELL BULK NAND2_X1
X$15728 \$3699 \$14850 \$13989 NWELL PWELL BULK AND2_X1
X$15730 \$19162 \$16940 \$3699 \$20738 NWELL PWELL BULK NAND3_X1
X$15733 \$19771 \$3699 \$20156 NWELL PWELL BULK NAND2_X1
X$15736 \$52774 \$53068 \$3699 \$53679 NWELL PWELL BULK NAND3_X1
X$15739 \$3699 \$58109 \$58723 NWELL PWELL BULK AND2_X1
X$15742 \$3699 \$55683 \$55847 NWELL PWELL BULK AND2_X1
X$15744 \$44596 \$44849 \$3699 \$44859 NWELL PWELL BULK NAND3_X1
X$15746 \$47489 \$47803 \$3699 \$47805 NWELL PWELL BULK NAND3_X1
X$15748 \$11070 \$11455 \$3699 \$11460 NWELL PWELL BULK NAND3_X1
X$15751 \$3699 \$11821 \$11456 NWELL PWELL BULK AND2_X1
X$15753 \$46776 \$47779 \$3699 \$47452 NWELL PWELL BULK NAND3_X1
X$15755 \$50891 \$50892 \$3699 \$51343 NWELL PWELL BULK NAND3_X1
X$15758 \$3699 \$49078 \$48634 NWELL PWELL BULK AND2_X1
X$15760 \$3699 \$65932 \$65933 NWELL PWELL BULK AND2_X1
X$15762 \$16031 \$16275 \$3699 \$14776 NWELL PWELL BULK NAND3_X1
X$15764 \$3699 \$55101 \$55515 NWELL PWELL BULK AND2_X1
X$15767 \$56267 \$56294 \$3699 \$55509 NWELL PWELL BULK NAND3_X1
X$15769 \$16964 \$3699 \$14782 NWELL PWELL BULK NAND2_X1
X$15772 \$57328 \$57569 \$3699 \$57213 NWELL PWELL BULK OAI21_X1
X$15775 \$3699 \$57332 \$57913 NWELL PWELL BULK AND2_X1
X$15777 \$3699 \$63855 \$63858 NWELL PWELL BULK AND2_X1
X$15779 \$3699 \$63450 \$63018 NWELL PWELL BULK AND2_X1
X$15782 \$3699 \$63846 \$63449 NWELL PWELL BULK AND2_X1
X$15785 \$65497 \$64890 \$3699 \$65505 NWELL PWELL BULK NAND3_X1
X$15787 \$3699 \$57197 \$57204 NWELL PWELL BULK AND2_X1
X$15789 \$3699 \$59908 \$60251 NWELL PWELL BULK AND2_X1
X$15792 \$3699 \$61775 \$61763 NWELL PWELL BULK AND2_X1
X$15794 \$16031 \$3699 \$17443 NWELL PWELL BULK NAND2_X1
X$15796 \$3699 \$63963 \$64407 NWELL PWELL BULK AND2_X1
X$15799 \$17995 \$3699 \$19872 NWELL PWELL BULK NAND2_X1
X$15801 \$19151 \$18954 \$3699 \$19592 NWELL PWELL BULK NAND3_X1
X$15803 \$19143 \$18425 \$3699 \$19145 NWELL PWELL BULK NAND3_X2
X$15805 \$3699 \$74247 \$73846 NWELL PWELL BULK AND2_X1
X$15808 \$3699 \$72945 \$72951 NWELL PWELL BULK AND2_X1
X$15810 \$19145 \$19141 \$3699 \$19891 NWELL PWELL BULK OAI21_X1
X$15812 \$3699 \$10090 \$10057 NWELL PWELL BULK AND2_X1
X$15814 \$75053 \$75052 \$3699 \$74903 NWELL PWELL BULK NAND3_X1
X$15816 \$3699 \$45704 \$46396 NWELL PWELL BULK AND2_X1
X$15818 \$44288 \$44608 \$3699 \$44606 NWELL PWELL BULK OAI21_X1
X$15821 \$13069 \$13512 \$3699 \$13565 NWELL PWELL BULK NAND3_X1
X$15823 \$9843 \$10112 \$3699 \$10042 NWELL PWELL BULK NAND3_X1
X$15825 \$11520 \$3699 \$11775 NWELL PWELL BULK NAND2_X1
X$15828 \$10449 \$3699 \$10821 NWELL PWELL BULK NAND2_X1
X$15830 \$3699 \$72543 \$73684 NWELL PWELL BULK AND2_X1
X$15833 \$3699 \$72785 \$72781 NWELL PWELL BULK AND2_X1
X$15836 \$3699 \$44926 NWELL PWELL BULK INV_X32
X$15838 \$3699 \$9193 \$9195 NWELL PWELL BULK AND2_X1
X$15840 \$12988 \$11431 \$3699 \$13838 NWELL PWELL BULK NAND3_X1
X$15844 \$14741 \$3699 \$14759 NWELL PWELL BULK NAND2_X1
X$15846 \$13211 \$11791 \$12118 \$3699 \$13198 NWELL PWELL BULK NAND4_X1
X$15848 \$3699 \$13497 \$13498 \$11479 NWELL PWELL BULK OAI21_X2
X$15850 \$3699 \$70661 \$70659 NWELL PWELL BULK AND2_X1
X$15852 \$73400 \$73401 \$3699 \$73399 NWELL PWELL BULK NAND3_X1
X$15854 \$66289 \$65979 \$3699 \$66198 NWELL PWELL BULK NAND3_X1
X$15856 \$3699 \$66182 \$65586 NWELL PWELL BULK AND2_X1
X$15858 \$70643 \$70645 \$3699 \$69842 NWELL PWELL BULK NAND3_X1
X$15860 \$3699 \$26647 \$26080 NWELL PWELL BULK AND2_X1
X$15863 \$3699 \$29735 \$29926 NWELL PWELL BULK AND2_X1
X$15865 \$3699 \$34232 \$33746 NWELL PWELL BULK AND2_X1
X$15867 \$32512 \$3699 \$33073 NWELL PWELL BULK NAND2_X1
X$15870 \$32816 \$32505 \$3699 \$32116 NWELL PWELL BULK OAI21_X1
X$15873 \$32500 \$33860 \$3699 \$32498 NWELL PWELL BULK NAND3_X1
X$15876 \$3699 \$12272 \$12265 NWELL PWELL BULK AND2_X1
X$15879 \$3699 \$36960 \$36134 NWELL PWELL BULK AND2_X1
X$15881 \$33354 \$32500 \$3699 \$32112 NWELL PWELL BULK NAND3_X1
X$15884 \$3699 \$31977 \$31528 NWELL PWELL BULK AND2_X1
X$15887 \$3699 \$8690 \$9057 NWELL PWELL BULK AND2_X1
X$15890 \$31795 \$31988 \$3699 \$31794 NWELL PWELL BULK NAND3_X1
X$15893 \$24250 \$25088 \$3699 \$24602 NWELL PWELL BULK NAND3_X1
X$15895 \$28914 \$28912 \$3699 \$29476 NWELL PWELL BULK NAND3_X1
X$15897 \$34252 \$34251 \$3699 \$34496 NWELL PWELL BULK NAND3_X1
X$15900 \$3699 \$29744 \$30138 NWELL PWELL BULK AND2_X1
X$15903 \$3699 \$9344 \$9793 NWELL PWELL BULK AND2_X1
X$15905 \$36987 \$36983 \$3699 \$36997 NWELL PWELL BULK NAND3_X1
X$15907 \$3699 \$19293 \$19096 NWELL PWELL BULK AND2_X1
X$15909 \$3699 \$20696 \$20972 NWELL PWELL BULK AND2_X1
X$15912 \$3699 \$30478 \$30331 NWELL PWELL BULK AND2_X1
X$15914 \$3699 \$28123 \$27193 NWELL PWELL BULK AND2_X1
X$15916 \$3699 \$22288 \$22289 \$22913 NWELL PWELL BULK AND3_X1
X$15918 \$3699 \$28526 \$28385 NWELL PWELL BULK AND2_X1
X$15920 \$30103 \$30486 \$3699 \$30131 NWELL PWELL BULK NAND3_X1
X$15922 \$3699 \$42555 \$42550 \$42815 NWELL PWELL BULK AND3_X1
X$15924 \$3699 \$25623 \$24544 NWELL PWELL BULK AND2_X1
X$15927 \$29267 \$29270 \$3699 \$29268 NWELL PWELL BULK NAND3_X1
X$15929 \$3699 \$28860 \$29373 NWELL PWELL BULK AND2_X1
X$15931 \$25449 \$25011 \$3699 \$25452 NWELL PWELL BULK NAND3_X1
X$15934 \$3699 \$28077 \$28853 NWELL PWELL BULK AND2_X1
X$15936 \$27891 \$28091 \$3699 \$17990 NWELL PWELL BULK OAI21_X1
X$15939 \$3699 \$32336 \$32749 NWELL PWELL BULK AND2_X1
X$15941 \$29335 \$29233 \$3699 \$29326 NWELL PWELL BULK NAND3_X1
X$15944 \$27768 \$28098 \$3699 \$28088 NWELL PWELL BULK NAND3_X1
X$15946 \$30819 \$30465 \$3699 \$30863 NWELL PWELL BULK NAND3_X1
X$15948 \$21416 \$21410 \$3699 \$21850 NWELL PWELL BULK OAI21_X1
X$15951 \$3699 \$29239 \$29240 NWELL PWELL BULK AND2_X1
X$15954 \$39047 \$38853 \$3699 \$38465 NWELL PWELL BULK NAND3_X1
X$15957 \$3699 \$24639 \$25112 NWELL PWELL BULK AND2_X1
X$15959 \$22650 \$22260 \$3699 \$22262 \$23561 NWELL PWELL BULK AOI22_X1
X$15962 \$3699 \$39640 \$39988 NWELL PWELL BULK AND2_X1
X$15964 \$22895 \$22891 \$3699 \$23116 NWELL PWELL BULK NAND3_X1
X$15966 \$22342 \$22560 \$3699 \$22576 NWELL PWELL BULK NAND3_X1
X$15969 \$25925 \$3699 \$26888 NWELL PWELL BULK NAND2_X1
X$15971 \$25927 \$25925 \$3699 \$25379 NWELL PWELL BULK NAND3_X2
X$15973 \$3699 \$28785 \$29196 NWELL PWELL BULK AND2_X1
X$15976 \$42550 \$42552 \$3699 \$42553 NWELL PWELL BULK OAI21_X1
X$15978 \$26670 \$26673 \$3699 \$26679 NWELL PWELL BULK NAND3_X1
X$15980 \$21455 \$22642 \$3699 \$22626 NWELL PWELL BULK NAND3_X1
X$15983 \$3699 \$28786 \$29532 NWELL PWELL BULK AND2_X1
X$15986 \$3699 \$29741 \$29891 NWELL PWELL BULK AND2_X1
X$15989 \$3699 \$27179 \$27502 NWELL PWELL BULK AND2_X1
X$15992 \$3699 \$29292 \$29289 NWELL PWELL BULK AND2_X1
X$15994 \$32505 \$31992 \$3699 \$32378 NWELL PWELL BULK OAI21_X1
X$15997 \$3699 \$9054 \$9053 NWELL PWELL BULK AND2_X1
X$15999 \$3699 \$37139 \$37347 NWELL PWELL BULK AND2_X1
X$16001 \$3699 \$32352 \$32923 NWELL PWELL BULK AND2_X1
X$16003 \$3699 \$38245 \$38462 NWELL PWELL BULK AND2_X1
X$16005 \$30723 \$30298 \$3699 \$30725 NWELL PWELL BULK NAND3_X1
X$16008 \$3699 \$7230 \$7089 NWELL PWELL BULK AND2_X1
X$16011 \$8001 \$8003 \$3699 \$8002 NWELL PWELL BULK NAND3_X1
X$16013 \$3699 \$7084 \$7083 NWELL PWELL BULK AND2_X1
X$16015 \$3699 \$30689 \$30304 NWELL PWELL BULK AND2_X1
X$16017 \$3699 \$32981 \$32362 NWELL PWELL BULK AND2_X1
X$16019 \$31224 \$3699 \$31226 NWELL PWELL BULK NAND2_X1
X$16023 \$3699 \$31036 \$31522 NWELL PWELL BULK AND2_X1
X$16026 \$35656 \$38404 \$3699 \$38178 NWELL PWELL BULK NAND3_X1
X$16029 \$38122 \$3699 \$40177 NWELL PWELL BULK NAND2_X1
X$16031 \$40720 \$3699 \$40719 \$40170 NWELL PWELL BULK AOI21_X1
X$16034 \$40458 \$38668 \$3699 \$40154 NWELL PWELL BULK OAI21_X1
X$16036 \$40717 \$3699 \$40712 NWELL PWELL BULK NAND2_X1
X$16039 \$36081 \$3699 \$38414 NWELL PWELL BULK NAND2_X1
X$16041 \$39299 \$3699 \$38415 \$40088 NWELL PWELL BULK AOI21_X1
X$16572 \$17920 \$9693 \$18341 \$3778 NWELL PWELL BULK MUX2_X1
X$16617 \$3826 \$3922 \$3871 \$3824 NWELL PWELL BULK MUX2_X1
X$16624 \$3960 \$3962 \$3826 \$4192 NWELL PWELL BULK MUX2_X1
X$16647 \$3858 \$4338 \$6842 \$7637 NWELL PWELL BULK MUX2_X1
X$16650 \$3858 \$4398 \$7389 \$7175 NWELL PWELL BULK MUX2_X1
X$16653 \$6463 \$4375 \$3858 \$6634 NWELL PWELL BULK MUX2_X1
X$16656 \$6111 \$4537 \$3858 \$6467 NWELL PWELL BULK MUX2_X1
X$16685 \$3960 \$4336 \$3871 \$4173 NWELL PWELL BULK MUX2_X1
X$16687 \$3871 \$4338 \$4341 \$3963 NWELL PWELL BULK MUX2_X1
X$16689 \$3871 \$4398 \$4343 \$3966 NWELL PWELL BULK MUX2_X1
X$16749 \$4378 \$3922 \$4213 \$4890 NWELL PWELL BULK MUX2_X1
X$16751 \$5438 \$3922 \$4680 \$5632 NWELL PWELL BULK MUX2_X1
X$16753 \$6755 \$3922 \$6758 \$6591 NWELL PWELL BULK MUX2_X1
X$16755 \$9110 \$3922 \$8741 \$9673 NWELL PWELL BULK MUX2_X1
X$16758 \$4231 \$3922 \$3973 \$4227 NWELL PWELL BULK MUX2_X1
X$16760 \$4695 \$3922 \$4348 \$4569 NWELL PWELL BULK MUX2_X1
X$16762 \$7611 \$3922 \$6802 \$7809 NWELL PWELL BULK MUX2_X1
X$16764 \$8239 \$3922 \$7606 \$7822 NWELL PWELL BULK MUX2_X1
X$16767 \$6817 \$3922 \$6439 \$7153 NWELL PWELL BULK MUX2_X1
X$16770 \$7620 \$3922 \$8330 \$8325 NWELL PWELL BULK MUX2_X1
X$16772 \$4289 \$3922 \$3926 \$4288 NWELL PWELL BULK MUX2_X1
X$16776 \$3922 \$8980 NWELL PWELL BULK BUF_X8
X$16778 \$10645 \$3922 \$10646 \$11334 NWELL PWELL BULK MUX2_X1
X$16780 \$12956 \$3922 \$12957 \$14078 NWELL PWELL BULK MUX2_X1
X$16782 \$6054 \$3922 \$5757 \$6628 NWELL PWELL BULK MUX2_X1
X$16785 \$4707 \$3922 \$4357 \$4708 NWELL PWELL BULK MUX2_X1
X$16788 \$6046 \$3922 \$5748 \$6230 NWELL PWELL BULK MUX2_X1
X$16791 \$7585 \$3922 \$7123 \$8126 NWELL PWELL BULK MUX2_X1
X$16821 \$3926 \$4398 \$5352 \$5458 NWELL PWELL BULK MUX2_X1
X$16824 \$3926 \$4338 \$5347 \$4978 NWELL PWELL BULK MUX2_X1
X$16826 \$3992 \$4336 \$3926 \$4642 NWELL PWELL BULK MUX2_X1
X$16836 \$24191 \$16197 \$25357 \$3931 NWELL PWELL BULK OAI21_X4
X$16839 \$3931 \$27064 \$27066 NWELL PWELL BULK NAND2_X1
X$16842 \$3931 \$27403 \$25900 \$26262 \$27718 NWELL PWELL BULK AOI22_X1
X$16844 \$3931 \$26766 \$28484 \$27719 \$27791 NWELL PWELL BULK OAI22_X1
X$16848 \$26262 \$27070 \$3931 \$27409 NWELL PWELL BULK AOI21_X1
X$16850 \$26768 \$26393 \$3931 \$25897 NWELL PWELL BULK AOI21_X1
X$16853 \$27423 \$27804 \$26399 \$3931 \$27685 \$27428 NWELL PWELL BULK
+ OAI221_X2
X$16855 \$3931 \$26399 \$27685 \$26813 NWELL PWELL BULK OAI21_X1
X$16876 \$27867 \$3932 NWELL PWELL BULK BUF_X32
X$16878 \$3932 \$33462 \$33795 \$33463 NWELL PWELL BULK AOI21_X1
X$16881 \$35570 \$3932 \$34478 NWELL PWELL BULK NOR2_X1
X$16883 \$36374 \$3932 \$35275 NWELL PWELL BULK NOR2_X1
X$16885 \$34643 \$3932 \$34340 NWELL PWELL BULK NOR2_X1
X$16887 \$3932 \$33461 \$34334 \$34330 NWELL PWELL BULK AOI21_X1
X$16890 \$3932 \$31016 \$31335 \$31509 NWELL PWELL BULK AOI21_X1
X$16892 \$32436 \$3932 \$32142 NWELL PWELL BULK NOR2_X1
X$16894 \$3932 \$33454 \$33085 \$33455 NWELL PWELL BULK AOI21_X1
X$16897 \$25879 \$3932 \$33791 NWELL PWELL BULK NOR2_X1
X$16900 \$3932 \$38430 \$38292 \$37647 NWELL PWELL BULK AOI21_X1
X$16902 \$35739 \$3932 \$35740 NWELL PWELL BULK NOR2_X1
X$16905 \$3932 \$33458 \$33803 \$33800 NWELL PWELL BULK AOI21_X1
X$16908 \$37644 \$37511 \$38333 \$3932 \$37510 NWELL PWELL BULK NOR4_X1
X$16910 \$32895 \$3932 \$32442 NWELL PWELL BULK NOR2_X1
X$16912 \$27718 \$3932 \$29070 NWELL PWELL BULK NOR2_X1
X$16914 \$28156 \$3932 \$28148 NWELL PWELL BULK NOR2_X1
X$16916 \$3932 \$28116 \$27391 \$27776 NWELL PWELL BULK AOI21_X1
X$16918 \$29022 \$3932 \$29129 NWELL PWELL BULK NOR2_X1
X$16920 \$31001 \$30759 \$3932 \$31295 NWELL PWELL BULK NOR3_X1
X$16922 \$30527 \$3932 \$30521 NWELL PWELL BULK NOR2_X1
X$16924 \$3932 \$32439 \$32924 \$31765 NWELL PWELL BULK AOI21_X1
X$16927 \$3932 \$32531 \$32922 \$32135 NWELL PWELL BULK AOI21_X1
X$16929 \$30940 \$30570 \$3932 \$30054 NWELL PWELL BULK NOR3_X1
X$16931 \$3932 \$31010 \$31319 \$30943 NWELL PWELL BULK AOI21_X1
X$16933 \$3932 \$29518 \$29515 NWELL PWELL BULK OR2_X1
X$16935 \$3932 \$27277 \$27393 NWELL PWELL BULK OR2_X1
X$16937 \$38446 \$38447 \$37504 \$3932 \$39100 NWELL PWELL BULK NOR4_X1
X$16940 \$37493 \$3932 \$38444 NWELL PWELL BULK NOR2_X1
X$16943 \$41882 \$3932 \$42203 NWELL PWELL BULK NOR2_X1
X$16945 \$41120 \$3932 \$40625 NWELL PWELL BULK NOR2_X1
X$16947 \$30588 \$3932 \$30168 NWELL PWELL BULK NOR2_X1
X$16949 \$3932 \$29547 \$30060 \$29996 NWELL PWELL BULK AOI21_X1
X$16951 \$3932 \$27822 \$31381 \$30068 \$25917 \$30778 \$31379 NWELL PWELL BULK
+ OAI33_X1
X$16953 \$29142 \$3932 \$29144 NWELL PWELL BULK NOR2_X1
X$16955 \$29981 \$3932 \$30055 NWELL PWELL BULK NOR2_X1
X$16957 \$30924 \$3932 \$31514 NWELL PWELL BULK NOR2_X1
X$16959 \$22633 \$3932 \$23539 NWELL PWELL BULK NOR2_X1
X$16961 \$21262 \$3932 \$21259 NWELL PWELL BULK NOR2_X1
X$16963 \$3932 \$22623 \$22145 \$22620 NWELL PWELL BULK AOI21_X1
X$16965 \$23575 \$3932 \$23551 NWELL PWELL BULK NOR2_X1
X$16968 \$3932 \$26810 \$25739 \$24945 NWELL PWELL BULK AOI21_X1
X$16970 \$3932 \$23746 \$23172 \$23490 NWELL PWELL BULK AOI21_X1
X$16972 \$3932 \$22083 \$21369 \$21783 NWELL PWELL BULK AOI21_X1
X$16974 \$3932 \$22875 \$23178 \$23179 NWELL PWELL BULK AOI21_X1
X$16977 \$3932 \$22539 \$23068 \$22535 NWELL PWELL BULK AOI21_X1
X$16979 \$3932 \$24166 \$24165 \$25250 NWELL PWELL BULK AOI21_X1
X$16981 \$3932 \$25696 \$25349 \$25888 NWELL PWELL BULK AOI21_X1
X$16984 \$3932 \$25883 \$26190 NWELL PWELL BULK OR2_X1
X$16986 \$28673 \$3932 \$28476 NWELL PWELL BULK NOR2_X1
X$16988 \$28107 \$3932 \$28108 NWELL PWELL BULK NOR2_X1
X$16990 \$27781 \$3932 \$28128 NWELL PWELL BULK NOR2_X1
X$16992 \$23472 \$3932 \$23995 NWELL PWELL BULK NOR2_X1
X$16994 \$3932 \$30784 \$31408 \$31515 NWELL PWELL BULK AOI21_X1
X$16997 \$30154 \$3932 \$30288 NWELL PWELL BULK NOR2_X1
X$16999 \$29984 \$26294 \$30652 \$3932 \$30647 NWELL PWELL BULK NOR4_X1
X$17001 \$3932 \$23183 \$23751 \$23184 NWELL PWELL BULK AOI21_X1
X$17003 \$25230 \$3932 \$24930 NWELL PWELL BULK NOR2_X1
X$17005 \$27268 \$3932 \$26725 NWELL PWELL BULK NOR2_X1
X$17008 \$25225 \$3932 \$25688 NWELL PWELL BULK NOR2_X1
X$17010 \$3932 \$25236 \$24455 \$25700 NWELL PWELL BULK AOI21_X1
X$17012 \$12281 \$3932 \$11993 NWELL PWELL BULK NOR2_X1
X$17015 \$3932 \$9471 \$9336 \$9687 NWELL PWELL BULK AOI21_X1
X$17017 \$11512 \$3932 \$11507 NWELL PWELL BULK NOR2_X1
X$17019 \$19439 \$3932 \$19295 NWELL PWELL BULK NOR2_X1
X$17021 \$20373 \$3932 \$20372 NWELL PWELL BULK NOR2_X1
X$17023 \$22770 \$3932 \$22296 NWELL PWELL BULK NOR2_X1
X$17025 \$23074 \$3932 \$23679 NWELL PWELL BULK NOR2_X1
X$17027 \$21291 \$3932 \$21290 NWELL PWELL BULK NOR2_X1
X$17030 \$3932 \$22293 \$23784 \$24343 NWELL PWELL BULK AOI21_X1
X$17032 \$3932 \$24498 \$24885 \$24966 NWELL PWELL BULK AOI21_X1
X$17035 \$3932 \$8803 \$8682 \$8796 NWELL PWELL BULK AOI21_X1
X$17037 \$3932 \$9167 \$9170 \$9457 NWELL PWELL BULK AOI21_X1
X$17039 \$3932 \$7680 \$7678 \$7087 NWELL PWELL BULK AOI21_X1
X$17041 \$8016 \$3932 \$7564 NWELL PWELL BULK NOR2_X1
X$17045 \$3932 \$8477 \$8474 NWELL PWELL BULK OR2_X1
X$17159 \$7318 \$3937 NWELL PWELL BULK BUF_X4
X$17162 \$3937 \$9959 NWELL PWELL BULK BUF_X4
X$17164 \$3937 \$13875 NWELL PWELL BULK BUF_X4
X$17166 \$3937 \$15814 NWELL PWELL BULK BUF_X4
X$17170 \$3937 \$10263 NWELL PWELL BULK BUF_X4
X$17173 \$3937 \$21355 NWELL PWELL BULK BUF_X4
X$17176 \$3937 \$18338 NWELL PWELL BULK BUF_X4
X$17180 \$3937 \$6741 NWELL PWELL BULK BUF_X4
X$17183 \$3937 \$20888 NWELL PWELL BULK BUF_X4
X$17186 \$3937 \$15283 NWELL PWELL BULK BUF_X4
X$17234 \$13811 \$3962 \$14165 \$14082 NWELL PWELL BULK MUX2_X1
X$17237 \$11344 \$3962 \$10933 \$9732 NWELL PWELL BULK MUX2_X1
X$17239 \$5933 \$3962 \$5749 \$5942 NWELL PWELL BULK MUX2_X1
X$17242 \$4964 \$3962 \$4707 \$4973 NWELL PWELL BULK MUX2_X1
X$17245 \$7119 \$3962 \$7585 \$7325 NWELL PWELL BULK MUX2_X1
X$17248 \$5243 \$3962 \$4684 \$5234 NWELL PWELL BULK MUX2_X1
X$17251 \$8738 \$3962 \$9106 \$9322 NWELL PWELL BULK MUX2_X1
X$17253 \$8372 \$3962 \$8982 \$8992 NWELL PWELL BULK MUX2_X1
X$17256 \$9331 \$3962 \$9099 \$9098 NWELL PWELL BULK MUX2_X1
X$17258 \$4346 \$3962 \$4695 \$4347 NWELL PWELL BULK MUX2_X1
X$17261 \$5282 \$3962 \$5284 \$4928 NWELL PWELL BULK MUX2_X1
X$17263 \$3992 \$3962 \$4289 \$4362 NWELL PWELL BULK MUX2_X1
X$17265 \$10320 \$3962 \$10639 \$10321 NWELL PWELL BULK MUX2_X1
X$17267 \$12070 \$3962 \$12501 \$12509 NWELL PWELL BULK MUX2_X1
X$17270 \$15337 \$3962 \$14458 \$14170 NWELL PWELL BULK MUX2_X1
X$17273 \$7905 \$3962 \$8239 \$8240 NWELL PWELL BULK MUX2_X1
X$17275 \$9395 \$3962 \$8732 \$9013 NWELL PWELL BULK MUX2_X1
X$17277 \$7907 \$3962 \$7607 \$7814 NWELL PWELL BULK MUX2_X1
X$17279 \$5347 \$3962 \$5352 \$4713 NWELL PWELL BULK MUX2_X1
X$17281 \$4376 \$3962 NWELL PWELL BULK BUF_X16
X$17284 \$14870 \$3962 \$14168 \$14454 NWELL PWELL BULK MUX2_X1
X$17286 \$15013 \$3962 \$14863 \$14316 NWELL PWELL BULK MUX2_X1
X$17288 \$12479 \$3962 \$12954 \$13327 NWELL PWELL BULK MUX2_X1
X$17290 \$13338 \$3962 \$12065 \$12497 NWELL PWELL BULK MUX2_X1
X$17292 \$5756 \$3962 \$6057 \$6633 NWELL PWELL BULK MUX2_X1
X$17295 \$4350 \$3962 \$4231 \$4600 NWELL PWELL BULK MUX2_X1
X$17298 \$6053 \$3962 \$6054 \$6055 NWELL PWELL BULK MUX2_X1
X$17300 \$11396 \$3962 \$11398 \$10322 NWELL PWELL BULK MUX2_X1
X$17302 \$10327 \$3962 \$10329 \$10328 NWELL PWELL BULK MUX2_X1
X$17304 \$12950 \$3962 \$12667 \$12953 NWELL PWELL BULK MUX2_X1
X$17306 \$5685 \$3962 \$5028 \$5029 NWELL PWELL BULK MUX2_X1
X$17308 \$4705 \$3962 \$5302 \$4354 NWELL PWELL BULK MUX2_X1
X$17311 \$16214 \$3962 \$15334 \$15716 NWELL PWELL BULK MUX2_X1
X$17314 \$6971 \$3962 \$6399 \$6604 NWELL PWELL BULK MUX2_X1
X$17316 \$7588 \$3962 \$7124 \$7783 NWELL PWELL BULK MUX2_X1
X$17318 \$5008 \$3962 \$5438 \$5010 NWELL PWELL BULK MUX2_X1
X$17320 \$16220 \$3962 \$15870 \$15720 NWELL PWELL BULK MUX2_X1
X$17323 \$4341 \$3962 \$4343 \$4198 NWELL PWELL BULK MUX2_X1
X$17325 \$6756 \$3962 \$6755 \$6594 NWELL PWELL BULK MUX2_X1
X$17327 \$5747 \$3962 \$6046 \$5931 NWELL PWELL BULK MUX2_X1
X$17427 \$4044 \$3964 NWELL PWELL BULK BUF_X16
X$17493 \$3973 \$4398 \$5302 \$5297 NWELL PWELL BULK MUX2_X1
X$17495 \$3973 \$4338 \$4705 \$4702 NWELL PWELL BULK MUX2_X1
X$17498 \$4350 \$4336 \$3973 \$4940 NWELL PWELL BULK MUX2_X1
X$17533 \$11765 \$3997 \$11766 \$11416 NWELL PWELL BULK MUX2_X1
X$17535 \$8645 \$3997 \$8397 \$8320 NWELL PWELL BULK MUX2_X1
X$17537 \$7152 \$3997 \$7618 \$7615 NWELL PWELL BULK MUX2_X1
X$17539 \$9656 \$3997 \$9405 \$9650 NWELL PWELL BULK MUX2_X1
X$17541 \$9742 \$3997 \$9744 \$9407 NWELL PWELL BULK MUX2_X1
X$17544 \$10196 \$3997 \$10029 \$9743 NWELL PWELL BULK MUX2_X1
X$17547 \$9049 \$3997 \$8747 \$9048 NWELL PWELL BULK MUX2_X1
X$17549 \$12542 \$3997 \$12079 \$12077 NWELL PWELL BULK MUX2_X1
X$17552 \$13820 \$3997 \$14048 \$14056 NWELL PWELL BULK MUX2_X1
X$17555 \$11030 \$3997 \$10652 \$11284 NWELL PWELL BULK MUX2_X1
X$17557 \$12083 \$3997 \$11609 \$12563 NWELL PWELL BULK MUX2_X1
X$17559 \$10336 \$3997 \$10656 \$10889 NWELL PWELL BULK MUX2_X1
X$17562 \$9936 \$3997 \$10023 \$10225 NWELL PWELL BULK MUX2_X1
X$17564 \$4969 \$3997 \$4715 \$5367 NWELL PWELL BULK MUX2_X1
X$17567 \$6798 \$3997 \$6800 \$6713 NWELL PWELL BULK MUX2_X1
X$17569 \$5041 \$3997 \$4719 \$5379 NWELL PWELL BULK MUX2_X1
X$17572 \$20097 \$3997 NWELL PWELL BULK BUF_X16
X$17574 \$5786 \$3997 \$5787 \$5980 NWELL PWELL BULK MUX2_X1
X$17577 \$5789 \$3997 \$5704 \$5791 NWELL PWELL BULK MUX2_X1
X$17580 \$17121 \$3997 \$16248 \$16568 NWELL PWELL BULK MUX2_X1
X$17582 \$19481 \$3997 \$19623 \$19396 NWELL PWELL BULK MUX2_X1
X$17585 \$10249 \$3997 \$10021 \$9943 NWELL PWELL BULK MUX2_X1
X$17588 \$10331 \$3997 \$10252 \$9944 NWELL PWELL BULK MUX2_X1
X$17591 \$13823 \$3997 \$13484 \$13825 NWELL PWELL BULK MUX2_X1
X$17593 \$12686 \$3997 \$12962 \$13674 NWELL PWELL BULK MUX2_X1
X$17595 \$14480 \$3997 \$14482 \$14294 NWELL PWELL BULK MUX2_X1
X$17597 \$17072 \$3997 \$15878 \$16585 NWELL PWELL BULK MUX2_X1
X$17600 \$12674 \$3997 \$12532 \$12076 NWELL PWELL BULK MUX2_X1
X$17603 \$13817 \$3997 \$13818 \$13819 NWELL PWELL BULK MUX2_X1
X$17606 \$12527 \$3997 \$13365 \$12071 NWELL PWELL BULK MUX2_X1
X$17608 \$13479 \$3997 \$12681 \$13680 NWELL PWELL BULK MUX2_X1
X$17610 \$12086 \$3997 \$11761 \$10344 NWELL PWELL BULK MUX2_X1
X$17612 \$11758 \$3997 \$11412 \$12080 NWELL PWELL BULK MUX2_X1
X$17615 \$10024 \$3997 \$9740 \$9649 NWELL PWELL BULK MUX2_X1
X$17617 \$10659 \$3997 \$10871 \$10343 NWELL PWELL BULK MUX2_X1
X$17619 \$6072 \$3997 \$6076 \$5781 NWELL PWELL BULK MUX2_X1
X$17621 \$4293 \$3997 \$3998 \$4303 NWELL PWELL BULK MUX2_X1
X$17624 \$12091 \$3997 \$12093 \$12594 NWELL PWELL BULK MUX2_X1
X$17626 \$16672 \$3997 \$16123 \$16231 NWELL PWELL BULK MUX2_X1
X$17628 \$11304 \$3997 \$11026 \$11624 NWELL PWELL BULK MUX2_X1
X$17630 \$19730 \$3997 \$19940 \$19628 NWELL PWELL BULK MUX2_X1
X$17632 \$17975 \$3997 \$17976 \$17226 NWELL PWELL BULK MUX2_X1
X$17634 \$14476 \$3997 \$14478 \$14932 NWELL PWELL BULK MUX2_X1
X$17637 \$14472 \$3997 \$14474 \$14475 NWELL PWELL BULK MUX2_X1
X$17640 \$18783 \$3997 \$18226 \$18224 NWELL PWELL BULK MUX2_X1
X$17642 \$17972 \$3997 \$18677 \$18231 NWELL PWELL BULK MUX2_X1
X$17644 \$17091 \$3997 \$17094 \$17099 NWELL PWELL BULK MUX2_X1
X$17647 \$16096 \$3997 \$15882 \$16246 NWELL PWELL BULK MUX2_X1
X$17649 \$17224 \$3997 \$17227 \$17515 NWELL PWELL BULK MUX2_X1
X$17651 \$17603 \$3997 \$18393 \$17521 NWELL PWELL BULK MUX2_X1
X$17653 \$21224 \$3997 \$21217 \$21222 NWELL PWELL BULK MUX2_X1
X$17710 \$9656 \$3999 \$9396 \$9274 NWELL PWELL BULK MUX2_X1
X$17712 \$13479 \$3999 \$12960 \$13686 NWELL PWELL BULK MUX2_X1
X$17715 \$21428 \$3999 \$20990 \$22070 NWELL PWELL BULK MUX2_X1
X$17718 \$17972 \$3999 \$17970 \$18384 NWELL PWELL BULK MUX2_X1
X$17721 \$10331 \$3999 \$10016 \$10014 NWELL PWELL BULK MUX2_X1
X$17724 \$11304 \$3999 \$11021 \$11630 NWELL PWELL BULK MUX2_X1
X$17727 \$12674 \$3999 \$12072 \$13367 NWELL PWELL BULK MUX2_X1
X$17730 \$13817 \$3999 \$13467 \$14067 NWELL PWELL BULK MUX2_X1
X$17732 \$14472 \$3999 \$14468 \$14470 NWELL PWELL BULK MUX2_X1
X$17735 \$11758 \$3999 \$11280 \$11897 NWELL PWELL BULK MUX2_X1
X$17737 \$3999 \$6072 \$6370 NWELL PWELL BULK NOR2_X1
X$17740 \$3999 \$4969 \$5461 NWELL PWELL BULK NOR2_X1
X$17745 \$6370 \$6070 \$3999 \$6367 NWELL PWELL BULK AOI21_X1
X$17749 \$3999 \$4293 \$4000 NWELL PWELL BULK NOR2_X1
X$17751 \$9936 \$3999 \$9115 \$9941 NWELL PWELL BULK MUX2_X1
X$17753 \$11030 \$3999 \$10338 \$11286 NWELL PWELL BULK MUX2_X1
X$17755 \$17091 \$3999 \$16589 \$17526 NWELL PWELL BULK MUX2_X1
X$17757 \$3999 \$12088 NWELL PWELL BULK BUF_X8
X$17759 \$20993 \$3999 \$20992 \$21430 NWELL PWELL BULK MUX2_X1
X$17803 \$4017 \$5785 NWELL PWELL BULK BUF_X4
X$17806 \$4017 \$11033 NWELL PWELL BULK BUF_X4
X$17810 \$4017 \$6472 NWELL PWELL BULK BUF_X4
X$17813 \$4017 \$12700 NWELL PWELL BULK BUF_X4
X$17816 \$4017 \$13468 NWELL PWELL BULK BUF_X4
X$17819 \$4017 \$8751 NWELL PWELL BULK BUF_X4
X$17822 \$4017 \$9747 NWELL PWELL BULK BUF_X4
X$17825 \$11414 \$4017 NWELL PWELL BULK BUF_X4
X$17827 \$4017 \$4735 NWELL PWELL BULK BUF_X4
X$17831 \$4017 \$5815 NWELL PWELL BULK BUF_X4
X$17886 \$4734 \$4376 \$5336 \$4023 NWELL PWELL BULK MUX2_X1
X$17892 \$I177710 \$4031 \$4026 \$4735 NWELL PWELL BULK DFF_X1
X$17895 \$I175445 \$4032 \$4027 \$4735 NWELL PWELL BULK DFF_X1
X$17919 \$4390 \$4375 \$4275 \$4043 NWELL PWELL BULK MUX2_X1
X$17922 \$4396 \$4044 \$4507 \$4050 NWELL PWELL BULK MUX2_X1
X$17924 \$29585 \$29192 \$4044 \$29203 NWELL PWELL BULK MUX2_X2
X$17926 \$22665 \$4044 \$22334 \$22648 NWELL PWELL BULK MUX2_X1
X$17928 \$31432 \$31441 \$4044 \$31434 NWELL PWELL BULK MUX2_X2
X$17932 \$31447 \$31426 \$4044 \$31440 NWELL PWELL BULK MUX2_X2
X$17937 \$28136 \$4044 \$27493 \$27888 NWELL PWELL BULK MUX2_X1
X$17939 \$29181 \$29933 \$4044 \$29936 NWELL PWELL BULK MUX2_X2
X$17942 \$29213 \$30093 \$4044 \$30101 NWELL PWELL BULK MUX2_X2
X$17944 \$31300 \$4044 \$31306 \$31056 NWELL PWELL BULK MUX2_X1
X$17951 \$28579 \$4044 \$28799 \$28544 NWELL PWELL BULK MUX2_X1
X$17954 \$29845 \$4044 \$29224 \$29795 NWELL PWELL BULK MUX2_X1
X$17956 \$26763 \$4044 \$26761 \$26648 NWELL PWELL BULK MUX2_X1
X$17958 \$30799 \$25950 \$I245579 \$4044 NWELL PWELL BULK DFF_X2
X$17962 \$26129 \$4044 \$25443 \$25501 NWELL PWELL BULK MUX2_X1
X$17997 \$5237 \$4514 \$5089 \$4045 NWELL PWELL BULK MUX2_X1
X$18001 \$4048 \$4514 \$4522 \$4396 NWELL PWELL BULK MUX2_X1
X$18008 \$4399 \$4514 \$4052 \$4507 NWELL PWELL BULK MUX2_X1
X$18017 \$44926 \$4056 NWELL PWELL BULK BUF_X32
X$18019 \$4056 \$5824 \$5516 \$5857 NWELL PWELL BULK AOI21_X1
X$18022 \$4056 \$5513 \$5570 \$5568 NWELL PWELL BULK AOI21_X1
X$18024 \$5873 \$4056 \$6190 NWELL PWELL BULK NOR2_X1
X$18027 \$7339 \$4056 \$7340 NWELL PWELL BULK NOR2_X1
X$18030 \$4056 \$6914 \$6482 \$6915 NWELL PWELL BULK AOI21_X1
X$18033 \$4056 \$5100 \$4764 \$5158 NWELL PWELL BULK AOI21_X1
X$18036 \$7198 \$4056 \$7199 NWELL PWELL BULK NOR2_X1
X$18038 \$4056 \$7301 \$7309 \$6852 NWELL PWELL BULK AOI21_X1
X$18040 \$4056 \$7721 \$7723 \$7321 NWELL PWELL BULK AOI21_X1
X$18042 \$7346 \$4056 \$7359 NWELL PWELL BULK NOR2_X1
X$18045 \$8577 \$4056 \$8899 NWELL PWELL BULK NOR2_X1
X$18048 \$8432 \$4056 \$8545 NWELL PWELL BULK NOR2_X1
X$18051 \$4056 \$8430 \$7969 \$8550 NWELL PWELL BULK AOI21_X1
X$18053 \$8542 \$4056 \$8543 NWELL PWELL BULK NOR2_X1
X$18056 \$4056 \$7208 \$7209 \$7210 NWELL PWELL BULK AOI21_X1
X$18059 \$4056 \$6504 \$6494 \$6874 NWELL PWELL BULK AOI21_X1
X$18062 \$4056 \$6862 \$6511 \$6493 NWELL PWELL BULK AOI21_X1
X$18064 \$4056 \$7222 \$6870 \$7216 NWELL PWELL BULK AOI21_X1
X$18067 \$7260 \$4056 \$7202 NWELL PWELL BULK NOR2_X1
X$18070 \$4056 \$8525 \$7980 \$8843 NWELL PWELL BULK AOI21_X1
X$18073 \$14867 \$4056 \$14273 NWELL PWELL BULK NOR2_X1
X$18076 \$4056 \$14874 \$15176 \$15764 NWELL PWELL BULK AOI21_X1
X$18078 \$4056 \$18923 \$18533 \$18538 NWELL PWELL BULK AOI21_X1
X$18081 \$11452 \$4056 \$11811 NWELL PWELL BULK NOR2_X1
X$18084 \$4056 \$11073 \$11095 \$11072 NWELL PWELL BULK AOI21_X1
X$18086 \$16282 \$4056 \$16988 NWELL PWELL BULK NOR2_X1
X$18088 \$16719 \$17996 \$4056 \$19767 NWELL PWELL BULK NOR3_X1
X$18093 \$19144 \$18425 \$4056 \$20517 \$19749 \$19751 NWELL PWELL BULK
+ AOI221_X1
X$18096 \$4056 \$10053 \$10094 \$10054 NWELL PWELL BULK AOI21_X1
X$18098 \$11829 \$4056 \$11137 NWELL PWELL BULK NOR2_X1
X$18101 \$4056 \$9763 \$9826 \$9824 NWELL PWELL BULK AOI21_X1
X$18103 \$4056 \$10049 \$10051 \$10685 NWELL PWELL BULK AOI21_X1
X$18105 \$10690 \$4056 \$10689 NWELL PWELL BULK NOR2_X1
X$18108 \$4056 \$18808 \$19142 \$19145 \$18966 NWELL PWELL BULK OAI22_X1
X$18110 \$4056 \$12182 \$12153 \$12151 NWELL PWELL BULK AOI21_X1
X$18112 \$4056 \$13857 \$13557 \$13008 NWELL PWELL BULK AOI21_X1
X$18114 \$4056 \$14640 \$14219 \$14554 NWELL PWELL BULK AOI21_X1
X$18116 \$4056 \$13517 \$13895 \$13545 NWELL PWELL BULK AOI21_X1
X$18118 \$4056 \$13533 \$12743 \$13521 NWELL PWELL BULK AOI21_X1
X$18121 \$4056 \$13888 \$12149 \$13859 NWELL PWELL BULK AOI21_X1
X$18123 \$4056 \$12251 \$12284 \$12260 NWELL PWELL BULK AOI21_X1
X$18125 \$4056 \$11155 \$9759 \$10364 NWELL PWELL BULK AOI21_X1
X$18128 \$11172 \$11431 \$4056 \$11862 \$11056 NWELL PWELL BULK NOR4_X2
X$18130 \$8069 \$4056 \$7967 NWELL PWELL BULK NOR2_X1
X$18132 \$4056 \$9142 \$9216 \$9214 NWELL PWELL BULK AOI21_X1
X$18134 \$4056 \$9760 \$9433 \$9834 NWELL PWELL BULK AOI21_X1
X$18136 \$4056 \$9549 \$9554 \$9558 NWELL PWELL BULK AOI21_X1
X$18139 \$4056 \$9190 \$9151 \$9189 NWELL PWELL BULK AOI21_X1
X$18141 \$12981 \$11788 \$4056 \$13321 \$12985 \$13328 NWELL PWELL BULK
+ AOI221_X1
X$18144 \$4056 \$37324 \$36608 \$36949 NWELL PWELL BULK AOI21_X1
X$18147 \$4056 \$42793 \$42213 \$41547 NWELL PWELL BULK AOI21_X1
X$18149 \$26639 \$4056 \$26637 NWELL PWELL BULK NOR2_X1
X$18151 \$25093 \$4056 \$24611 NWELL PWELL BULK NOR2_X1
X$18153 \$4056 \$38216 \$37841 \$37525 NWELL PWELL BULK AOI21_X1
X$18155 \$4056 \$26614 \$25083 \$26018 NWELL PWELL BULK AOI21_X1
X$18158 \$26016 \$4056 \$26015 NWELL PWELL BULK NOR2_X1
X$18161 \$25468 \$4056 \$25467 NWELL PWELL BULK NOR2_X1
X$18164 \$4056 \$30098 \$30097 \$30324 NWELL PWELL BULK AOI21_X1
X$18166 \$4056 \$26629 \$26505 \$25470 NWELL PWELL BULK AOI21_X1
X$18168 \$4056 \$25028 \$25567 \$25031 NWELL PWELL BULK AOI21_X1
X$18170 \$4056 \$37334 \$37143 \$37142 NWELL PWELL BULK AOI21_X1
X$18172 \$4056 \$25099 \$25588 \$25097 NWELL PWELL BULK AOI21_X1
X$18175 \$4056 \$34596 \$35060 \$34499 NWELL PWELL BULK AOI21_X1
X$18177 \$4056 \$32851 \$32568 \$32570 NWELL PWELL BULK AOI21_X1
X$18180 \$33252 \$4056 \$33672 NWELL PWELL BULK NOR2_X1
X$18183 \$4056 \$32847 \$32565 \$32564 NWELL PWELL BULK AOI21_X1
X$18186 \$37836 \$4056 \$37609 NWELL PWELL BULK NOR2_X1
X$18189 \$4056 \$36979 \$36984 \$36130 NWELL PWELL BULK AOI21_X1
X$18191 \$4056 \$41202 \$41411 \$40754 NWELL PWELL BULK AOI21_X1
X$18193 \$4056 \$31050 \$31264 \$31266 NWELL PWELL BULK AOI21_X1
X$18195 \$4056 \$26001 \$26002 \$26500 NWELL PWELL BULK AOI21_X1
X$18197 \$4056 \$29226 \$29364 \$29831 NWELL PWELL BULK AOI21_X1
X$18200 \$29837 \$4056 \$30105 NWELL PWELL BULK NOR2_X1
X$18202 \$4056 \$27905 \$28003 \$27906 NWELL PWELL BULK AOI21_X1
X$18205 \$4056 \$25008 \$25641 \$24686 NWELL PWELL BULK AOI21_X1
X$18207 \$27185 \$4056 \$27142 NWELL PWELL BULK NOR2_X1
X$18209 \$4056 \$30413 \$30403 \$30406 NWELL PWELL BULK AOI21_X1
X$18212 \$4056 \$29235 \$29236 \$29305 NWELL PWELL BULK AOI21_X1
X$18214 \$4056 \$30433 \$30438 \$30447 NWELL PWELL BULK AOI21_X1
X$18216 \$4056 \$31541 \$30107 \$31808 NWELL PWELL BULK AOI21_X1
X$18219 \$4056 \$31175 \$30108 \$30822 NWELL PWELL BULK AOI21_X1
X$18221 \$4056 \$30455 \$30457 \$30340 NWELL PWELL BULK AOI21_X1
X$18223 \$30468 \$4056 \$31221 NWELL PWELL BULK NOR2_X1
X$18225 \$27894 \$4056 \$27501 NWELL PWELL BULK NOR2_X1
X$18227 \$29826 \$4056 \$29755 NWELL PWELL BULK NOR2_X1
X$18229 \$4056 \$31599 \$31058 \$31601 NWELL PWELL BULK AOI21_X1
X$18231 \$41417 \$4056 \$41543 NWELL PWELL BULK NOR2_X1
X$18234 \$4056 \$40547 \$40219 \$41069 NWELL PWELL BULK AOI21_X1
X$18236 \$4056 \$24625 \$25100 \$24546 NWELL PWELL BULK AOI21_X1
X$18238 \$4056 \$24634 \$24245 \$24637 NWELL PWELL BULK AOI21_X1
X$18240 \$26093 \$4056 \$26699 NWELL PWELL BULK NOR2_X1
X$18243 \$4056 \$24590 \$24253 \$24595 NWELL PWELL BULK AOI21_X1
X$18245 \$4056 \$27903 \$28564 \$28011 NWELL PWELL BULK AOI21_X1
X$18248 \$4056 \$40559 \$39987 \$40571 NWELL PWELL BULK AOI21_X1
X$18250 \$4056 \$23437 \$23283 \$23898 NWELL PWELL BULK AOI21_X1
X$18252 \$4056 \$23823 \$23428 \$23287 NWELL PWELL BULK AOI21_X1
X$18254 \$4056 \$21891 \$22548 \$21460 NWELL PWELL BULK AOI21_X1
X$18256 \$4056 \$23272 \$23021 \$23273 NWELL PWELL BULK AOI21_X1
X$18258 \$4056 \$24539 \$24540 \$24673 NWELL PWELL BULK AOI21_X1
X$18261 \$4056 \$24650 \$25017 \$24543 NWELL PWELL BULK AOI21_X1
X$18264 \$25993 \$4056 \$26493 NWELL PWELL BULK NOR2_X1
X$18266 \$21538 \$4056 \$22590 NWELL PWELL BULK NOR2_X1
X$18269 \$4056 \$22615 \$22621 \$21884 NWELL PWELL BULK AOI21_X1
X$18271 \$4056 \$26087 \$26088 \$26501 NWELL PWELL BULK AOI21_X1
X$18273 \$4056 \$25023 \$25021 \$25020 NWELL PWELL BULK AOI21_X1
X$18275 \$4056 \$23280 \$22951 \$23451 NWELL PWELL BULK AOI21_X1
X$18277 \$4056 \$23278 \$22950 \$23467 NWELL PWELL BULK AOI21_X1
X$18279 \$4056 \$33489 \$33659 \$33125 NWELL PWELL BULK AOI21_X1
X$18281 \$4056 \$28808 \$29241 \$29764 NWELL PWELL BULK AOI21_X1
X$18283 \$40038 \$4056 \$41763 NWELL PWELL BULK NOR2_X1
X$18286 \$4056 \$28024 \$27901 \$28030 NWELL PWELL BULK AOI21_X1
X$18289 \$30513 \$4056 \$30810 NWELL PWELL BULK NOR2_X1
X$18291 \$28041 \$4056 \$27144 NWELL PWELL BULK NOR2_X1
X$18294 \$4056 \$31283 \$31044 \$31608 NWELL PWELL BULK AOI21_X1
X$18296 \$4056 \$31957 \$31796 \$31532 NWELL PWELL BULK AOI21_X1
X$18298 \$4056 \$39349 \$39350 \$39978 NWELL PWELL BULK AOI21_X1
X$18300 \$4056 \$39041 \$37529 \$38856 NWELL PWELL BULK AOI21_X1
X$18302 \$41202 \$41909 \$4056 \$41735 NWELL PWELL BULK NOR3_X1
X$18304 \$31070 \$4056 \$30825 NWELL PWELL BULK NOR2_X1
X$18459 \$7695 \$7652 \$4057 NWELL PWELL BULK NOR2_X1
X$18470 \$4067 \$4419 \$4420 \$5523 NWELL PWELL BULK DFF_X1
X$18526 \$4390 \$4514 \$4391 \$4132 NWELL PWELL BULK MUX2_X1
X$18589 \$4377 \$4376 \$4378 \$4206 NWELL PWELL BULK MUX2_X1
X$18596 \$4377 \$4375 \$4213 \$4211 NWELL PWELL BULK MUX2_X1
X$18604 \$4213 \$4398 \$5336 \$5653 NWELL PWELL BULK MUX2_X1
X$18607 \$4213 \$4338 \$4734 \$5490 NWELL PWELL BULK MUX2_X1
X$18651 \$4275 \$4338 \$5237 \$5500 NWELL PWELL BULK MUX2_X1
X$18654 \$4275 \$4398 \$5089 \$5235 NWELL PWELL BULK MUX2_X1
X$18657 \$4391 \$4537 \$4275 \$4834 NWELL PWELL BULK MUX2_X1
X$18702 \$12262 \$9693 \$12799 \$4312 NWELL PWELL BULK MUX2_X1
X$18736 \$4964 \$4336 \$4357 \$4959 NWELL PWELL BULK MUX2_X1
X$18739 \$9395 \$4336 \$8734 \$9394 NWELL PWELL BULK MUX2_X1
X$18741 \$6053 \$4336 \$5757 \$6262 NWELL PWELL BULK MUX2_X1
X$18745 \$10320 \$4336 \$10637 \$11327 NWELL PWELL BULK MUX2_X1
X$18747 \$4336 \$12955 NWELL PWELL BULK BUF_X8
X$18750 \$4375 \$4336 NWELL PWELL BULK BUF_X8
X$18753 \$10642 \$4336 \$10646 \$11016 NWELL PWELL BULK MUX2_X1
X$18755 \$13338 \$4336 \$12063 \$13337 NWELL PWELL BULK MUX2_X1
X$18757 \$4346 \$4336 \$4348 \$4572 NWELL PWELL BULK MUX2_X1
X$18759 \$10327 \$4336 \$10557 \$10325 NWELL PWELL BULK MUX2_X1
X$18761 \$6756 \$4336 \$6758 \$6968 NWELL PWELL BULK MUX2_X1
X$18763 \$5747 \$4336 \$5748 \$5920 NWELL PWELL BULK MUX2_X1
X$18765 \$7119 \$4336 \$7123 \$7765 NWELL PWELL BULK MUX2_X1
X$18767 \$5008 \$4336 \$4680 \$5222 NWELL PWELL BULK MUX2_X1
X$18770 \$8372 \$4336 \$8730 \$8729 NWELL PWELL BULK MUX2_X1
X$18792 \$14163 \$4338 \$13811 \$13810 NWELL PWELL BULK MUX2_X1
X$18794 \$26487 \$4338 \$25992 \$26112 NWELL PWELL BULK MUX2_X1
X$18797 \$21436 \$4338 \$21996 \$22000 NWELL PWELL BULK MUX2_X1
X$18799 \$12062 \$4338 \$12479 \$12846 NWELL PWELL BULK MUX2_X1
X$18802 \$27101 \$4338 \$30076 \$30289 NWELL PWELL BULK MUX2_X1
X$18805 \$27450 \$4338 \$30712 \$30295 NWELL PWELL BULK MUX2_X1
X$18808 \$25439 \$4338 \$25665 \$25141 NWELL PWELL BULK MUX2_X1
X$18812 \$8330 \$4338 \$8755 \$9006 NWELL PWELL BULK MUX2_X1
X$18814 \$27137 \$4338 \$27196 \$28140 NWELL PWELL BULK MUX2_X1
X$18818 \$4680 \$4338 \$5243 \$5239 NWELL PWELL BULK MUX2_X1
X$18820 \$4357 \$4338 \$5685 \$6011 NWELL PWELL BULK MUX2_X1
X$18822 \$23239 \$4338 \$23256 \$24006 NWELL PWELL BULK MUX2_X1
X$18824 \$28783 \$4338 \$29748 \$29747 NWELL PWELL BULK MUX2_X1
X$18828 \$16218 \$4338 \$15343 \$16107 NWELL PWELL BULK MUX2_X1
X$18830 \$27862 \$4338 \$30092 \$29871 NWELL PWELL BULK MUX2_X1
X$18833 \$17595 \$4338 \$17596 \$17838 NWELL PWELL BULK MUX2_X1
X$18835 \$9121 \$4338 \$9576 \$9584 NWELL PWELL BULK MUX2_X1
X$18837 \$14313 \$4338 \$15337 \$16126 NWELL PWELL BULK MUX2_X1
X$18840 \$8741 \$4338 \$8742 \$9111 NWELL PWELL BULK MUX2_X1
X$18842 \$8734 \$4338 \$8738 \$8375 NWELL PWELL BULK MUX2_X1
X$18845 \$6439 \$4338 \$6095 \$6292 NWELL PWELL BULK MUX2_X1
X$18847 \$6802 \$4338 \$6803 \$7062 NWELL PWELL BULK MUX2_X1
X$18849 \$7606 \$4338 \$7907 \$7819 NWELL PWELL BULK MUX2_X1
X$18851 \$29940 \$30081 \$4338 NWELL PWELL BULK NAND2_X4
X$18853 \$14464 \$4338 \$15740 \$15742 NWELL PWELL BULK MUX2_X1
X$18856 \$10646 \$4338 \$11403 \$11910 NWELL PWELL BULK MUX2_X1
X$18858 \$12957 \$4338 \$13814 \$14460 NWELL PWELL BULK MUX2_X1
X$18860 \$12063 \$4338 \$12070 \$13349 NWELL PWELL BULK MUX2_X1
X$18862 \$10350 \$4338 \$11196 \$11197 NWELL PWELL BULK MUX2_X1
X$18864 \$17826 \$4338 \$17969 \$17967 NWELL PWELL BULK MUX2_X1
X$18867 \$4338 \$7947 \$7946 NWELL PWELL BULK NAND2_X1
X$18872 \$5230 \$4338 \$5214 \$5508 NWELL PWELL BULK MUX2_X1
X$18875 \$10637 \$4338 \$11396 \$11663 NWELL PWELL BULK MUX2_X1
X$18879 \$4348 \$4338 \$5282 \$5024 NWELL PWELL BULK MUX2_X1
X$18881 \$27595 \$4338 \$29223 \$29222 NWELL PWELL BULK MUX2_X1
X$18884 \$26825 \$4338 \$28797 \$28884 NWELL PWELL BULK MUX2_X1
X$18886 \$5757 \$4338 \$5756 \$5961 NWELL PWELL BULK MUX2_X1
X$18888 \$28371 \$4338 \$29187 \$29186 NWELL PWELL BULK MUX2_X1
X$18890 \$10557 \$4338 \$11344 \$11655 NWELL PWELL BULK MUX2_X1
X$18893 \$6758 \$4338 \$6971 \$6760 NWELL PWELL BULK MUX2_X1
X$18895 \$7123 \$4338 \$7588 \$7587 NWELL PWELL BULK MUX2_X1
X$18897 \$28776 \$4338 \$28939 \$28781 NWELL PWELL BULK MUX2_X1
X$18900 \$15865 \$4338 \$16220 \$17042 NWELL PWELL BULK MUX2_X1
X$18903 \$19463 \$4338 \$19465 \$19650 NWELL PWELL BULK MUX2_X1
X$18905 \$5748 \$4338 \$5933 \$5930 NWELL PWELL BULK MUX2_X1
X$18907 \$8730 \$4338 \$9331 \$9648 NWELL PWELL BULK MUX2_X1
X$18995 \$I178109 \$4346 \$4572 \$4693 NWELL PWELL BULK DFF_X1
X$19006 \$4348 \$4398 \$5284 \$5278 NWELL PWELL BULK MUX2_X1
X$19014 \$I178064 \$4350 \$4940 \$4693 NWELL PWELL BULK DFF_X1
X$19023 \$4357 \$4398 \$5028 \$5449 NWELL PWELL BULK MUX2_X1
X$19043 \$26489 \$4375 \$26487 \$26795 NWELL PWELL BULK MUX2_X1
X$19045 \$27885 \$4375 \$27137 \$28175 NWELL PWELL BULK MUX2_X1
X$19048 \$8403 \$4375 \$8330 \$8633 NWELL PWELL BULK MUX2_X1
X$19051 \$6816 \$4375 \$6439 \$7012 NWELL PWELL BULK MUX2_X1
X$19054 \$27881 \$4375 \$26825 \$28888 NWELL PWELL BULK MUX2_X1
X$19056 \$8265 \$4375 \$6802 \$7910 NWELL PWELL BULK MUX2_X1
X$19060 \$10147 \$4375 \$10350 \$10459 NWELL PWELL BULK MUX2_X1
X$19062 \$9023 \$4375 \$8741 \$8647 NWELL PWELL BULK MUX2_X1
X$19064 \$7905 \$4375 \$7606 \$8232 NWELL PWELL BULK MUX2_X1
X$19069 \$5505 \$4375 \$5230 \$5502 NWELL PWELL BULK MUX2_X1
X$19071 \$7944 \$4375 \$8209 NWELL PWELL BULK OR2_X1
X$19073 \$9418 \$4375 \$9121 \$9420 NWELL PWELL BULK MUX2_X1
X$19078 \$30319 \$4375 \$28783 \$30808 NWELL PWELL BULK MUX2_X1
X$19080 \$27875 \$4375 \$27862 \$28582 NWELL PWELL BULK MUX2_X1
X$19083 \$29219 \$4375 \$27595 \$29402 NWELL PWELL BULK MUX2_X1
X$19085 \$22330 \$4375 \$21436 \$21879 NWELL PWELL BULK MUX2_X1
X$19088 \$25002 \$4375 \$25439 \$25675 NWELL PWELL BULK MUX2_X1
X$19121 \$20094 \$4376 \$20828 \$20521 NWELL PWELL BULK MUX2_X1
X$19124 \$30076 \$4376 \$31031 \$31441 NWELL PWELL BULK MUX2_X1
X$19127 \$30074 \$4376 \$31029 \$31432 NWELL PWELL BULK MUX2_X1
X$19130 \$28939 \$4376 \$29590 \$29192 NWELL PWELL BULK MUX2_X1
X$19133 \$30712 \$4376 \$30792 \$31426 NWELL PWELL BULK MUX2_X1
X$19136 \$30790 \$4376 \$31448 \$31447 NWELL PWELL BULK MUX2_X1
X$19141 \$29179 \$4376 \$29180 \$29181 NWELL PWELL BULK MUX2_X1
X$19144 \$29187 \$4376 \$28774 \$29933 NWELL PWELL BULK MUX2_X1
X$19147 \$9023 \$4376 \$9110 \$9295 NWELL PWELL BULK MUX2_X1
X$19150 \$6095 \$4376 \$6995 \$6699 NWELL PWELL BULK MUX2_X1
X$19152 \$19465 \$4376 \$19467 \$19646 NWELL PWELL BULK MUX2_X1
X$19154 \$13814 \$4376 \$13355 \$13815 NWELL PWELL BULK MUX2_X1
X$19156 \$13469 \$4376 \$12956 \$13359 NWELL PWELL BULK MUX2_X1
X$19159 \$14462 \$4376 \$14463 \$14465 NWELL PWELL BULK MUX2_X1
X$19161 \$8742 \$4376 \$8743 \$9113 NWELL PWELL BULK MUX2_X1
X$19164 \$8265 \$4376 \$7611 \$7483 NWELL PWELL BULK MUX2_X1
X$19166 \$6816 \$4376 \$6817 \$6441 NWELL PWELL BULK MUX2_X1
X$19169 \$8755 \$4376 \$8756 \$7621 NWELL PWELL BULK MUX2_X1
X$19171 \$8403 \$4376 \$7620 \$8402 NWELL PWELL BULK MUX2_X1
X$19173 \$6803 \$4376 \$7475 \$7481 NWELL PWELL BULK MUX2_X1
X$19175 \$17596 \$4376 \$17962 \$18252 NWELL PWELL BULK MUX2_X1
X$19177 \$17594 \$4376 \$18263 \$17961 NWELL PWELL BULK MUX2_X1
X$19180 \$11403 \$4376 \$11404 \$11639 NWELL PWELL BULK MUX2_X1
X$19182 \$10642 \$4376 \$10645 \$10643 NWELL PWELL BULK MUX2_X1
X$19184 \$15740 \$4376 \$15209 \$14467 NWELL PWELL BULK MUX2_X1
X$19186 \$17965 \$4376 \$17598 \$17828 NWELL PWELL BULK MUX2_X1
X$19188 \$17969 \$4376 \$17533 \$18238 NWELL PWELL BULK MUX2_X1
X$19190 \$16237 \$4376 \$16677 \$15881 NWELL PWELL BULK MUX2_X1
X$19192 \$15343 \$4376 \$15344 \$15345 NWELL PWELL BULK MUX2_X1
X$19195 \$4514 \$4376 NWELL PWELL BULK BUF_X16
X$19234 \$28951 \$4376 \$28779 \$29585 NWELL PWELL BULK MUX2_X1
X$19284 \$5230 \$4398 \$5817 \$5888 NWELL PWELL BULK MUX2_X1
X$19287 \$26487 \$4398 \$26492 \$26774 NWELL PWELL BULK MUX2_X1
X$19289 \$14163 \$4398 \$14165 \$14873 NWELL PWELL BULK MUX2_X1
X$19291 \$29940 \$30290 \$4398 NWELL PWELL BULK NAND2_X4
X$19294 \$15865 \$4398 \$15870 \$16559 NWELL PWELL BULK MUX2_X1
X$19296 \$28776 \$4398 \$29590 \$29918 NWELL PWELL BULK MUX2_X1
X$19299 \$21436 \$4398 \$22332 \$22670 NWELL PWELL BULK MUX2_X1
X$19302 \$27450 \$4398 \$30792 \$31032 NWELL PWELL BULK MUX2_X1
X$19304 \$27137 \$4398 \$27139 \$27494 NWELL PWELL BULK MUX2_X1
X$19309 \$27595 \$4398 \$28866 \$28802 NWELL PWELL BULK MUX2_X1
X$19311 \$8330 \$4398 \$8756 \$9266 NWELL PWELL BULK MUX2_X1
X$19315 \$5748 \$4398 \$5749 \$5944 NWELL PWELL BULK MUX2_X1
X$19318 \$7123 \$4398 \$7124 \$7337 NWELL PWELL BULK MUX2_X1
X$19320 \$7606 \$4398 \$7607 \$8255 NWELL PWELL BULK MUX2_X1
X$19324 \$6802 \$4398 \$7475 \$6804 NWELL PWELL BULK MUX2_X1
X$19327 \$28783 \$4398 \$29216 \$29858 NWELL PWELL BULK MUX2_X1
X$19330 \$26825 \$4398 \$27884 \$27883 NWELL PWELL BULK MUX2_X1
X$19332 \$6439 \$4398 \$6995 \$6818 NWELL PWELL BULK MUX2_X1
X$19339 \$27862 \$4398 \$29866 \$29212 NWELL PWELL BULK MUX2_X1
X$19342 \$8741 \$4398 \$8743 \$9676 NWELL PWELL BULK MUX2_X1
X$19344 \$16218 \$4398 \$15344 \$16590 NWELL PWELL BULK MUX2_X1
X$19346 \$10557 \$4398 \$10933 \$11015 NWELL PWELL BULK MUX2_X1
X$19348 \$12063 \$4398 \$12501 \$12502 NWELL PWELL BULK MUX2_X1
X$19351 \$10646 \$4398 \$11404 \$12520 NWELL PWELL BULK MUX2_X1
X$19353 \$9121 \$4398 \$9755 \$9852 NWELL PWELL BULK MUX2_X1
X$19356 \$14313 \$4398 \$14458 \$15222 NWELL PWELL BULK MUX2_X1
X$19358 \$8734 \$4398 \$9106 \$9666 NWELL PWELL BULK MUX2_X1
X$19363 \$27101 \$4398 \$31031 \$31634 NWELL PWELL BULK MUX2_X1
X$19365 \$14464 \$4398 \$15209 \$15749 NWELL PWELL BULK MUX2_X1
X$19367 \$17826 \$4398 \$17533 \$17968 NWELL PWELL BULK MUX2_X1
X$19369 \$17595 \$4398 \$17962 \$18713 NWELL PWELL BULK MUX2_X1
X$19372 \$12957 \$4398 \$13355 \$13471 NWELL PWELL BULK MUX2_X1
X$19375 \$10350 \$4398 \$10138 \$10037 NWELL PWELL BULK MUX2_X1
X$19379 \$4398 \$8418 \$8770 NWELL PWELL BULK NAND2_X1
X$19382 \$12062 \$4398 \$12954 \$13807 NWELL PWELL BULK MUX2_X1
X$19384 \$5757 \$4398 \$6057 \$6287 NWELL PWELL BULK MUX2_X1
X$19386 \$28371 \$4398 \$28774 \$29641 NWELL PWELL BULK MUX2_X1
X$19389 \$10637 \$4398 \$11398 \$12482 NWELL PWELL BULK MUX2_X1
X$19393 \$6758 \$4398 \$6399 \$6982 NWELL PWELL BULK MUX2_X1
X$19395 \$4680 \$4398 \$4684 \$5013 NWELL PWELL BULK MUX2_X1
X$19397 \$19463 \$4398 \$19467 \$19721 NWELL PWELL BULK MUX2_X1
X$19399 \$23239 \$4398 \$23800 \$24003 NWELL PWELL BULK MUX2_X1
X$19402 \$25439 \$4398 \$25004 \$25986 NWELL PWELL BULK MUX2_X1
X$19404 \$8730 \$4398 \$9099 \$9100 NWELL PWELL BULK MUX2_X1
X$19522 \$4760 \$4761 \$4407 NWELL PWELL BULK NAND2_X1
X$19535 \$4418 \$5523 NWELL PWELL BULK BUF_X4
X$19540 \$4418 \$16316 NWELL PWELL BULK BUF_X4
X$19543 \$4418 \$7214 NWELL PWELL BULK BUF_X4
X$19545 \$11414 \$4418 NWELL PWELL BULK BUF_X4
X$19548 \$4418 \$10373 NWELL PWELL BULK BUF_X4
X$19551 \$4418 \$10681 NWELL PWELL BULK BUF_X4
X$19553 \$4418 \$21032 NWELL PWELL BULK BUF_X4
X$19557 \$4418 \$16716 NWELL PWELL BULK BUF_X4
X$19560 \$4418 \$21461 NWELL PWELL BULK BUF_X4
X$19630 \$5098 \$4765 \$4460 NWELL PWELL BULK NAND2_X1
X$19687 \$22330 \$4514 \$22331 \$22665 NWELL PWELL BULK MUX2_X1
X$19690 \$25665 \$4514 \$25004 \$25443 NWELL PWELL BULK MUX2_X1
X$19692 \$5214 \$4514 \$5817 \$5213 NWELL PWELL BULK MUX2_X1
X$19695 \$21996 \$4514 \$22332 \$22334 NWELL PWELL BULK MUX2_X1
X$19697 \$27196 \$4514 \$27139 \$27493 NWELL PWELL BULK MUX2_X1
X$19700 \$28797 \$4514 \$27884 \$28799 NWELL PWELL BULK MUX2_X1
X$19703 \$27881 \$4514 \$27882 \$28579 NWELL PWELL BULK MUX2_X1
X$19706 \$30319 \$4514 \$31301 \$31300 NWELL PWELL BULK MUX2_X1
X$19708 \$5505 \$4514 \$5506 \$5585 NWELL PWELL BULK MUX2_X1
X$19710 \$10147 \$4514 \$10036 \$10144 NWELL PWELL BULK MUX2_X1
X$19712 \$11196 \$4514 \$10138 \$10673 NWELL PWELL BULK MUX2_X1
X$19714 \$7949 \$4514 \$8420 \$8586 NWELL PWELL BULK MUX2_X1
X$19718 \$9576 \$4514 \$9755 \$9854 NWELL PWELL BULK MUX2_X1
X$19720 \$9418 \$4514 \$9423 \$9857 NWELL PWELL BULK MUX2_X1
X$19722 \$6842 \$4514 \$7389 \$7177 NWELL PWELL BULK MUX2_X1
X$19725 \$7944 \$4514 \$8905 \$8416 NWELL PWELL BULK MUX2_X1
X$19727 \$6463 \$4514 \$6111 \$6617 NWELL PWELL BULK MUX2_X1
X$19733 \$30311 \$31789 \$I245605 \$4514 NWELL PWELL BULK DFF_X2
X$19737 \$27875 \$4514 \$27876 \$29213 NWELL PWELL BULK MUX2_X1
X$19740 \$29219 \$4514 \$29392 \$29845 NWELL PWELL BULK MUX2_X1
X$19742 \$30092 \$4514 \$29866 \$30093 NWELL PWELL BULK MUX2_X1
X$19745 \$27885 \$4514 \$27886 \$28136 NWELL PWELL BULK MUX2_X1
X$19747 \$29223 \$4514 \$28866 \$29224 NWELL PWELL BULK MUX2_X1
X$19750 \$25992 \$4514 \$26492 \$26761 NWELL PWELL BULK MUX2_X1
X$19752 \$29748 \$4514 \$29216 \$31306 NWELL PWELL BULK MUX2_X1
X$19755 \$26489 \$4514 \$26119 \$26763 NWELL PWELL BULK MUX2_X1
X$19757 \$25002 \$4514 \$25985 \$26129 NWELL PWELL BULK MUX2_X1
X$19759 \$23256 \$4514 \$23800 \$22930 NWELL PWELL BULK MUX2_X1
X$19762 \$22929 \$4514 \$23657 \$23253 NWELL PWELL BULK MUX2_X1
X$19831 \$27882 \$4537 \$26825 \$28210 NWELL PWELL BULK MUX2_X1
X$19833 \$9423 \$4537 \$9121 \$9421 NWELL PWELL BULK MUX2_X1
X$19835 \$10036 \$4537 \$10350 \$11203 NWELL PWELL BULK MUX2_X1
X$19839 \$5506 \$4537 \$5230 \$5618 NWELL PWELL BULK MUX2_X1
X$19841 \$8905 \$4537 \$8914 NWELL PWELL BULK OR2_X1
X$19847 \$28779 \$4537 \$28776 \$29625 NWELL PWELL BULK MUX2_X1
X$19849 \$29392 \$4537 \$27595 \$29220 NWELL PWELL BULK MUX2_X1
X$19851 \$31301 \$4537 \$28783 \$31313 NWELL PWELL BULK MUX2_X1
X$19853 \$29180 \$4537 \$28371 \$29649 NWELL PWELL BULK MUX2_X1
X$19855 \$4537 \$8980 NWELL PWELL BULK BUF_X8
X$19857 \$27886 \$4537 \$27137 \$27490 NWELL PWELL BULK MUX2_X1
X$19859 \$22331 \$4537 \$21436 \$21881 NWELL PWELL BULK MUX2_X1
X$19862 \$26119 \$4537 \$26487 \$26122 NWELL PWELL BULK MUX2_X1
X$19864 \$25985 \$4537 \$25439 \$25984 NWELL PWELL BULK MUX2_X1
X$19866 \$23657 \$4537 \$23239 \$24019 NWELL PWELL BULK MUX2_X1
X$19900 \$27876 \$4537 \$27862 \$28889 NWELL PWELL BULK MUX2_X1
X$19909 \$I174306 \$4695 \$4569 \$4693 NWELL PWELL BULK DFF_X1
X$19995 \$I174850 \$5282 \$5024 \$4693 NWELL PWELL BULK DFF_X1
X$19999 \$I174853 \$5284 \$5278 \$4693 NWELL PWELL BULK DFF_X1
X$20002 \$5019 \$5273 \$5271 \$4693 NWELL PWELL BULK DFF_X1
X$20005 \$I175663 \$7878 \$7590 \$4693 NWELL PWELL BULK DFF_X1
X$20007 \$I177889 \$9075 \$9254 \$4693 NWELL PWELL BULK DFF_X1
X$20009 \$I177875 \$7877 \$8142 \$4693 NWELL PWELL BULK DFF_X1
X$20012 \$I175687 \$8583 \$8712 \$4693 NWELL PWELL BULK DFF_X1
X$20014 \$7018 \$6767 \$7005 \$4693 NWELL PWELL BULK DFF_X1
X$20016 \$I177792 \$7593 \$7133 \$4693 NWELL PWELL BULK DFF_X1
X$20019 \$6645 \$6643 \$6290 \$4693 NWELL PWELL BULK DFF_X1
X$20023 \$I178073 \$6057 \$6287 \$4693 NWELL PWELL BULK DFF_X1
X$20025 \$I177813 \$7131 \$7360 \$4693 NWELL PWELL BULK DFF_X1
X$20028 \$I177818 \$6054 \$6628 \$4693 NWELL PWELL BULK DFF_X1
X$20030 \$6401 \$6991 \$6989 \$4693 NWELL PWELL BULK DFF_X1
X$20033 \$I175641 \$7591 \$7805 \$4693 NWELL PWELL BULK DFF_X1
X$20038 \$6258 \$5753 \$5947 \$4693 NWELL PWELL BULK DFF_X1
X$20041 \$I178232 \$6053 \$6262 \$4693 NWELL PWELL BULK DFF_X1
X$20043 \$I176287 \$5756 \$5961 \$4693 NWELL PWELL BULK DFF_X1
X$20045 \$I177811 \$7353 \$7129 \$4693 NWELL PWELL BULK DFF_X1
X$20047 \$I177041 \$7124 \$7337 \$4693 NWELL PWELL BULK DFF_X1
X$20049 \$I177871 \$6399 \$6982 \$4693 NWELL PWELL BULK DFF_X1
X$20052 \$I175446 \$6971 \$6760 \$4693 NWELL PWELL BULK DFF_X1
X$20055 \$I177006 \$7588 \$7587 \$4693 NWELL PWELL BULK DFF_X1
X$20058 \$I175370 \$5749 \$5944 \$4693 NWELL PWELL BULK DFF_X1
X$20061 \$I177205 \$5933 \$5930 \$4693 NWELL PWELL BULK DFF_X1
X$20063 \$6051 \$6050 \$6248 \$4693 NWELL PWELL BULK DFF_X1
X$20065 \$I177003 \$8363 \$8572 \$4693 NWELL PWELL BULK DFF_X1
X$20148 \$I178887 \$6817 \$7153 \$4735 NWELL PWELL BULK DFF_X1
X$20150 \$I176129 \$6823 \$6821 \$4735 NWELL PWELL BULK DFF_X1
X$20152 \$I178486 \$6995 \$6818 \$4735 NWELL PWELL BULK DFF_X1
X$20155 \$I176534 \$6446 \$6097 \$4735 NWELL PWELL BULK DFF_X1
X$20157 \$I174951 \$5071 \$5487 \$4735 NWELL PWELL BULK DFF_X1
X$20159 \$I178883 \$7620 \$8325 \$4735 NWELL PWELL BULK DFF_X1
X$20162 \$I174510 \$7618 \$7923 \$4735 NWELL PWELL BULK DFF_X1
X$20164 \$I177719 \$8756 \$9266 \$4735 NWELL PWELL BULK DFF_X1
X$20166 \$I174487 \$8755 \$9006 \$4735 NWELL PWELL BULK DFF_X1
X$20168 \$I176450 \$9744 \$9410 \$4735 NWELL PWELL BULK DFF_X1
X$20170 \$I178035 \$7758 \$7628 \$4735 NWELL PWELL BULK DFF_X1
X$20172 \$I178171 \$7163 \$7486 \$4735 NWELL PWELL BULK DFF_X1
X$20174 \$I178163 \$7502 \$6969 \$4735 NWELL PWELL BULK DFF_X1
X$20176 \$I178144 \$8757 \$8977 \$4735 NWELL PWELL BULK DFF_X1
X$20178 \$I175896 \$8311 \$7926 \$4735 NWELL PWELL BULK DFF_X1
X$20181 \$I176220 \$8403 \$8633 \$4735 NWELL PWELL BULK DFF_X1
X$20184 \$I178075 \$5808 \$5805 \$4735 NWELL PWELL BULK DFF_X1
X$20187 \$I178447 \$5497 \$5929 \$4735 NWELL PWELL BULK DFF_X1
X$20189 \$I178025 \$6453 \$6278 \$4735 NWELL PWELL BULK DFF_X1
X$20192 \$I178169 \$6827 \$7532 \$4735 NWELL PWELL BULK DFF_X1
X$20194 \$I175975 \$5801 \$5798 \$4735 NWELL PWELL BULK DFF_X1
X$20197 \$I178308 \$7157 \$7552 \$4735 NWELL PWELL BULK DFF_X1
X$20199 \$I178053 \$6455 \$6978 \$4735 NWELL PWELL BULK DFF_X1
X$20201 \$I178450 \$5336 \$5653 \$4735 NWELL PWELL BULK DFF_X1
X$20203 \$I178164 \$6105 \$5951 \$4735 NWELL PWELL BULK DFF_X1
X$20206 \$I175944 \$6460 \$6651 \$4735 NWELL PWELL BULK DFF_X1
X$20209 \$I175375 \$4736 \$5646 \$4735 NWELL PWELL BULK DFF_X1
X$20212 \$I178407 \$5075 \$5323 \$4735 NWELL PWELL BULK DFF_X1
X$20273 \$5098 \$4760 NWELL PWELL BULK INV_X4
X$20275 \$4760 \$5563 \$5822 NWELL PWELL BULK NAND2_X1
X$20278 \$4760 \$5099 \$5516 NWELL PWELL BULK NAND2_X1
X$20281 \$4760 \$7191 \$I241124 \$7187 NWELL PWELL BULK HA_X1
X$20283 \$4760 \$6120 \$6482 NWELL PWELL BULK NAND2_X1
X$20287 \$4760 \$5163 \$5570 NWELL PWELL BULK NAND2_X1
X$20290 \$4760 \$4765 \$4764 NWELL PWELL BULK NAND2_X1
X$20310 \$4765 \$5099 \$5163 \$5563 NWELL PWELL BULK HA_X1
X$20323 \$4777 \$18013 NWELL PWELL BULK INV_X1
X$20326 \$16856 \$16313 \$4777 \$15926 \$17333 \$16747 NWELL PWELL BULK
+ OAI221_X2
X$20328 \$16856 \$15941 \$4777 \$16297 \$16411 \$9767 NWELL PWELL BULK OAI221_X2
X$20345 \$5098 \$4791 \$5100 NWELL PWELL BULK NAND2_X1
X$20355 \$4791 \$7702 \$7957 NWELL PWELL BULK XNOR2_X2
X$20377 \$5006 \$4836 \$4833 \$5004 NWELL PWELL BULK DFF_X1
X$20537 \$I177427 \$9849 \$9844 \$5004 NWELL PWELL BULK DFF_X1
X$20539 \$5917 \$5743 \$5913 \$5004 NWELL PWELL BULK DFF_X1
X$20541 \$5744 \$6225 \$6221 \$5004 NWELL PWELL BULK DFF_X1
X$20544 \$I175385 \$7113 \$7284 \$5004 NWELL PWELL BULK DFF_X1
X$20546 \$6951 \$6935 \$6940 \$5004 NWELL PWELL BULK DFF_X1
X$20549 \$6581 \$6937 \$6580 \$5004 NWELL PWELL BULK DFF_X1
X$20551 \$I175464 \$8092 \$8088 \$5004 NWELL PWELL BULK DFF_X1
X$20554 \$I176185 \$7868 \$8099 \$5004 NWELL PWELL BULK DFF_X1
X$20557 \$7300 \$6946 \$6948 \$5004 NWELL PWELL BULK DFF_X1
X$20560 \$I177182 \$7578 \$7751 \$5004 NWELL PWELL BULK DFF_X1
X$20563 \$I175386 \$8076 \$7865 \$5004 NWELL PWELL BULK DFF_X1
X$20565 \$6585 \$6206 \$5904 \$5004 NWELL PWELL BULK DFF_X1
X$20568 \$6392 \$6576 \$6577 \$5004 NWELL PWELL BULK DFF_X1
X$20570 \$I177068 \$9061 \$9203 \$5004 NWELL PWELL BULK DFF_X1
X$20573 \$I174387 \$9356 \$9516 \$5004 NWELL PWELL BULK DFF_X1
X$20575 \$I177176 \$7110 \$7108 \$5004 NWELL PWELL BULK DFF_X1
X$20578 \$6570 \$6566 \$6042 \$5004 NWELL PWELL BULK DFF_X1
X$20581 \$I177191 \$7863 \$8063 \$5004 NWELL PWELL BULK DFF_X1
X$20583 \$I177190 \$7864 \$8521 \$5004 NWELL PWELL BULK DFF_X1
X$20586 \$6191 \$5885 \$5734 \$5004 NWELL PWELL BULK DFF_X1
X$20588 \$I177120 \$8846 \$9210 \$5004 NWELL PWELL BULK DFF_X1
X$20590 \$5737 \$5739 \$5896 \$5004 NWELL PWELL BULK DFF_X1
X$20592 \$I176576 \$6745 \$7269 \$5004 NWELL PWELL BULK DFF_X1
X$20594 \$I175498 \$8526 \$8857 \$5004 NWELL PWELL BULK DFF_X1
X$20597 \$I177175 \$7106 \$7264 \$5004 NWELL PWELL BULK DFF_X1
X$20600 \$I174492 \$9360 \$9361 \$5004 NWELL PWELL BULK DFF_X1
X$20603 \$5205 \$5615 \$5202 \$5004 NWELL PWELL BULK DFF_X1
X$20608 \$I175518 \$8537 \$8864 \$5004 NWELL PWELL BULK DFF_X1
X$20611 \$I177186 \$8704 \$9063 \$5004 NWELL PWELL BULK DFF_X1
X$20807 \$5098 \$6123 \$5824 NWELL PWELL BULK NAND2_X1
X$20811 \$5098 \$5099 \$5513 NWELL PWELL BULK NAND2_X1
X$20813 \$5098 \$7192 \$7190 \$I241487 NWELL PWELL BULK HA_X1
X$20815 \$5098 \$6851 \$6914 NWELL PWELL BULK NAND2_X1
X$20848 \$15926 \$5108 \$16313 \$15939 \$15937 NWELL PWELL BULK OAI22_X1
X$20850 \$16297 \$5108 \$15941 \$15939 \$15940 NWELL PWELL BULK OAI22_X1
X$20852 \$5108 \$18823 \$15939 \$18877 \$18017 \$18459 NWELL PWELL BULK
+ OAI221_X2
X$20892 \$5139 \$8114 \$14200 NWELL PWELL BULK NAND2_X2
X$20898 \$9559 \$8114 \$5139 \$17995 NWELL PWELL BULK AND3_X2
X$20900 \$5139 \$8114 \$9559 \$17993 NWELL PWELL BULK NAND3_X1
X$20902 \$9756 \$9146 \$8881 \$5139 \$10361 NWELL PWELL BULK OR4_X2
X$20905 \$9756 \$9146 \$8881 \$5139 \$10449 NWELL PWELL BULK NOR4_X4
X$21249 \$I176329 \$5787 \$5468 \$5785 NWELL PWELL BULK DFF_X1
X$21301 \$I175775 \$5505 \$5502 \$5815 NWELL PWELL BULK DFF_X1
X$21331 \$5838 \$5526 \$5522 \$5523 NWELL PWELL BULK DFF_X1
X$21333 \$6860 \$7268 \$7279 \$5523 NWELL PWELL BULK DFF_X1
X$21335 \$6859 \$6537 \$6490 \$5523 NWELL PWELL BULK DFF_X1
X$21337 \$6536 \$6531 \$6535 \$5523 NWELL PWELL BULK DFF_X1
X$21341 \$6164 \$6546 \$6129 \$5523 NWELL PWELL BULK DFF_X1
X$21343 \$I177807 \$7971 \$8545 \$5523 NWELL PWELL BULK DFF_X1
X$21346 \$I176482 \$7259 \$7202 \$5523 NWELL PWELL BULK DFF_X1
X$21349 \$I176523 \$8050 \$7672 \$5523 NWELL PWELL BULK DFF_X1
X$21351 \$I175863 \$8446 \$8010 \$5523 NWELL PWELL BULK DFF_X1
X$21353 \$I176526 \$6131 \$6130 \$5523 NWELL PWELL BULK DFF_X1
X$21356 \$I176536 \$6867 \$6493 \$5523 NWELL PWELL BULK DFF_X1
X$21359 \$I179128 \$6497 \$6874 \$5523 NWELL PWELL BULK DFF_X1
X$21361 \$I178552 \$7997 \$7998 \$5523 NWELL PWELL BULK DFF_X1
X$21364 \$I176743 \$8455 \$7991 \$5523 NWELL PWELL BULK DFF_X1
X$21366 \$I175803 \$7992 \$7995 \$5523 NWELL PWELL BULK DFF_X1
X$21368 \$I178706 \$9449 \$9166 \$5523 NWELL PWELL BULK DFF_X1
X$21371 \$I178499 \$8464 \$8486 \$5523 NWELL PWELL BULK DFF_X1
X$21373 \$I179207 \$9500 \$9169 \$5523 NWELL PWELL BULK DFF_X1
X$21375 \$I178498 \$8450 \$8787 \$5523 NWELL PWELL BULK DFF_X1
X$21377 \$I175335 \$8512 \$8837 \$5523 NWELL PWELL BULK DFF_X1
X$21380 \$I179159 \$9770 \$9445 \$5523 NWELL PWELL BULK DFF_X1
X$21382 \$I175194 \$9447 \$9492 \$5523 NWELL PWELL BULK DFF_X1
X$21385 \$I176778 \$9773 \$9772 \$5523 NWELL PWELL BULK DFF_X1
X$21388 \$I178753 \$9454 \$9479 \$5523 NWELL PWELL BULK DFF_X1
X$21390 \$I176429 \$7654 \$7199 \$5523 NWELL PWELL BULK DFF_X1
X$21392 \$I179122 \$8431 \$8550 \$5523 NWELL PWELL BULK DFF_X1
X$21395 \$I178393 \$9154 \$9189 \$5523 NWELL PWELL BULK DFF_X1
X$21397 \$I175336 \$9833 \$9834 \$5523 NWELL PWELL BULK DFF_X1
X$21399 \$7967 \$5523 \$I245694 \$8428 NWELL PWELL BULK DFF_X2
X$21742 \$I179283 \$5786 \$5784 \$5785 NWELL PWELL BULK DFF_X1
X$21744 \$7519 \$7497 \$7506 \$5785 NWELL PWELL BULK DFF_X1
X$21747 \$8290 \$8286 \$8276 \$5785 NWELL PWELL BULK DFF_X1
X$21750 \$I176434 \$8747 \$9116 \$5785 NWELL PWELL BULK DFF_X1
X$21752 \$7515 \$7509 \$7514 \$5785 NWELL PWELL BULK DFF_X1
X$21755 \$8274 \$7912 \$8661 \$5785 NWELL PWELL BULK DFF_X1
X$21758 \$I178573 \$8742 \$9111 \$5785 NWELL PWELL BULK DFF_X1
X$21761 \$I174964 \$8265 \$7910 \$5785 NWELL PWELL BULK DFF_X1
X$21764 \$I174971 \$7611 \$7809 \$5785 NWELL PWELL BULK DFF_X1
X$21766 \$I178607 \$8738 \$8375 \$5785 NWELL PWELL BULK DFF_X1
X$21768 \$I176459 \$9106 \$9666 \$5785 NWELL PWELL BULK DFF_X1
X$21770 \$I178590 \$8239 \$7822 \$5785 NWELL PWELL BULK DFF_X1
X$21772 \$I176503 \$9110 \$9673 \$5785 NWELL PWELL BULK DFF_X1
X$21775 \$I178621 \$9023 \$8647 \$5785 NWELL PWELL BULK DFF_X1
X$21777 \$I176483 \$8743 \$9676 \$5785 NWELL PWELL BULK DFF_X1
X$21779 \$I174720 \$9049 \$9286 \$5785 NWELL PWELL BULK DFF_X1
X$21782 \$8384 \$8663 \$8656 \$5785 NWELL PWELL BULK DFF_X1
X$21785 \$8390 \$9034 \$9038 \$5785 NWELL PWELL BULK DFF_X1
X$21787 \$I178800 \$9656 \$9274 \$5785 NWELL PWELL BULK DFF_X1
X$21789 \$I177135 \$9936 \$9941 \$5785 NWELL PWELL BULK DFF_X1
X$21791 \$I178767 \$9405 \$9736 \$5785 NWELL PWELL BULK DFF_X1
X$21793 \$I178619 \$7475 \$6804 \$5785 NWELL PWELL BULK DFF_X1
X$21795 \$7028 \$6808 \$6811 \$5785 NWELL PWELL BULK DFF_X1
X$21797 \$6740 \$7029 \$7042 \$5785 NWELL PWELL BULK DFF_X1
X$21802 \$I174975 \$7607 \$8255 \$5785 NWELL PWELL BULK DFF_X1
X$21805 \$I174935 \$7907 \$7819 \$5785 NWELL PWELL BULK DFF_X1
X$21807 \$I176846 \$10021 \$10020 \$5785 NWELL PWELL BULK DFF_X1
X$21809 \$I177301 \$10252 \$10017 \$5785 NWELL PWELL BULK DFF_X1
X$21811 \$I175736 \$8732 \$9000 \$5785 NWELL PWELL BULK DFF_X1
X$21895 \$I178242 \$9750 \$9878 \$5815 NWELL PWELL BULK DFF_X1
X$21897 \$I177208 \$9418 \$9420 \$5815 NWELL PWELL BULK DFF_X1
X$21899 \$I177114 \$9138 \$9873 \$5815 NWELL PWELL BULK DFF_X1
X$21901 \$I178158 \$7165 \$7629 \$5815 NWELL PWELL BULK DFF_X1
X$21904 \$I175809 \$7930 \$8282 \$5815 NWELL PWELL BULK DFF_X1
X$21907 \$I178139 \$7934 \$8256 \$5815 NWELL PWELL BULK DFF_X1
X$21910 \$I178427 \$6845 \$7178 \$5815 NWELL PWELL BULK DFF_X1
X$21913 \$I178146 \$8764 \$8945 \$5815 NWELL PWELL BULK DFF_X1
X$21915 \$I176579 \$8766 \$9128 \$5815 NWELL PWELL BULK DFF_X1
X$21918 \$I175372 \$8767 \$9235 \$5815 NWELL PWELL BULK DFF_X1
X$21921 \$I175832 \$8409 \$8407 \$5815 NWELL PWELL BULK DFF_X1
X$21923 \$I175949 \$7479 \$6964 \$5815 NWELL PWELL BULK DFF_X1
X$21925 \$I175403 \$6107 \$6106 \$5815 NWELL PWELL BULK DFF_X1
X$21927 \$I175429 \$6837 \$7458 \$5815 NWELL PWELL BULK DFF_X1
X$21929 \$I178168 \$6961 \$7169 \$5815 NWELL PWELL BULK DFF_X1
X$21932 \$I175390 \$7949 \$7946 \$5815 NWELL PWELL BULK DFF_X1
X$21935 \$I178434 \$7935 \$8411 \$5815 NWELL PWELL BULK DFF_X1
X$21938 \$I178057 \$8412 \$8614 \$5815 NWELL PWELL BULK DFF_X1
X$21941 \$I175384 \$7180 \$7743 \$5815 NWELL PWELL BULK DFF_X1
X$21943 \$I176597 \$9136 \$9605 \$5815 NWELL PWELL BULK DFF_X1
X$21946 \$I176073 \$8414 \$7940 \$5815 NWELL PWELL BULK DFF_X1
X$21950 \$I176575 \$9423 \$9421 \$5815 NWELL PWELL BULK DFF_X1
X$21953 \$I178429 \$8905 \$8914 \$5815 NWELL PWELL BULK DFF_X1
X$21955 \$I176567 \$9576 \$9584 \$5815 NWELL PWELL BULK DFF_X1
X$21958 \$I175534 \$8420 \$8770 \$5815 NWELL PWELL BULK DFF_X1
X$21960 \$I178428 \$6842 \$7637 \$5815 NWELL PWELL BULK DFF_X1
X$21962 \$I176585 \$9134 \$9133 \$5815 NWELL PWELL BULK DFF_X1
X$21965 \$I175400 \$7173 \$7439 \$5815 NWELL PWELL BULK DFF_X1
X$21967 \$I175396 \$7944 \$8209 \$5815 NWELL PWELL BULK DFF_X1
X$21994 \$I175329 \$5817 \$5888 \$6472 NWELL PWELL BULK DFF_X1
X$22000 \$6120 \$5822 \$5873 NWELL PWELL BULK XOR2_X1
X$22020 \$7973 \$5834 \$I241004 \$7656 NWELL PWELL BULK HA_X1
X$22023 \$5834 \$7207 \$7208 NWELL PWELL BULK NAND2_X1
X$22026 \$5834 \$6137 \$6140 NWELL PWELL BULK NAND2_X1
X$22028 \$5834 \$7215 \$7222 NWELL PWELL BULK NAND2_X1
X$22031 \$5834 \$6497 \$6504 NWELL PWELL BULK NAND2_X1
X$22033 \$5834 \$6132 NWELL PWELL BULK INV_X2
X$22035 \$5834 \$6867 \$6862 NWELL PWELL BULK NAND2_X1
X$22278 \$I178510 \$9372 \$9988 \$6058 NWELL PWELL BULK DFF_X1
X$22281 \$I178835 \$10300 \$10530 \$6058 NWELL PWELL BULK DFF_X1
X$22284 \$I178288 \$7830 \$8182 \$6058 NWELL PWELL BULK DFF_X1
X$22287 \$I177959 \$7890 \$7594 \$6058 NWELL PWELL BULK DFF_X1
X$22290 \$I177835 \$9078 \$9267 \$6058 NWELL PWELL BULK DFF_X1
X$22293 \$I178330 \$8164 \$8585 \$6058 NWELL PWELL BULK DFF_X1
X$22296 \$I174472 \$9709 \$9582 \$6058 NWELL PWELL BULK DFF_X1
X$22298 \$I179225 \$12659 \$13269 \$6058 NWELL PWELL BULK DFF_X1
X$22300 \$I177840 \$7886 \$7885 \$6058 NWELL PWELL BULK DFF_X1
X$22303 \$I177605 \$8369 \$8718 \$6058 NWELL PWELL BULK DFF_X1
X$22305 \$I177687 \$8935 \$9080 \$6058 NWELL PWELL BULK DFF_X1
X$22308 \$I176354 \$8601 \$8936 \$6058 NWELL PWELL BULK DFF_X1
X$22312 \$6771 \$7382 \$7379 \$6058 NWELL PWELL BULK DFF_X1
X$22314 \$I174824 \$10526 \$10623 \$6058 NWELL PWELL BULK DFF_X1
X$22316 \$I178508 \$10990 \$11276 \$6058 NWELL PWELL BULK DFF_X1
X$22318 \$6302 \$6297 \$6295 \$6058 NWELL PWELL BULK DFF_X1
X$22320 \$I175222 \$11387 \$11642 \$6058 NWELL PWELL BULK DFF_X1
X$22322 \$I178538 \$10987 \$11265 \$6058 NWELL PWELL BULK DFF_X1
X$22325 \$I178463 \$9892 \$9579 \$6058 NWELL PWELL BULK DFF_X1
X$22328 \$I175267 \$7414 \$7141 \$6058 NWELL PWELL BULK DFF_X1
X$22331 \$I178453 \$8204 \$8610 \$6058 NWELL PWELL BULK DFF_X1
X$22334 \$I175008 \$7388 \$7394 \$6058 NWELL PWELL BULK DFF_X1
X$22337 \$I179212 \$7897 \$8208 \$6058 NWELL PWELL BULK DFF_X1
X$22339 \$I179140 \$8372 \$8729 \$6058 NWELL PWELL BULK DFF_X1
X$22342 \$I179055 \$11660 \$11936 \$6058 NWELL PWELL BULK DFF_X1
X$22344 \$I179162 \$11648 \$11732 \$6058 NWELL PWELL BULK DFF_X1
X$22346 \$I175735 \$9395 \$9394 \$6058 NWELL PWELL BULK DFF_X1
X$22349 \$I174463 \$9331 \$9648 \$6058 NWELL PWELL BULK DFF_X1
X$22352 \$I178567 \$8982 \$8373 \$6058 NWELL PWELL BULK DFF_X1
X$22355 \$I174465 \$9099 \$9100 \$6058 NWELL PWELL BULK DFF_X1
X$22384 \$6791 \$6685 \$6065 \$6067 NWELL PWELL BULK MUX2_X1
X$22466 \$I175357 \$6116 \$6213 \$6472 NWELL PWELL BULK DFF_X1
X$22478 \$I178597 \$6120 \$6190 \$6472 NWELL PWELL BULK DFF_X1
X$22486 \$6123 \$7196 \$7959 NWELL PWELL BULK XNOR2_X2
X$22488 \$6123 \$6124 NWELL PWELL BULK INV_X1
X$22501 \$6132 \$6131 \$6511 NWELL PWELL BULK NAND2_X1
X$22503 \$6131 \$6147 \$6150 NWELL PWELL BULK XNOR2_X1
X$22508 \$6132 \$6137 \$6870 NWELL PWELL BULK NAND2_X1
X$22511 \$6132 \$6497 \$7209 NWELL PWELL BULK NAND2_X1
X$22514 \$6132 \$6133 \$6494 NWELL PWELL BULK NAND2_X1
X$22517 \$6132 \$6499 \$6135 NWELL PWELL BULK NAND2_X1
X$22522 \$7664 \$6132 \$6861 \$I241545 NWELL PWELL BULK HA_X1
X$22525 \$6132 \$6144 \$6147 NWELL PWELL BULK NAND2_X1
X$22529 \$6137 \$6497 \$6133 \$6144 NWELL PWELL BULK HA_X1
X$22535 \$6499 \$6137 \$6136 \$7214 NWELL PWELL BULK DFF_X1
X$22872 \$I177480 \$6471 \$6929 \$6472 NWELL PWELL BULK DFF_X1
X$22879 \$I178083 \$6851 \$6915 \$6472 NWELL PWELL BULK DFF_X1
X$22883 \$I174940 \$7189 \$7340 \$6472 NWELL PWELL BULK DFF_X1
X$22885 \$7962 \$8087 \$8101 \$6472 NWELL PWELL BULK DFF_X1
X$22889 \$I176215 \$7196 \$6852 \$6472 NWELL PWELL BULK DFF_X1
X$22891 \$I176493 \$7702 \$7651 \$6472 NWELL PWELL BULK DFF_X1
X$22896 \$I175919 \$7194 \$7321 \$6472 NWELL PWELL BULK DFF_X1
X$22899 \$I179164 \$6473 \$6924 \$6472 NWELL PWELL BULK DFF_X1
X$22903 \$I179248 \$7643 \$8176 \$6472 NWELL PWELL BULK DFF_X1
X$22906 \$I175305 \$7184 \$7734 \$6472 NWELL PWELL BULK DFF_X1
X$22908 \$7952 \$7188 \$7950 \$6472 NWELL PWELL BULK DFF_X1
X$22910 \$I175960 \$8422 \$8899 \$6472 NWELL PWELL BULK DFF_X1
X$22914 \$8145 \$8136 \$7953 \$6472 NWELL PWELL BULK DFF_X1
X$22917 \$I177280 \$9755 \$9852 \$6472 NWELL PWELL BULK DFF_X1
X$22919 \$11428 \$6472 \$10801 \$11054 NWELL PWELL BULK DFF_X2
X$22921 \$10674 \$6472 \$10359 \$10677 NWELL PWELL BULK DFF_X2
X$22924 \$I174755 \$6599 \$6601 \$6472 NWELL PWELL BULK DFF_X1
X$22926 \$10043 \$9758 \$10042 \$6472 NWELL PWELL BULK DFF_X1
X$22930 \$11158 \$6472 \$I245638 \$11060 NWELL PWELL BULK DFF_X2
X$22932 \$10450 \$6472 \$11170 \$11439 NWELL PWELL BULK DFF_X2
X$22934 \$I176479 \$8773 \$9214 \$6472 NWELL PWELL BULK DFF_X1
X$22937 \$9834 \$6472 \$I245702 \$10106 NWELL PWELL BULK DFF_X2
X$22939 \$I177513 \$7641 \$7740 \$6472 NWELL PWELL BULK DFF_X1
X$22942 \$I178370 \$9150 \$9558 \$6472 NWELL PWELL BULK DFF_X1
X$22944 \$I175363 \$8775 \$9195 \$6472 NWELL PWELL BULK DFF_X1
X$22984 \$6487 \$9147 \$9146 NWELL PWELL BULK NOR2_X1
X$23011 \$6507 \$6509 \$6506 \$6741 NWELL PWELL BULK DFF_X1
X$23027 \$6521 \$6523 \$6881 \$6741 NWELL PWELL BULK DFF_X1
X$23037 \$15926 \$6525 \$16313 \$16314 \$15949 NWELL PWELL BULK OAI22_X1
X$23039 \$16297 \$6525 \$15941 \$16314 \$15947 NWELL PWELL BULK OAI22_X1
X$23041 \$6525 \$18823 \$18877 \$16314 \$18442 \$18465 NWELL PWELL BULK
+ OAI221_X2
X$23217 \$20070 \$6685 \$20071 \$20434 NWELL PWELL BULK MUX2_X1
X$23219 \$31006 \$6685 \$31008 \$29699 NWELL PWELL BULK MUX2_X1
X$23222 \$22566 \$6685 \$22568 \$22573 NWELL PWELL BULK MUX2_X1
X$23225 \$29173 \$6685 NWELL PWELL BULK BUF_X16
X$23227 \$9241 \$6685 \$9550 \$9071 NWELL PWELL BULK MUX2_X1
X$23229 \$10141 \$6685 \$9705 \$9974 NWELL PWELL BULK MUX2_X1
X$23231 \$7902 \$6685 \$8229 \$7604 NWELL PWELL BULK MUX2_X1
X$23234 \$9075 \$6685 \$8583 \$9261 NWELL PWELL BULK MUX2_X1
X$23236 \$20392 \$6685 \$20676 \$20397 NWELL PWELL BULK MUX2_X1
X$23238 \$18206 \$6685 \$18210 \$18217 NWELL PWELL BULK MUX2_X1
X$23241 \$18995 \$6685 \$19108 \$18355 NWELL PWELL BULK MUX2_X1
X$23243 \$16193 \$6685 \$16194 \$16644 NWELL PWELL BULK MUX2_X1
X$23246 \$14988 \$6685 \$15318 \$14990 NWELL PWELL BULK MUX2_X1
X$23248 \$14133 \$6685 \$14994 \$15320 NWELL PWELL BULK MUX2_X1
X$23251 \$16190 \$6685 \$16191 \$16485 NWELL PWELL BULK MUX2_X1
X$23253 \$14408 \$6685 \$14131 \$14737 NWELL PWELL BULK MUX2_X1
X$23256 \$13787 \$6685 \$13788 \$12928 NWELL PWELL BULK MUX2_X1
X$23258 \$11384 \$6685 \$12026 \$12380 NWELL PWELL BULK MUX2_X1
X$23261 \$12648 \$6685 \$12650 \$12929 NWELL PWELL BULK MUX2_X1
X$23263 \$11725 \$6685 \$12367 \$12927 NWELL PWELL BULK MUX2_X1
X$23266 \$33091 \$6685 \$33093 \$32917 NWELL PWELL BULK MUX2_X1
X$23268 \$32908 \$6685 \$31761 \$32915 NWELL PWELL BULK MUX2_X1
X$23270 \$29506 \$6685 \$28725 \$29509 NWELL PWELL BULK MUX2_X1
X$23273 \$29954 \$6685 \$30549 \$29958 NWELL PWELL BULK MUX2_X1
X$23275 \$29056 \$6685 \$29054 \$29507 NWELL PWELL BULK MUX2_X1
X$23277 \$23509 \$6685 \$22579 \$22244 NWELL PWELL BULK MUX2_X1
X$23279 \$16947 \$6685 \$16643 \$17191 NWELL PWELL BULK MUX2_X1
X$23281 \$17574 \$6685 \$17931 \$17932 NWELL PWELL BULK MUX2_X1
X$23284 \$19106 \$6685 \$19696 \$20063 NWELL PWELL BULK MUX2_X1
X$23287 \$16635 \$6685 \$16476 \$17928 NWELL PWELL BULK MUX2_X1
X$23289 \$10838 \$6685 \$10979 \$10293 NWELL PWELL BULK MUX2_X1
X$23291 \$16195 \$6685 \$15323 \$16196 NWELL PWELL BULK MUX2_X1
X$23293 \$10509 \$6685 \$11241 \$10851 NWELL PWELL BULK MUX2_X1
X$23295 \$18762 \$6685 \$19341 \$19116 NWELL PWELL BULK MUX2_X1
X$23298 \$7429 \$6685 \$7450 \$7827 NWELL PWELL BULK MUX2_X1
X$23301 \$17194 \$6685 \$17195 \$17196 NWELL PWELL BULK MUX2_X1
X$23307 \$8363 \$6685 \$8710 \$9260 NWELL PWELL BULK MUX2_X1
X$23310 \$8361 \$6685 \$7876 \$9070 NWELL PWELL BULK MUX2_X1
X$23313 \$9872 \$6685 \$9880 \$10852 NWELL PWELL BULK MUX2_X1
X$23393 \$9687 \$6741 \$I245685 \$9689 NWELL PWELL BULK DFF_X2
X$23396 \$I177756 \$10961 \$10956 \$6741 NWELL PWELL BULK DFF_X1
X$23398 \$9793 \$6741 \$I245689 \$9343 NWELL PWELL BULK DFF_X2
X$23401 \$I177721 \$10756 \$10594 \$6741 NWELL PWELL BULK DFF_X1
X$23406 \$I178323 \$7088 \$7089 \$6741 NWELL PWELL BULK DFF_X1
X$23409 \$8038 \$7091 \$7696 \$6741 NWELL PWELL BULK DFF_X1
X$23411 \$I175562 \$8695 \$8826 \$6741 NWELL PWELL BULK DFF_X1
X$23414 \$I175588 \$8507 \$8696 \$6741 NWELL PWELL BULK DFF_X1
X$23416 \$I178339 \$9194 \$9192 \$6741 NWELL PWELL BULK DFF_X1
X$23419 \$I177675 \$10590 \$10417 \$6741 NWELL PWELL BULK DFF_X1
X$23421 \$I176452 \$9961 \$10081 \$6741 NWELL PWELL BULK DFF_X1
X$23423 \$8341 \$8032 \$8490 \$6741 NWELL PWELL BULK DFF_X1
X$23426 \$I177711 \$8339 \$9057 \$6741 NWELL PWELL BULK DFF_X1
X$23429 \$8342 \$8825 \$8691 \$6741 NWELL PWELL BULK DFF_X1
X$23432 \$I178324 \$7846 \$7564 \$6741 NWELL PWELL BULK DFF_X1
X$23435 \$7850 \$7849 \$7566 \$6741 NWELL PWELL BULK DFF_X1
X$23438 \$I178333 \$8344 \$8494 \$6741 NWELL PWELL BULK DFF_X1
X$23440 \$I176306 \$9347 \$9487 \$6741 NWELL PWELL BULK DFF_X1
X$23442 \$I178261 \$9964 \$10441 \$6741 NWELL PWELL BULK DFF_X1
X$23446 \$9053 \$6741 \$I245587 \$8684 NWELL PWELL BULK DFF_X2
X$23449 \$I176316 \$9339 \$9687 \$6741 NWELL PWELL BULK DFF_X1
X$23452 \$I176525 \$8335 \$8796 \$6741 NWELL PWELL BULK DFF_X1
X$23454 \$I177745 \$11987 \$11983 \$6741 NWELL PWELL BULK DFF_X1
X$23456 \$8479 \$8338 \$8474 \$6741 NWELL PWELL BULK DFF_X1
X$23458 \$9457 \$6741 \$I245684 \$9693 NWELL PWELL BULK DFF_X2
X$23460 \$I176347 \$9052 \$9457 \$6741 NWELL PWELL BULK DFF_X1
X$23463 \$I177694 \$7563 \$7087 \$6741 NWELL PWELL BULK DFF_X1
X$23467 \$7842 \$8334 \$8002 \$6741 NWELL PWELL BULK DFF_X1
X$23508 \$I175613 \$6754 \$6957 \$7118 NWELL PWELL BULK DFF_X1
X$23519 \$I176676 \$6756 \$6968 \$7118 NWELL PWELL BULK DFF_X1
X$23682 \$6849 \$7344 \$7346 NWELL PWELL BULK XNOR2_X1
X$23688 \$6851 \$8773 \$7958 NWELL PWELL BULK XNOR2_X2
X$23713 \$6860 \$6861 \$7268 \$7201 NWELL PWELL BULK MUX2_X1
X$23718 \$7205 \$7259 \$6861 \$7260 NWELL PWELL BULK AOI21_X1
X$23723 \$6861 \$7261 \$7205 NWELL PWELL BULK NOR2_X1
X$23725 \$7657 \$6861 \$8064 NWELL PWELL BULK NOR2_X1
X$23733 \$8050 \$6867 \$7244 NWELL PWELL BULK XNOR2_X1
X$23935 \$7086 \$7558 \$7084 NWELL PWELL BULK XNOR2_X1
X$23941 \$7555 \$7086 \$7678 NWELL PWELL BULK NAND2_X1
X$23947 \$7088 \$7563 \$8013 NWELL PWELL BULK XNOR2_X1
X$23950 \$7088 \$7845 \$7846 \$7230 NWELL PWELL BULK MUX2_X1
X$23984 \$I177002 \$7116 \$7117 \$7118 NWELL PWELL BULK DFF_X1
X$23993 \$I177403 \$11605 \$11723 \$7118 NWELL PWELL BULK DFF_X1
X$23995 \$I177400 \$11725 \$11953 \$7118 NWELL PWELL BULK DFF_X1
X$24003 \$I174478 \$9241 \$9066 \$7118 NWELL PWELL BULK DFF_X1
X$24006 \$I176488 \$8707 \$8879 \$7118 NWELL PWELL BULK DFF_X1
X$24008 \$I176904 \$8360 \$8553 \$7118 NWELL PWELL BULK DFF_X1
X$24012 \$I177042 \$7585 \$8126 \$7118 NWELL PWELL BULK DFF_X1
X$24014 \$I176495 \$7119 \$7765 \$7118 NWELL PWELL BULK DFF_X1
X$24016 \$I176905 \$8356 \$8354 \$7118 NWELL PWELL BULK DFF_X1
X$24019 \$I176500 \$8108 \$7870 \$7118 NWELL PWELL BULK DFF_X1
X$24021 \$I176907 \$9230 \$9228 \$7118 NWELL PWELL BULK DFF_X1
X$24023 \$I176415 \$9970 \$10127 \$7118 NWELL PWELL BULK DFF_X1
X$24026 \$I176408 \$10838 \$10834 \$7118 NWELL PWELL BULK DFF_X1
X$24028 \$I177407 \$10979 \$11232 \$7118 NWELL PWELL BULK DFF_X1
X$24030 \$I176414 \$10496 \$10616 \$7118 NWELL PWELL BULK DFF_X1
X$24032 \$I176999 \$11380 \$11600 \$7118 NWELL PWELL BULK DFF_X1
X$24034 \$I176085 \$10509 \$10844 \$7118 NWELL PWELL BULK DFF_X1
X$24036 \$I176982 \$9705 \$9858 \$7118 NWELL PWELL BULK DFF_X1
X$24038 \$I176983 \$10141 \$9973 \$7118 NWELL PWELL BULK DFF_X1
X$24040 \$I176267 \$12644 \$12923 \$7118 NWELL PWELL BULK DFF_X1
X$24043 \$I177451 \$14408 \$14128 \$7118 NWELL PWELL BULK DFF_X1
X$24045 \$I176258 \$12643 \$12855 \$7118 NWELL PWELL BULK DFF_X1
X$24047 \$I177007 \$8710 \$9564 \$7118 NWELL PWELL BULK DFF_X1
X$24049 \$I177005 \$7876 \$7875 \$7118 NWELL PWELL BULK DFF_X1
X$24052 \$I177001 \$8361 \$8561 \$7118 NWELL PWELL BULK DFF_X1
X$24055 \$I176081 \$9872 \$9870 \$7118 NWELL PWELL BULK DFF_X1
X$24058 \$I177024 \$9550 \$9548 \$7118 NWELL PWELL BULK DFF_X1
X$24061 \$I177029 \$9880 \$10152 \$7118 NWELL PWELL BULK DFF_X1
X$24124 \$22556 \$7143 \$22240 \$21787 NWELL PWELL BULK MUX2_X1
X$24127 \$29134 \$7143 \$27916 \$29492 NWELL PWELL BULK MUX2_X1
X$24139 \$30248 \$7143 \$30249 \$30947 NWELL PWELL BULK MUX2_X1
X$24142 \$7143 \$29172 NWELL PWELL BULK BUF_X8
X$24259 \$7189 \$7185 \$7333 \$7341 \$7188 NWELL PWELL BULK FA_X1
X$24261 \$7187 \$7185 \$7186 NWELL PWELL BULK XOR2_X1
X$24264 \$7186 \$7190 \$7344 NWELL PWELL BULK NOR2_X1
X$24269 \$7187 \$7341 NWELL PWELL BULK INV_X1
X$24275 \$7952 \$7190 \$7188 \$7646 NWELL PWELL BULK MUX2_X1
X$24277 \$7329 \$7189 \$7190 \$7339 NWELL PWELL BULK AOI21_X1
X$24284 \$7190 \$7333 \$7329 NWELL PWELL BULK NOR2_X1
X$24292 \$7191 \$7192 NWELL PWELL BULK INV_X1
X$24295 \$7191 \$7196 \$7301 NWELL PWELL BULK NAND2_X1
X$24297 \$7191 \$7194 \$7721 NWELL PWELL BULK NAND2_X1
X$24299 \$7191 \$8145 \$8140 NWELL PWELL BULK NOR2_X1
X$24301 \$8136 \$7191 \$7702 \$8127 NWELL PWELL BULK MUX2_X1
X$24303 \$8881 \$9204 \$7191 NWELL PWELL BULK OR2_X2
X$24306 \$7191 \$8773 \$9142 NWELL PWELL BULK NAND2_X1
X$24317 \$7192 \$7194 \$7309 NWELL PWELL BULK NAND2_X1
X$24320 \$8138 \$7192 \$7956 NWELL PWELL BULK AND2_X1
X$24322 \$7192 \$7647 \$7723 NWELL PWELL BULK NAND2_X1
X$24324 \$7192 \$8136 \$8575 NWELL PWELL BULK NOR2_X1
X$24326 \$7192 \$8422 \$9216 NWELL PWELL BULK NAND2_X1
X$24334 \$8136 \$7194 \$7647 \$8138 NWELL PWELL BULK HA_X1
X$24349 \$7655 \$7654 \$7652 \$7198 NWELL PWELL BULK AOI21_X1
X$24366 \$I175219 \$7207 \$7210 \$7214 NWELL PWELL BULK DFF_X1
X$24369 \$7984 \$7207 \$7670 NWELL PWELL BULK XNOR2_X1
X$24378 \$7210 \$7214 \$I245545 \$8456 NWELL PWELL BULK DFF_X2
X$24384 \$7212 \$7215 \$7225 NWELL PWELL BULK XNOR2_X1
X$24386 \$8843 \$7214 \$I245559 \$7212 NWELL PWELL BULK DFF_X2
X$24388 \$7212 \$7983 NWELL PWELL BULK INV_X1
X$24390 \$7212 \$7984 \$7973 \$8009 NWELL PWELL BULK AND3_X2
X$24392 \$7212 \$7984 \$7664 \$8006 NWELL PWELL BULK NOR3_X4
X$24394 \$7664 \$7212 \$8525 NWELL PWELL BULK NAND2_X1
X$24396 \$9439 \$9533 \$9155 \$7214 NWELL PWELL BULK DFF_X1
X$24399 \$I174460 \$7972 \$8543 \$7214 NWELL PWELL BULK DFF_X1
X$24402 \$7976 \$7978 \$7975 \$7214 NWELL PWELL BULK DFF_X1
X$24405 \$7216 \$7214 \$I245731 \$7986 NWELL PWELL BULK DFF_X2
X$24407 \$I179129 \$7215 \$7216 \$7214 NWELL PWELL BULK DFF_X1
X$24411 \$9508 \$7214 \$I245586 \$7984 NWELL PWELL BULK DFF_X2
X$24418 \$I175259 \$7987 \$8448 \$7214 NWELL PWELL BULK DFF_X1
X$24421 \$I175268 \$9446 \$9444 \$7214 NWELL PWELL BULK DFF_X1
X$24424 \$13082 \$13907 \$13568 \$7214 NWELL PWELL BULK DFF_X1
X$24426 \$12318 \$12137 \$12315 \$7214 NWELL PWELL BULK DFF_X1
X$24429 \$12328 \$12329 \$12330 \$7214 NWELL PWELL BULK DFF_X1
X$24432 \$I176964 \$11447 \$11803 \$7214 NWELL PWELL BULK DFF_X1
X$24435 \$12731 \$13004 \$13107 \$7214 NWELL PWELL BULK DFF_X1
X$24437 \$13585 \$13583 \$13006 \$7214 NWELL PWELL BULK DFF_X1
X$24439 \$I177054 \$9436 \$9824 \$7214 NWELL PWELL BULK DFF_X1
X$24441 \$I176959 \$9175 \$9512 \$7214 NWELL PWELL BULK DFF_X1
X$24443 \$10054 \$7214 \$I245755 \$10365 NWELL PWELL BULK DFF_X2
X$24446 \$I177101 \$10370 \$10689 \$7214 NWELL PWELL BULK DFF_X1
X$24449 \$11450 \$12139 \$11467 \$7214 NWELL PWELL BULK DFF_X1
X$24451 \$10369 \$10059 \$10057 \$7214 NWELL PWELL BULK DFF_X1
X$24454 \$I176038 \$10692 \$10754 \$7214 NWELL PWELL BULK DFF_X1
X$24456 \$13007 \$13570 \$13098 \$7214 NWELL PWELL BULK DFF_X1
X$24459 \$11137 \$7214 \$I245756 \$11064 NWELL PWELL BULK DFF_X2
X$24461 \$12737 \$12755 \$12735 \$7214 NWELL PWELL BULK DFF_X1
X$24463 \$I177108 \$12143 \$11811 \$7214 NWELL PWELL BULK DFF_X1
X$24467 \$12307 \$11810 \$12303 \$7214 NWELL PWELL BULK DFF_X1
X$24514 \$7845 \$7234 \$I241121 \$11508 NWELL PWELL BULK HA_X1
X$24516 \$7234 \$7555 NWELL PWELL BULK INV_X2
X$24519 \$7234 \$9052 \$9167 NWELL PWELL BULK NAND2_X1
X$24521 \$7234 \$9339 \$9471 NWELL PWELL BULK NAND2_X1
X$24523 \$7234 \$7563 \$7680 NWELL PWELL BULK NAND2_X1
X$24525 \$7234 \$8334 \$8003 NWELL PWELL BULK NAND2_X1
X$24527 \$7234 \$8335 \$8803 NWELL PWELL BULK NAND2_X1
X$24559 \$7259 \$7658 \$7261 \$7270 \$7268 NWELL PWELL BULK FA_X1
X$24584 \$7656 \$7270 NWELL PWELL BULK INV_X1
X$24594 \$8865 \$9376 \$7282 \$8606 \$9911 NWELL PWELL BULK NOR4_X4
X$24597 \$9288 \$9309 \$9380 \$7282 \$9086 NWELL PWELL BULK AOI22_X2
X$24602 \$7282 \$9606 \$9288 \$9389 \$9922 NWELL PWELL BULK AOI22_X1
X$24606 \$7282 \$8952 NWELL PWELL BULK INV_X1
X$24629 \$7318 \$19036 NWELL PWELL BULK BUF_X4
X$24631 \$24703 \$7318 NWELL PWELL BULK BUF_X4
X$24639 \$7318 \$25314 NWELL PWELL BULK BUF_X4
X$24888 \$10277 \$7555 \$11363 \$I241612 NWELL PWELL BULK HA_X1
X$24890 \$7555 \$8335 \$9336 NWELL PWELL BULK NAND2_X1
X$24893 \$7555 \$8334 \$9170 NWELL PWELL BULK NAND2_X1
X$24895 \$7555 \$8465 \$8682 NWELL PWELL BULK NAND2_X1
X$24898 \$7555 \$7559 \$7558 NWELL PWELL BULK NAND2_X1
X$24901 \$7555 \$7842 \$8001 NWELL PWELL BULK NAND2_X1
X$24913 \$8334 \$8335 \$8465 \$7559 NWELL PWELL BULK HA_X1
X$25048 \$7962 \$7652 \$8087 \$8093 NWELL PWELL BULK MUX2_X1
X$25054 \$7652 \$7966 \$7655 NWELL PWELL BULK NOR2_X1
X$25060 \$7654 \$7964 \$7966 \$8082 \$8087 NWELL PWELL BULK FA_X1
X$25067 \$7656 \$7658 \$7657 NWELL PWELL BULK XOR2_X1
X$25078 \$7973 \$7664 NWELL PWELL BULK INV_X2
X$25080 \$7664 \$7976 \$8848 NWELL PWELL BULK NOR2_X1
X$25082 \$7983 \$7984 \$7664 \$8447 NWELL PWELL BULK NOR3_X4
X$25111 \$8072 \$7964 \$7695 NWELL PWELL BULK XOR2_X1
X$25219 \$9343 \$7845 \$8339 \$9344 NWELL PWELL BULK MUX2_X1
X$25222 \$10277 \$7845 NWELL PWELL BULK INV_X2
X$25225 \$7845 \$9343 \$8684 \$10262 NWELL PWELL BULK AND3_X4
X$25228 \$7845 \$8340 \$8024 NWELL PWELL BULK NAND2_X1
X$25231 \$7845 \$9343 \$10280 \$9683 NWELL PWELL BULK AND3_X4
X$25233 \$8339 \$7845 \$8817 \$8690 NWELL PWELL BULK MUX2_X1
X$25236 \$8338 \$7845 \$8479 \$8477 NWELL PWELL BULK MUX2_X1
X$25238 \$8684 \$7845 \$8338 \$9054 NWELL PWELL BULK MUX2_X1
X$25253 \$7846 \$8024 \$8016 NWELL PWELL BULK XOR2_X1
X$25320 \$9297 \$8947 \$8728 \$7888 \$8725 NWELL PWELL BULK OR4_X4
X$25323 \$7888 \$9304 NWELL PWELL BULK INV_X1
X$25325 \$9288 \$9088 \$7888 \$8727 \$9082 NWELL PWELL BULK AOI22_X1
X$25410 \$7949 \$7947 NWELL PWELL BULK INV_X1
X$25424 \$8422 \$7956 \$8577 NWELL PWELL BULK XNOR2_X1
X$25427 \$7958 \$7957 \$7959 \$8114 NWELL PWELL BULK NAND3_X4
X$25429 \$7957 \$7958 \$7959 \$8881 NWELL PWELL BULK AND3_X2
X$25452 \$7970 \$7971 \$7969 NWELL PWELL BULK NAND2_X1
X$25454 \$7970 \$8779 \$8861 NWELL PWELL BULK NAND2_X1
X$25459 \$7970 \$9536 \$9826 NWELL PWELL BULK NAND2_X1
X$25462 \$7970 \$9439 \$9182 NWELL PWELL BULK NAND2_X1
X$25464 \$10099 \$10365 \$7970 \$10429 NWELL PWELL BULK NAND3_X4
X$25466 \$7970 \$9436 \$10051 NWELL PWELL BULK NAND2_X1
X$25468 \$10772 \$10365 \$7970 \$12725 NWELL PWELL BULK NAND3_X4
X$25470 \$7970 \$9533 \$10094 NWELL PWELL BULK NAND2_X1
X$25472 \$7970 \$8427 \$I241007 \$8072 NWELL PWELL BULK HA_X1
X$25485 \$7971 \$8861 \$8432 NWELL PWELL BULK XOR2_X1
X$25490 \$7972 \$8853 \$8542 NWELL PWELL BULK XOR2_X1
X$25493 \$8050 \$7973 \$7972 \$8054 NWELL PWELL BULK MUX2_X1
X$25495 \$7984 \$7973 \$9175 \$9156 NWELL PWELL BULK MUX2_X1
X$25498 \$9175 \$7973 \$9513 \$9441 NWELL PWELL BULK MUX2_X1
X$25501 \$7973 \$8428 \$15605 \$16449 NWELL PWELL BULK AOI21_X4
X$25504 \$7973 \$7978 \$8435 NWELL PWELL BULK NOR2_X1
X$25506 \$7973 \$8850 \$8853 NWELL PWELL BULK NAND2_X1
X$25509 \$7983 \$7984 \$7973 \$7990 NWELL PWELL BULK AND3_X2
X$25515 \$7973 \$7978 \$7980 NWELL PWELL BULK NAND2_X1
X$25538 \$7978 \$9175 \$9513 \$8850 NWELL PWELL BULK HA_X1
X$25565 \$9771 \$7986 \$10412 \$10695 NWELL PWELL BULK MUX2_X1
X$25567 \$8789 \$7986 \$8791 \$9162 NWELL PWELL BULK MUX2_X1
X$25570 \$9470 \$7986 \$9464 \$9460 NWELL PWELL BULK MUX2_X1
X$25572 \$8812 \$7986 \$7988 \$9158 NWELL PWELL BULK MUX2_X1
X$25574 \$10061 \$7986 \$9775 \$10083 NWELL PWELL BULK MUX2_X1
X$25576 \$10704 \$7986 \$10699 \$10700 NWELL PWELL BULK MUX2_X1
X$25586 \$7987 \$8447 \$8443 \$8448 NWELL PWELL BULK MUX2_X1
X$25588 \$7987 \$8456 \$8450 \$7988 NWELL PWELL BULK MUX2_X1
X$25594 \$7997 \$8447 \$7989 \$7998 NWELL PWELL BULK MUX2_X1
X$25597 \$7992 \$8009 \$7989 \$7995 NWELL PWELL BULK MUX2_X1
X$25600 \$8455 \$7990 \$7989 \$7991 NWELL PWELL BULK MUX2_X1
X$25603 \$8464 \$8006 \$7989 \$8486 NWELL PWELL BULK MUX2_X1
X$25606 \$15407 \$15947 \$15409 \$7989 NWELL PWELL BULK OR3_X2
X$25611 \$8446 \$7990 \$8443 \$8010 NWELL PWELL BULK MUX2_X1
X$25616 \$9449 \$7990 \$9160 \$9166 NWELL PWELL BULK MUX2_X1
X$25618 \$10374 \$7990 \$10062 \$10064 NWELL PWELL BULK MUX2_X1
X$25620 \$10697 \$7990 \$9501 \$10739 NWELL PWELL BULK MUX2_X1
X$25622 \$9770 \$7990 \$9767 \$9445 NWELL PWELL BULK MUX2_X1
X$25630 \$7997 \$8456 \$7992 \$8791 NWELL PWELL BULK MUX2_X1
X$25662 \$9447 \$8006 \$9160 \$9492 NWELL PWELL BULK MUX2_X1
X$25664 \$10713 \$8006 \$10062 \$10394 NWELL PWELL BULK MUX2_X1
X$25667 \$10395 \$8006 \$9501 \$10400 NWELL PWELL BULK MUX2_X1
X$25672 \$8512 \$8006 \$8443 \$8837 NWELL PWELL BULK MUX2_X1
X$25674 \$9446 \$8006 \$9767 \$9444 NWELL PWELL BULK MUX2_X1
X$25684 \$9500 \$8009 \$9501 \$9169 NWELL PWELL BULK MUX2_X1
X$25686 \$8450 \$8009 \$8443 \$8787 NWELL PWELL BULK MUX2_X1
X$25688 \$9455 \$8009 \$9160 \$10070 NWELL PWELL BULK MUX2_X1
X$25691 \$10376 \$8009 \$10062 \$11084 NWELL PWELL BULK MUX2_X1
X$25693 \$10694 \$8009 \$9767 \$11106 NWELL PWELL BULK MUX2_X1
X$25709 \$8684 \$9052 \$8014 NWELL PWELL BULK XNOR2_X1
X$25747 \$8428 \$8064 \$8069 NWELL PWELL BULK XNOR2_X1
X$25759 \$8072 \$8082 NWELL PWELL BULK INV_X1
X$25766 \$8526 \$8854 \$8076 \$8348 NWELL PWELL BULK MUX2_X1
X$25808 \$8114 \$15399 \$17250 \$16724 \$16921 \$14533 NWELL PWELL BULK
+ AOI221_X1
X$25812 \$10792 \$18006 \$18499 \$17739 \$18511 \$8114 \$18010 NWELL PWELL BULK
+ AOI222_X2
X$25816 \$15394 \$15393 \$15919 \$15390 \$8114 \$15388 NWELL PWELL BULK
+ AOI221_X1
X$25821 \$15619 \$8114 \$15923 \$15605 NWELL PWELL BULK AOI21_X2
X$25851 \$8134 \$9309 \$9380 \$8606 \$9935 NWELL PWELL BULK AOI22_X2
X$25853 \$8606 \$9606 \$8134 \$9389 \$10215 NWELL PWELL BULK AOI22_X1
X$25856 \$8134 \$9088 \$8725 \$8727 \$8967 NWELL PWELL BULK AOI22_X1
X$25861 \$9269 \$9537 \$9288 \$8134 \$11730 NWELL PWELL BULK NOR4_X4
X$25961 \$9381 \$9633 \$9383 \$8238 \$9729 NWELL PWELL BULK OAI22_X4
X$25998 \$9381 \$9086 \$9383 \$8253 \$9304 NWELL PWELL BULK OAI22_X4
X$26100 \$8338 \$8339 \$8817 \$8340 NWELL PWELL BULK HA_X1
X$26166 \$8982 \$8980 \$8730 \$8373 NWELL PWELL BULK MUX2_X1
X$26180 \$I178853 \$8645 \$8392 \$8751 NWELL PWELL BULK DFF_X1
X$26183 \$I174433 \$8397 \$8393 \$8751 NWELL PWELL BULK DFF_X1
X$26223 \$8420 \$8418 NWELL PWELL BULK INV_X1
X$26236 \$8426 \$9428 \$9554 NWELL PWELL BULK NAND2_X1
X$26239 \$8426 \$10043 \$9843 NWELL PWELL BULK NAND2_X1
X$26242 \$8426 \$9431 \$9430 NWELL PWELL BULK NAND2_X1
X$26245 \$8426 \$9758 \$9759 NWELL PWELL BULK NAND2_X1
X$26248 \$8426 \$8775 \$9151 NWELL PWELL BULK NAND2_X1
X$26250 \$8427 \$8426 NWELL PWELL BULK INV_X2
X$26253 \$8426 \$9150 \$9433 NWELL PWELL BULK NAND2_X1
X$26257 \$16934 \$10792 \$8427 NWELL PWELL BULK NAND2_X2
X$26260 \$8427 \$10682 \$11155 NWELL PWELL BULK NAND2_X1
X$26263 \$8427 \$9758 \$10112 NWELL PWELL BULK NAND2_X1
X$26266 \$8427 \$9833 \$9760 NWELL PWELL BULK NAND2_X1
X$26270 \$8427 \$9150 \$9549 NWELL PWELL BULK NAND2_X1
X$26272 \$8427 \$9154 \$9190 NWELL PWELL BULK NAND2_X1
X$26278 \$17624 \$16940 \$11796 \$11064 \$8428 \$15398 \$16934 NWELL PWELL BULK
+ OAI222_X2
X$26281 \$11064 \$14208 \$14530 \$8428 \$16960 \$17244 NWELL PWELL BULK
+ OAI221_X2
X$26284 \$8428 \$15916 \$16031 NWELL PWELL BULK AND2_X1
X$26286 \$8428 \$16943 NWELL PWELL BULK INV_X1
X$26288 \$15145 \$8428 \$13596 \$11064 \$16945 \$16951 NWELL PWELL BULK
+ OAI221_X2
X$26291 \$15388 \$8428 \$15917 NWELL PWELL BULK NOR2_X1
X$26312 \$8431 \$9154 \$10046 NWELL PWELL BULK XNOR2_X2
X$26319 \$17271 \$15941 \$9434 \$16297 \$16813 \$8443 NWELL PWELL BULK OAI221_X2
X$26333 \$8512 \$8456 \$8446 \$8812 NWELL PWELL BULK MUX2_X1
X$26337 \$9454 \$8447 \$9160 \$9479 NWELL PWELL BULK MUX2_X1
X$26339 \$9773 \$8447 \$9501 \$9772 NWELL PWELL BULK MUX2_X1
X$26341 \$10692 \$8447 \$9767 \$10754 NWELL PWELL BULK MUX2_X1
X$26346 \$10375 \$8447 \$10062 \$10065 NWELL PWELL BULK MUX2_X1
X$26366 \$8464 \$8456 \$8455 \$8789 NWELL PWELL BULK MUX2_X1
X$26374 \$9454 \$8456 \$9455 \$9464 NWELL PWELL BULK MUX2_X1
X$26377 \$10375 \$8456 \$10376 \$10699 NWELL PWELL BULK MUX2_X1
X$26379 \$10692 \$8456 \$10694 \$10412 NWELL PWELL BULK MUX2_X1
X$26382 \$9447 \$8456 \$9449 \$9470 NWELL PWELL BULK MUX2_X1
X$26385 \$9773 \$8456 \$9500 \$9775 NWELL PWELL BULK MUX2_X1
X$26387 \$10395 \$8456 \$10697 \$10061 NWELL PWELL BULK MUX2_X1
X$26389 \$10713 \$8456 \$10374 \$10704 NWELL PWELL BULK MUX2_X1
X$26391 \$9446 \$8456 \$9770 \$9771 NWELL PWELL BULK MUX2_X1
X$26547 \$8606 \$8970 NWELL PWELL BULK INV_X1
X$26614 \$8684 \$10280 NWELL PWELL BULK INV_X1
X$26618 \$8684 \$9343 \$10277 \$10266 NWELL PWELL BULK NOR3_X4
X$26627 \$9343 \$9339 \$8685 NWELL PWELL BULK XNOR2_X1
X$26642 \$8701 \$9606 \$9389 \$9076 \$9947 NWELL PWELL BULK AOI22_X2
X$26644 \$10290 \$9527 \$10489 \$8701 \$10874 NWELL PWELL BULK NOR4_X4
X$26646 \$8701 \$9092 NWELL PWELL BULK INV_X1
X$26648 \$9076 \$9309 \$9380 \$8701 \$9633 NWELL PWELL BULK AOI22_X2
X$26684 \$8725 \$9724 NWELL PWELL BULK INV_X1
X$26688 \$27091 \$27823 \$27665 \$8727 NWELL PWELL BULK NOR3_X4
X$26691 \$14155 \$9088 \$14146 \$8727 \$14075 NWELL PWELL BULK AOI22_X1
X$26693 \$14424 \$9088 \$14431 \$8727 \$14824 NWELL PWELL BULK AOI22_X1
X$26695 \$11385 \$9088 \$11746 \$8727 \$12454 NWELL PWELL BULK AOI22_X1
X$26698 \$10631 \$9088 \$11003 \$8727 \$11317 NWELL PWELL BULK AOI22_X1
X$26701 \$11736 \$9088 \$12044 \$8727 \$12048 NWELL PWELL BULK AOI22_X1
X$26703 \$12947 \$9088 \$8728 \$8727 \$12940 NWELL PWELL BULK AOI22_X1
X$26705 \$13284 \$9088 \$13798 \$8727 \$13795 NWELL PWELL BULK AOI22_X1
X$26708 \$9537 \$9088 \$9915 \$8727 \$9992 NWELL PWELL BULK AOI22_X1
X$26710 \$10521 \$9088 \$10994 \$8727 \$10996 NWELL PWELL BULK AOI22_X1
X$26713 \$15330 \$9088 \$15003 \$8727 \$16139 NWELL PWELL BULK AOI22_X1
X$26715 \$12392 \$9088 \$15332 \$8727 \$14448 NWELL PWELL BULK AOI22_X1
X$26718 \$20086 \$9088 \$19704 \$8727 \$23648 NWELL PWELL BULK AOI22_X1
X$26721 \$13790 \$9088 \$17484 \$8727 \$16210 NWELL PWELL BULK AOI22_X1
X$26724 \$16216 \$9088 \$17870 \$8727 \$18672 NWELL PWELL BULK AOI22_X1
X$26727 \$16970 \$9088 \$17217 \$8727 \$18279 NWELL PWELL BULK AOI22_X1
X$26732 \$9269 \$9088 \$9386 \$8727 \$9637 NWELL PWELL BULK AOI22_X1
X$26734 \$9076 \$9088 \$8947 \$8727 \$9324 NWELL PWELL BULK AOI22_X1
X$26769 \$8728 \$13309 NWELL PWELL BULK INV_X2
X$26794 \$8732 \$8980 \$8734 \$9000 NWELL PWELL BULK MUX2_X1
X$26842 \$I175991 \$12542 \$12959 \$8751 NWELL PWELL BULK DFF_X1
X$26844 \$I178737 \$12079 \$12679 \$8751 NWELL PWELL BULK DFF_X1
X$26846 \$I175393 \$11412 \$11411 \$8751 NWELL PWELL BULK DFF_X1
X$26848 \$I176760 \$11758 \$11897 \$8751 NWELL PWELL BULK DFF_X1
X$26853 \$I176638 \$9742 \$9646 \$8751 NWELL PWELL BULK DFF_X1
X$26855 \$I175381 \$10336 \$10337 \$8751 NWELL PWELL BULK DFF_X1
X$26858 \$I178766 \$10656 \$10655 \$8751 NWELL PWELL BULK DFF_X1
X$26861 \$I175686 \$10023 \$10230 \$8751 NWELL PWELL BULK DFF_X1
X$26864 \$I178765 \$10652 \$11277 \$8751 NWELL PWELL BULK DFF_X1
X$26867 \$I176793 \$10024 \$10341 \$8751 NWELL PWELL BULK DFF_X1
X$26870 \$I178691 \$10196 \$10513 \$8751 NWELL PWELL BULK DFF_X1
X$26873 \$I176768 \$9740 \$9917 \$8751 NWELL PWELL BULK DFF_X1
X$26875 \$I177143 \$13818 \$14063 \$8751 NWELL PWELL BULK DFF_X1
X$26877 \$I175276 \$13817 \$14067 \$8751 NWELL PWELL BULK DFF_X1
X$26879 \$I177302 \$12532 \$12530 \$8751 NWELL PWELL BULK DFF_X1
X$26882 \$I177271 \$12501 \$12502 \$8751 NWELL PWELL BULK DFF_X1
X$26885 \$I177263 \$11403 \$11910 \$8751 NWELL PWELL BULK DFF_X1
X$26888 \$I176784 \$10331 \$10014 \$8751 NWELL PWELL BULK DFF_X1
X$26891 \$I177344 \$10642 \$11016 \$8751 NWELL PWELL BULK DFF_X1
X$26893 \$I177262 \$10645 \$11334 \$8751 NWELL PWELL BULK DFF_X1
X$26895 \$I175746 \$10329 \$10550 \$8751 NWELL PWELL BULK DFF_X1
X$26897 \$I174595 \$11304 \$11630 \$8751 NWELL PWELL BULK DFF_X1
X$26900 \$I175214 \$11026 \$10648 \$8751 NWELL PWELL BULK DFF_X1
X$26903 \$I177300 \$10249 \$10332 \$8751 NWELL PWELL BULK DFF_X1
X$26905 \$I177160 \$11030 \$11286 \$8751 NWELL PWELL BULK DFF_X1
X$26907 \$I177363 \$12674 \$13367 \$8751 NWELL PWELL BULK DFF_X1
X$26910 \$I177251 \$12527 \$12673 \$8751 NWELL PWELL BULK DFF_X1
X$26912 \$I175316 \$11404 \$12520 \$8751 NWELL PWELL BULK DFF_X1
X$26955 \$9123 \$8758 \$8757 \$8963 NWELL PWELL BULK MUX2_X1
X$26961 \$11420 \$8758 \$11041 \$11421 NWELL PWELL BULK MUX2_X1
X$26964 \$19921 \$8758 \$19489 \$19488 NWELL PWELL BULK MUX2_X1
X$26966 \$22945 \$8758 \$23529 \$23023 NWELL PWELL BULK MUX2_X1
X$26968 \$9750 \$8758 \$10349 \$10156 NWELL PWELL BULK MUX2_X1
X$26970 \$18793 \$8758 \$18795 \$19357 NWELL PWELL BULK MUX2_X1
X$26973 \$14487 \$8758 NWELL PWELL BULK BUF_X16
X$26975 \$16262 \$8758 \$16263 \$16701 NWELL PWELL BULK MUX2_X1
X$26977 \$15028 \$8758 \$14490 \$14491 NWELL PWELL BULK MUX2_X1
X$26980 \$15033 \$8758 \$15036 \$15035 NWELL PWELL BULK MUX2_X1
X$26982 \$14492 \$8758 \$15796 \$14909 NWELL PWELL BULK MUX2_X1
X$26985 \$18792 \$8758 \$18410 \$18411 NWELL PWELL BULK MUX2_X1
X$26987 \$10857 \$8758 \$10345 \$10178 NWELL PWELL BULK MUX2_X1
X$26989 \$21019 \$8758 \$21018 \$21454 NWELL PWELL BULK MUX2_X1
X$26991 \$20135 \$8758 \$19893 \$19746 NWELL PWELL BULK MUX2_X1
X$26994 \$19745 \$8758 \$19138 \$20538 NWELL PWELL BULK MUX2_X1
X$26997 \$13390 \$8758 \$12096 \$12592 NWELL PWELL BULK MUX2_X1
X$26999 \$12967 \$8758 \$12817 \$13402 NWELL PWELL BULK MUX2_X1
X$27001 \$10487 \$8758 \$10163 \$10481 NWELL PWELL BULK MUX2_X1
X$27003 \$11040 \$8758 \$11247 \$11238 NWELL PWELL BULK MUX2_X1
X$27005 \$10031 \$8758 \$10865 \$10867 NWELL PWELL BULK MUX2_X1
X$27007 \$17480 \$8758 \$16694 \$17129 NWELL PWELL BULK MUX2_X1
X$27009 \$18418 \$8758 \$18797 \$18798 NWELL PWELL BULK MUX2_X1
X$27011 \$14187 \$8758 \$14004 \$13833 NWELL PWELL BULK MUX2_X1
X$27013 \$12694 \$8758 \$12695 \$11536 NWELL PWELL BULK MUX2_X1
X$27015 \$11044 \$8758 \$11537 \$11048 NWELL PWELL BULK MUX2_X1
X$27019 \$9622 \$8758 \$8961 \$8958 NWELL PWELL BULK MUX2_X1
X$27022 \$20132 \$8758 \$21009 \$19743 NWELL PWELL BULK MUX2_X1
X$27024 \$22947 \$8758 \$23501 \$22948 NWELL PWELL BULK MUX2_X1
X$27026 \$21011 \$8758 \$21013 \$21992 NWELL PWELL BULK MUX2_X1
X$27087 \$8775 \$9430 \$9193 NWELL PWELL BULK XNOR2_X1
X$27092 \$9533 \$9436 \$9536 \$8779 NWELL PWELL BULK HA_X1
X$27135 \$8846 \$8854 \$9360 \$9524 NWELL PWELL BULK MUX2_X1
X$27152 \$19683 \$8854 NWELL PWELL BULK BUF_X16
X$27154 \$19441 \$8854 \$20060 \$20386 NWELL PWELL BULK MUX2_X1
X$27156 \$18584 \$8854 \$19298 \$19306 NWELL PWELL BULK MUX2_X1
X$27159 \$9968 \$8854 \$10110 \$10613 NWELL PWELL BULK MUX2_X1
X$27162 \$10288 \$8854 \$10828 \$10483 NWELL PWELL BULK MUX2_X1
X$27165 \$16627 \$8854 \$16178 \$17375 NWELL PWELL BULK MUX2_X1
X$27167 \$17924 \$8854 \$18179 \$17782 NWELL PWELL BULK MUX2_X1
X$27170 \$17563 \$8854 \$17922 \$17565 NWELL PWELL BULK MUX2_X1
X$27172 \$13647 \$8854 \$12921 \$13660 NWELL PWELL BULK MUX2_X1
X$27175 \$13175 \$8854 \$13656 \$13444 NWELL PWELL BULK MUX2_X1
X$27178 \$21633 \$8854 \$20924 \$21374 NWELL PWELL BULK MUX2_X1
X$27180 \$21221 \$8854 \$20920 \$21231 NWELL PWELL BULK MUX2_X1
X$27182 \$15597 \$8854 \$15309 \$15604 NWELL PWELL BULK MUX2_X1
X$27184 \$16185 \$8854 \$15190 \$16920 NWELL PWELL BULK MUX2_X1
X$27186 \$14984 \$8854 \$14985 \$15310 NWELL PWELL BULK MUX2_X1
X$27188 \$9849 \$8854 \$9703 \$10486 NWELL PWELL BULK MUX2_X1
X$27190 \$11373 \$8854 \$10973 \$11204 NWELL PWELL BULK MUX2_X1
X$27192 \$18752 \$8854 \$18346 \$19100 NWELL PWELL BULK MUX2_X1
X$27194 \$15314 \$8854 \$14728 \$15850 NWELL PWELL BULK MUX2_X1
X$27197 \$16908 \$8854 \$16629 \$17393 NWELL PWELL BULK MUX2_X1
X$27199 \$17399 \$8854 \$17407 \$16632 NWELL PWELL BULK MUX2_X1
X$27201 \$17181 \$8854 \$17569 \$16919 NWELL PWELL BULK MUX2_X1
X$27204 \$19104 \$8854 \$18595 \$19308 NWELL PWELL BULK MUX2_X1
X$27246 \$8865 \$9606 \$9269 \$9389 \$10313 NWELL PWELL BULK AOI22_X1
X$27250 \$9269 \$9309 \$9380 \$8865 \$10239 NWELL PWELL BULK AOI22_X2
X$27255 \$8865 \$9631 NWELL PWELL BULK INV_X1
X$27271 \$11798 \$16732 \$15926 \$8881 \$16017 NWELL PWELL BULK OAI22_X2
X$27274 \$8881 \$17621 \$11798 \$17624 \$18141 NWELL PWELL BULK OAI22_X1
X$27331 \$8947 \$9729 NWELL PWELL BULK INV_X2
X$27349 \$I178170 \$8961 \$9126 \$9747 NWELL PWELL BULK DFF_X1
X$27365 \$31448 \$8980 \$27450 \$31631 NWELL PWELL BULK MUX2_X1
X$27367 \$14863 \$8980 \$14163 \$15244 NWELL PWELL BULK MUX2_X1
X$27371 \$12667 \$8980 \$12062 \$12951 NWELL PWELL BULK MUX2_X1
X$27374 \$16677 \$8980 \$16218 \$16675 NWELL PWELL BULK MUX2_X1
X$27377 \$10329 \$8980 \$10557 \$10550 NWELL PWELL BULK MUX2_X1
X$27380 \$17598 \$8980 \$17826 \$17530 NWELL PWELL BULK MUX2_X1
X$27382 \$14463 \$8980 \$14464 \$14905 NWELL PWELL BULK MUX2_X1
X$27384 \$30077 \$30081 \$30083 \$8980 NWELL PWELL BULK NOR3_X4
X$27388 \$31029 \$8980 \$27101 \$31423 NWELL PWELL BULK MUX2_X1
X$27391 \$14168 \$8980 \$14313 \$15233 NWELL PWELL BULK MUX2_X1
X$27393 \$18263 \$8980 \$17595 \$18268 NWELL PWELL BULK MUX2_X1
X$27396 \$12065 \$8980 \$12063 \$12486 NWELL PWELL BULK MUX2_X1
X$27400 \$10639 \$8980 \$10637 \$10939 NWELL PWELL BULK MUX2_X1
X$27402 \$15334 \$8980 \$15865 \$16550 NWELL PWELL BULK MUX2_X1
X$27404 \$20828 \$8980 \$19463 \$21283 NWELL PWELL BULK MUX2_X1
X$27517 \$9076 \$12392 \$12397 NWELL PWELL BULK NOR2_X2
X$27544 \$27091 \$27824 \$28507 \$9088 NWELL PWELL BULK NOR3_X4
X$27663 \$9123 \$9411 \$9124 \$9257 NWELL PWELL BULK MUX2_X1
X$27666 \$I178142 \$9123 \$9257 \$9747 NWELL PWELL BULK DFF_X1
X$27675 \$9381 \$9612 \$9383 \$9124 \$10003 NWELL PWELL BULK OAI22_X4
X$27712 \$9758 \$9150 \$9428 \$9431 NWELL PWELL BULK HA_X1
X$27733 \$9158 M1_AXI_BID[3] NWELL PWELL BULK BUF_X1
X$27744 \$15407 \$15940 \$15523 \$9160 NWELL PWELL BULK OR3_X2
X$27756 \$9162 M1_AXI_BRESP[0] NWELL PWELL BULK BUF_X1
X$27814 \$16719 \$16949 \$9204 \$15057 \$15399 \$16943 \$15390 NWELL PWELL BULK
+ AOI222_X2
X$27929 \$14432 \$9297 \$16206 \$20964 \$20966 NWELL PWELL BULK NOR4_X2
X$27931 \$21317 \$20079 \$14432 \$9297 \$16206 NWELL PWELL BULK OR4_X4
X$27933 \$16206 \$9297 \$14432 \$20079 \$20687 NWELL PWELL BULK NOR4_X4
X$27939 \$16206 \$9297 \$20953 NWELL PWELL BULK OR2_X1
X$27953 \$11736 \$9309 \$9380 \$10489 \$12434 NWELL PWELL BULK AOI22_X2
X$27955 \$14155 \$9309 \$9380 \$13791 \$14326 NWELL PWELL BULK AOI22_X2
X$27957 \$12947 \$9309 \$9380 \$13282 \$12054 NWELL PWELL BULK AOI22_X2
X$27959 \$13284 \$9309 \$9380 \$13261 \$13726 NWELL PWELL BULK AOI22_X2
X$27965 \$10521 \$9309 \$9380 \$9527 \$11308 NWELL PWELL BULK AOI22_X2
X$27967 \$11385 \$9309 \$9380 \$10982 \$12442 NWELL PWELL BULK AOI22_X2
X$27969 \$10631 \$9309 \$9380 \$10290 \$11009 NWELL PWELL BULK AOI22_X2
X$27971 \$14424 \$9309 \$9380 \$14436 \$15689 NWELL PWELL BULK AOI22_X2
X$27974 \$13790 \$9309 \$9380 \$16082 \$18269 NWELL PWELL BULK AOI22_X2
X$27976 \$15330 \$9309 \$9380 \$16208 \$16136 NWELL PWELL BULK AOI22_X2
X$27979 \$19457 \$9309 \$9380 \$18754 \$19659 NWELL PWELL BULK AOI22_X2
X$27981 \$20086 \$9309 \$9380 \$20087 \$20495 NWELL PWELL BULK AOI22_X2
X$27983 \$19455 \$19709 \$9309 NWELL PWELL BULK NOR2_X4
X$27985 \$16216 \$9309 \$9380 \$16666 \$17502 NWELL PWELL BULK AOI22_X2
X$27987 \$16970 \$9309 \$9380 \$16507 \$17875 NWELL PWELL BULK AOI22_X2
X$27989 \$12392 \$9309 \$9380 \$13452 \$14161 NWELL PWELL BULK AOI22_X2
X$27991 \$9537 \$9309 \$9380 \$9376 \$9612 NWELL PWELL BULK AOI22_X2
X$28053 \$10280 \$9343 \$10277 \$10282 NWELL PWELL BULK NOR3_X4
X$28068 \$I176670 \$9351 \$9696 \$10601 NWELL PWELL BULK DFF_X1
X$28098 \$9376 \$9600 NWELL PWELL BULK INV_X1
X$28103 \$9376 \$9606 \$9537 \$9389 \$10540 NWELL PWELL BULK AOI22_X1
X$28134 \$19455 \$19709 \$9380 NWELL PWELL BULK AND2_X4
X$28170 \$9381 \$17875 \$9383 \$16697 \$17949 NWELL PWELL BULK OAI22_X4
X$28172 \$24501 \$24502 \$9381 \$19735 NWELL PWELL BULK MUX2_X2
X$28174 \$20716 \$9381 \$20718 \$20726 NWELL PWELL BULK MUX2_X1
X$28176 \$24512 \$9381 \$25171 \$20123 NWELL PWELL BULK MUX2_X1
X$28179 \$9381 \$11308 \$9383 \$10352 \$11000 NWELL PWELL BULK OAI22_X4
X$28181 \$9381 \$13726 \$9383 \$12690 \$13464 NWELL PWELL BULK OAI22_X4
X$28183 \$25204 \$24862 \$9381 \$16257 NWELL PWELL BULK MUX2_X2
X$28185 \$20979 \$21652 \$9381 \$19486 NWELL PWELL BULK MUX2_X2
X$28187 \$9381 \$14161 \$9383 \$14181 \$15011 NWELL PWELL BULK OAI22_X4
X$28190 \$9381 \$14326 \$9383 \$13827 \$14156 NWELL PWELL BULK OAI22_X4
X$28193 \$23793 \$9381 \$24040 \$22942 NWELL PWELL BULK MUX2_X1
X$28196 \$9381 \$10239 \$9383 \$9745 \$10246 NWELL PWELL BULK OAI22_X4
X$28200 \$9381 \$9935 \$9383 \$9728 \$9724 NWELL PWELL BULK OAI22_X4
X$28203 \$24511 \$9381 \$24315 \$20602 NWELL PWELL BULK MUX2_X1
X$28205 \$9381 \$12442 \$9383 \$11032 \$12059 NWELL PWELL BULK OAI22_X4
X$28208 \$9381 \$11009 \$9383 \$11321 \$11011 NWELL PWELL BULK OAI22_X4
X$28212 \$9381 \$12054 \$9383 \$11424 \$13309 NWELL PWELL BULK OAI22_X4
X$28214 \$9381 \$12434 \$9383 \$11769 \$11741 NWELL PWELL BULK OAI22_X4
X$28217 \$9381 \$16136 \$9383 \$14189 \$15866 NWELL PWELL BULK OAI22_X4
X$28219 \$9381 \$15689 \$9383 \$13832 \$15257 NWELL PWELL BULK OAI22_X4
X$28221 \$9381 \$17502 \$9383 \$15349 \$16222 NWELL PWELL BULK OAI22_X4
X$28223 \$9381 \$19659 \$9383 \$17231 \$19714 NWELL PWELL BULK OAI22_X4
X$28226 \$19455 \$9381 \$20694 NWELL PWELL BULK XNOR2_X1
X$28228 \$9381 \$20495 \$9383 \$19137 \$19717 NWELL PWELL BULK OAI22_X4
X$28231 \$24476 \$24194 \$9381 NWELL PWELL BULK OR2_X4
X$28235 \$9381 \$18269 \$9383 \$18369 \$16663 NWELL PWELL BULK OAI22_X4
X$28320 \$9386 \$10246 NWELL PWELL BULK INV_X1
X$28323 \$14432 \$14146 \$9386 \$15003 \$14431 NWELL PWELL BULK OR4_X4
X$28328 \$16082 \$9606 \$9389 \$13790 \$17012 NWELL PWELL BULK AOI22_X2
X$28331 \$13791 \$9606 \$14155 \$9389 \$14334 NWELL PWELL BULK AOI22_X1
X$28333 \$13282 \$9606 \$9389 \$12947 \$12666 NWELL PWELL BULK AOI22_X2
X$28338 \$10982 \$9606 \$11385 \$9389 \$12456 NWELL PWELL BULK AOI22_X1
X$28341 \$13261 \$9606 \$9389 \$13284 \$13462 NWELL PWELL BULK AOI22_X2
X$28345 \$10290 \$9606 \$10631 \$9389 \$10927 NWELL PWELL BULK AOI22_X1
X$28350 \$9527 \$9606 \$10521 \$9389 \$10900 NWELL PWELL BULK AOI22_X1
X$28352 \$10489 \$9606 \$9389 \$11736 \$11665 NWELL PWELL BULK AOI22_X2
X$28354 \$16208 \$9606 \$15330 \$9389 \$16142 NWELL PWELL BULK AOI22_X1
X$28356 \$16666 \$9606 \$16216 \$9389 \$16215 NWELL PWELL BULK AOI22_X1
X$28358 \$14436 \$9606 \$9389 \$14424 \$14438 NWELL PWELL BULK AOI22_X2
X$28360 \$20087 \$9606 \$20086 \$9389 \$20489 NWELL PWELL BULK AOI22_X1
X$28364 \$18754 \$9606 \$9389 \$19457 \$19712 NWELL PWELL BULK AOI22_X2
X$28367 \$16507 \$9606 \$9389 \$16970 \$17495 NWELL PWELL BULK AOI22_X2
X$28369 \$13452 \$9606 \$12392 \$9389 \$15709 NWELL PWELL BULK AOI22_X1
X$28398 \$23228 \$22755 \$9389 NWELL PWELL BULK NOR2_X4
X$28445 \$12977 \$9411 \$11769 \$13634 NWELL PWELL BULK MUX2_X1
X$28448 \$10487 \$9411 \$9728 \$9883 NWELL PWELL BULK MUX2_X1
X$28451 \$21011 \$9411 \$20726 \$21449 NWELL PWELL BULK MUX2_X1
X$28453 \$15033 \$9411 \$14181 \$15354 NWELL PWELL BULK MUX2_X1
X$28455 \$10031 \$9411 \$9745 \$10180 NWELL PWELL BULK MUX2_X1
X$28457 \$18793 \$9411 \$18369 \$19366 NWELL PWELL BULK MUX2_X1
X$28459 \$14888 \$9411 \$14189 \$14897 NWELL PWELL BULK MUX2_X1
X$28461 \$12967 \$9411 \$12690 \$13655 NWELL PWELL BULK MUX2_X1
X$28463 \$11044 \$9411 \$11424 \$11552 NWELL PWELL BULK MUX2_X1
X$28465 \$11040 \$9411 \$11032 \$11248 NWELL PWELL BULK MUX2_X1
X$28467 \$12100 \$9411 \$11321 \$12571 NWELL PWELL BULK MUX2_X1
X$28469 \$19745 \$9411 \$19137 \$20553 NWELL PWELL BULK MUX2_X1
X$28471 \$18171 \$9411 \$16697 \$18172 NWELL PWELL BULK MUX2_X1
X$28473 \$17986 \$9411 \$16257 \$17985 NWELL PWELL BULK MUX2_X1
X$28477 \$22945 \$9411 \$22942 \$23558 NWELL PWELL BULK MUX2_X1
X$28479 \$9411 \$15887 NWELL PWELL BULK BUF_X8
X$28481 \$15028 \$9411 \$13832 \$15198 NWELL PWELL BULK MUX2_X1
X$28533 \$17271 \$16313 \$9434 \$15926 \$17687 \$18046 NWELL PWELL BULK
+ OAI221_X2
X$28536 \$9434 \$18475 NWELL PWELL BULK INV_X1
X$28588 \$I176018 \$9455 \$10070 \$10373 NWELL PWELL BULK DFF_X1
X$28603 \$12015 \$11378 \$9459 \$12344 NWELL PWELL BULK MUX2_X1
X$28614 \$9460 M1_AXI_BRESP[1] NWELL PWELL BULK BUF_X1
X$28686 \$9527 \$10627 NWELL PWELL BULK INV_X1
X$28742 \$14200 \$9559 \$15050 \$15680 NWELL PWELL BULK NOR3_X1
X$28744 \$14507 \$14857 \$14192 \$15048 \$9559 \$14200 \$14850 NWELL PWELL BULK
+ OAI33_X1
X$28747 \$14200 \$9559 \$14197 \$15165 NWELL PWELL BULK NOR3_X1
X$28757 \$14200 \$9559 \$14504 NWELL PWELL BULK NOR2_X4
X$28796 \$24493 \$23783 \$9606 NWELL PWELL BULK NOR2_X4
X$28866 \$I177066 \$9622 \$9625 \$9747 NWELL PWELL BULK DFF_X1
X$28918 \$15275 \$9683 \$14368 \$15273 NWELL PWELL BULK MUX2_X1
X$28921 \$9683 \$10726 \$11096 NWELL PWELL BULK NOR2_X1
X$28924 \$9683 \$11999 \$12000 NWELL PWELL BULK NOR2_X1
X$28926 \$12006 \$10789 \$9683 \$12302 NWELL PWELL BULK AOI21_X1
X$28928 \$9683 \$9684 \$9781 NWELL PWELL BULK NOR2_X1
X$28930 \$11096 \$11356 \$9683 \$10586 NWELL PWELL BULK AOI21_X1
X$28933 \$9683 \$10585 \$10946 NWELL PWELL BULK NOR2_X1
X$28936 \$9781 \$9955 \$9683 \$9956 NWELL PWELL BULK AOI21_X1
X$28938 \$9683 \$9961 \$10273 NWELL PWELL BULK NOR2_X1
X$28941 \$9683 \$13763 \$14683 NWELL PWELL BULK NOR2_X1
X$28944 \$14683 \$13117 \$9683 \$14394 NWELL PWELL BULK AOI21_X1
X$28947 \$9683 \$14113 \$13919 NWELL PWELL BULK NOR2_X1
X$28949 \$13919 \$13430 \$9683 \$13916 NWELL PWELL BULK AOI21_X1
X$28951 \$9683 \$14105 \$14376 NWELL PWELL BULK NOR2_X1
X$28954 \$12000 \$10965 \$9683 \$12293 NWELL PWELL BULK AOI21_X1
X$28956 \$14376 \$14104 \$9683 \$14633 NWELL PWELL BULK AOI21_X1
X$28959 \$9683 \$12823 \$12006 NWELL PWELL BULK NOR2_X1
X$28961 \$11974 \$11352 \$9683 \$12205 NWELL PWELL BULK AOI21_X1
X$28963 \$13055 \$12612 \$9683 \$13541 NWELL PWELL BULK AOI21_X1
X$28966 \$9683 \$13416 \$13055 NWELL PWELL BULK NOR2_X1
X$28968 \$13422 \$13750 \$9683 \$13562 NWELL PWELL BULK AOI21_X1
X$28970 \$9683 \$13751 \$13422 NWELL PWELL BULK NOR2_X1
X$28972 \$9683 \$11987 \$11985 NWELL PWELL BULK NOR2_X1
X$28975 \$21329 \$20886 \$9683 \$21327 NWELL PWELL BULK AOI21_X1
X$28977 \$9683 \$20884 \$21329 NWELL PWELL BULK NOR2_X1
X$28979 \$11985 \$11982 \$9683 \$11983 NWELL PWELL BULK AOI21_X1
X$28982 \$10273 \$10272 \$9683 \$10081 NWELL PWELL BULK AOI21_X1
X$28985 \$12897 \$12894 \$9683 \$12895 NWELL PWELL BULK AOI21_X1
X$28988 \$9683 \$13755 \$12897 NWELL PWELL BULK NOR2_X1
X$28990 \$9683 \$11491 \$11698 NWELL PWELL BULK NOR2_X1
X$28993 \$11698 \$11358 \$9683 \$11481 NWELL PWELL BULK AOI21_X1
X$28996 \$9683 \$15805 \$15423 NWELL PWELL BULK NOR2_X1
X$28999 \$9683 \$14088 \$14359 NWELL PWELL BULK NOR2_X1
X$29001 \$15423 \$14951 \$9683 \$15265 NWELL PWELL BULK AOI21_X1
X$29004 \$9683 \$17162 \$17317 NWELL PWELL BULK NOR2_X1
X$29006 \$17317 \$15813 \$9683 \$17548 NWELL PWELL BULK AOI21_X1
X$29008 \$17645 \$17156 \$9683 \$17154 NWELL PWELL BULK AOI21_X1
X$29010 \$9683 \$17287 \$17645 NWELL PWELL BULK NOR2_X1
X$29012 \$9683 \$20033 \$20032 NWELL PWELL BULK NOR2_X1
X$29014 \$20032 \$20229 \$9683 \$19665 NWELL PWELL BULK AOI21_X1
X$29017 \$9683 \$20034 \$20786 NWELL PWELL BULK NOR2_X1
X$29019 \$20786 \$20254 \$9683 \$19668 NWELL PWELL BULK AOI21_X1
X$29021 \$19226 \$17898 \$9683 \$19220 NWELL PWELL BULK AOI21_X1
X$29024 \$9683 \$18731 \$19226 NWELL PWELL BULK NOR2_X1
X$29027 \$9683 \$16606 \$16605 NWELL PWELL BULK NOR2_X1
X$29029 \$16605 \$15437 \$9683 \$16764 NWELL PWELL BULK AOI21_X1
X$29031 \$18487 \$17896 \$9683 \$18068 NWELL PWELL BULK AOI21_X1
X$29034 \$9683 \$18308 \$18487 NWELL PWELL BULK NOR2_X1
X$29037 \$20224 \$20027 \$9683 \$20627 NWELL PWELL BULK AOI21_X1
X$29040 \$9683 \$20030 \$20224 NWELL PWELL BULK NOR2_X1
X$29043 \$9683 \$17892 \$18466 NWELL PWELL BULK NOR2_X1
X$29045 \$18466 \$18303 \$9683 \$17889 NWELL PWELL BULK AOI21_X1
X$29048 \$16815 \$17326 \$9683 \$16810 NWELL PWELL BULK AOI21_X1
X$29050 \$18848 \$18845 \$9683 \$18718 NWELL PWELL BULK AOI21_X1
X$29053 \$9683 \$18722 \$18848 NWELL PWELL BULK NOR2_X1
X$29056 \$9683 \$16613 \$16815 NWELL PWELL BULK NOR2_X1
X$29058 \$9811 \$9683 \$9966 \$10782 NWELL PWELL BULK MUX2_X1
X$29060 \$9683 \$12868 \$12869 NWELL PWELL BULK NOR2_X1
X$29062 \$12869 \$11674 \$9683 \$12866 NWELL PWELL BULK AOI21_X1
X$29065 \$10946 \$10581 \$9683 \$10264 NWELL PWELL BULK AOI21_X1
X$29068 \$9683 \$11684 \$11974 NWELL PWELL BULK NOR2_X1
X$29071 \$10261 \$9683 \$10380 NWELL PWELL BULK OR2_X1
X$29074 \$14099 \$14095 \$9683 \$14237 NWELL PWELL BULK AOI21_X1
X$29076 \$19854 \$19563 \$9683 \$19856 NWELL PWELL BULK AOI21_X1
X$29079 \$9683 \$19081 \$19854 NWELL PWELL BULK NOR2_X1
X$29082 \$9683 \$19676 \$20036 NWELL PWELL BULK NOR2_X1
X$29085 \$20036 \$20283 \$9683 \$19424 NWELL PWELL BULK AOI21_X1
X$29088 \$9683 \$13879 \$14099 NWELL PWELL BULK NOR2_X1
X$29090 \$9683 \$11962 \$11960 NWELL PWELL BULK NOR2_X1
X$29093 \$14359 \$13738 \$9683 \$13867 NWELL PWELL BULK AOI21_X1
X$29095 \$11960 \$12610 \$9683 \$12176 NWELL PWELL BULK AOI21_X1
X$29098 \$9683 \$14370 \$14622 NWELL PWELL BULK NOR2_X1
X$29101 \$14622 \$13419 \$9683 \$14619 NWELL PWELL BULK AOI21_X1
X$29104 \$9683 \$18742 \$19264 NWELL PWELL BULK NOR2_X1
X$29106 \$19264 \$18329 \$9683 \$19260 NWELL PWELL BULK AOI21_X1
X$29108 \$9683 \$18563 \$19279 NWELL PWELL BULK NOR2_X1
X$29111 \$19279 \$19433 \$9683 \$18952 NWELL PWELL BULK AOI21_X1
X$29114 \$9683 \$20053 \$20052 NWELL PWELL BULK NOR2_X1
X$29117 \$20052 \$18745 \$9683 \$19686 NWELL PWELL BULK AOI21_X1
X$29121 \$9683 \$17356 \$17176 NWELL PWELL BULK NOR2_X1
X$29124 \$9683 \$16167 \$16859 NWELL PWELL BULK NOR2_X1
X$29126 \$17176 \$17755 \$9683 \$17354 NWELL PWELL BULK AOI21_X1
X$29129 \$16859 \$15525 \$9683 \$16850 NWELL PWELL BULK AOI21_X1
X$29131 \$9683 \$20660 \$21362 NWELL PWELL BULK NOR2_X1
X$29134 \$21362 \$21359 \$9683 \$21597 NWELL PWELL BULK AOI21_X1
X$29136 \$20321 \$20820 \$9683 \$20817 NWELL PWELL BULK AOI21_X1
X$29139 \$17728 \$17336 \$9683 \$17725 NWELL PWELL BULK AOI21_X1
X$29142 \$9683 \$17170 \$17728 NWELL PWELL BULK NOR2_X1
X$29145 \$20044 \$19425 \$9683 \$19427 NWELL PWELL BULK AOI21_X1
X$29148 \$9683 \$19428 \$20044 NWELL PWELL BULK NOR2_X1
X$29151 \$9683 \$15836 \$16032 NWELL PWELL BULK NOR2_X1
X$29153 \$16032 \$15832 \$9683 \$16619 NWELL PWELL BULK AOI21_X1
X$29155 \$16427 \$14390 \$9683 \$16165 NWELL PWELL BULK AOI21_X1
X$29158 \$9683 \$15291 \$16427 NWELL PWELL BULK NOR2_X1
X$29161 \$9683 \$20320 \$20321 NWELL PWELL BULK NOR2_X1
X$29163 \$9683 \$19091 \$19680 NWELL PWELL BULK NOR2_X1
X$29166 \$15302 \$13766 \$9683 \$15171 NWELL PWELL BULK AOI21_X1
X$29169 \$19680 \$18526 \$9683 \$19584 NWELL PWELL BULK AOI21_X1
X$29171 \$9683 \$15551 \$15549 NWELL PWELL BULK NOR2_X1
X$29174 \$15549 \$14973 \$9683 \$14972 NWELL PWELL BULK AOI21_X1
X$29177 \$9683 \$14691 \$15302 NWELL PWELL BULK NOR2_X1
X$29254 \$I176330 \$9684 \$9956 \$10263 NWELL PWELL BULK DFF_X1
X$29257 \$9782 \$9685 \$9684 \$10076 NWELL PWELL BULK MUX2_X1
X$29261 \$11972 \$9685 \$11684 \$11683 NWELL PWELL BULK MUX2_X1
X$29263 \$19085 \$9685 \$19428 \$19086 NWELL PWELL BULK MUX2_X1
X$29265 \$18325 \$9685 \$18738 \$20316 NWELL PWELL BULK MUX2_X1
X$29267 \$20042 \$9685 \$20309 \$21135 NWELL PWELL BULK MUX2_X1
X$29270 \$10717 \$9685 \$10585 \$11348 NWELL PWELL BULK MUX2_X1
X$29272 \$11699 \$9685 \$11491 \$12246 NWELL PWELL BULK MUX2_X1
X$29274 \$13753 \$9685 \$13755 \$13756 NWELL PWELL BULK MUX2_X1
X$29276 \$10961 \$9685 \$10756 \$10962 NWELL PWELL BULK MUX2_X1
X$29278 \$10408 \$9685 \$10270 \$10413 NWELL PWELL BULK MUX2_X1
X$29281 \$16163 \$9685 \$15836 \$16164 NWELL PWELL BULK MUX2_X1
X$29283 \$16617 \$9685 \$16836 \$16618 NWELL PWELL BULK MUX2_X1
X$29285 \$13428 \$9685 \$13096 \$12799 NWELL PWELL BULK MUX2_X1
X$29288 \$10948 \$9685 \$10726 \$11101 NWELL PWELL BULK MUX2_X1
X$29291 \$11690 \$9685 \$10952 \$10954 NWELL PWELL BULK MUX2_X1
X$29294 \$9689 \$9685 NWELL PWELL BULK BUF_X16
X$29296 \$13072 \$9685 \$11976 \$12775 NWELL PWELL BULK MUX2_X1
X$29298 \$13432 \$9685 \$14113 \$12907 NWELL PWELL BULK MUX2_X1
X$29301 \$12199 \$9685 \$11971 \$13060 NWELL PWELL BULK MUX2_X1
X$29303 \$9685 \$10578 NWELL PWELL BULK BUF_X16
X$29306 \$13105 \$9685 \$12903 \$13114 NWELL PWELL BULK MUX2_X1
X$29308 \$12257 \$9685 \$11987 \$12262 NWELL PWELL BULK MUX2_X1
X$29311 \$11981 \$9685 \$12787 \$12245 NWELL PWELL BULK MUX2_X1
X$29313 \$10590 \$9685 \$9961 \$11114 NWELL PWELL BULK MUX2_X1
X$29315 \$11680 \$9685 \$11965 \$11681 NWELL PWELL BULK MUX2_X1
X$29317 \$18328 \$9685 \$18131 \$17747 NWELL PWELL BULK MUX2_X1
X$29320 \$17911 \$9685 \$18742 \$17750 NWELL PWELL BULK MUX2_X1
X$29322 \$21143 \$9685 \$20320 \$20904 NWELL PWELL BULK MUX2_X1
X$29324 \$21155 \$9685 \$20650 \$20906 NWELL PWELL BULK MUX2_X1
X$29326 \$15503 \$9685 \$14112 \$14393 NWELL PWELL BULK MUX2_X1
X$29328 \$14387 \$9685 \$15285 \$14388 NWELL PWELL BULK MUX2_X1
X$29330 \$19089 \$9685 \$19091 \$19249 NWELL PWELL BULK MUX2_X1
X$29332 \$20292 \$9685 \$20899 \$20900 NWELL PWELL BULK MUX2_X1
X$29334 \$18321 \$9685 \$17170 \$18518 NWELL PWELL BULK MUX2_X1
X$29337 \$19572 \$9685 \$19676 \$20297 NWELL PWELL BULK MUX2_X1
X$29339 \$17557 \$9685 \$17909 \$17174 NWELL PWELL BULK MUX2_X1
X$29341 \$15517 \$9685 \$15291 \$15522 NWELL PWELL BULK MUX2_X1
X$29392 \$21361 \$9689 \$20660 \$21187 NWELL PWELL BULK MUX2_X1
X$29395 \$21603 \$9689 \$21777 \$21189 NWELL PWELL BULK MUX2_X1
X$29398 \$16166 \$9689 \$16167 \$16042 NWELL PWELL BULK MUX2_X1
X$29400 \$17360 \$9689 \$17356 \$16881 NWELL PWELL BULK MUX2_X1
X$29403 \$12004 \$9689 \$12823 \$11716 NWELL PWELL BULK MUX2_X1
X$29406 \$13943 \$9689 \$13620 \$13950 NWELL PWELL BULK MUX2_X1
X$29408 \$11998 \$9689 \$11999 \$11898 NWELL PWELL BULK MUX2_X1
X$29411 \$13762 \$9689 \$13763 \$13936 NWELL PWELL BULK MUX2_X1
X$29413 \$14117 \$9689 \$14691 \$14310 NWELL PWELL BULK MUX2_X1
X$29418 \$12910 \$9689 \$13610 \$13614 NWELL PWELL BULK MUX2_X1
X$29421 \$9964 \$9689 \$9804 \$9815 NWELL PWELL BULK MUX2_X1
X$29423 \$10093 \$9689 \$9811 \$9813 NWELL PWELL BULK MUX2_X1
X$29425 \$10968 \$9689 \$11163 \$11167 NWELL PWELL BULK MUX2_X1
X$29427 \$10602 \$9689 \$10780 \$11524 NWELL PWELL BULK MUX2_X1
X$29429 \$18746 \$9689 \$18335 \$18949 NWELL PWELL BULK MUX2_X1
X$29431 \$20048 \$9689 \$20053 \$19432 NWELL PWELL BULK MUX2_X1
X$29433 \$15526 \$9689 \$15841 \$15537 NWELL PWELL BULK MUX2_X1
X$29435 \$18337 \$9689 \$18563 \$17920 NWELL PWELL BULK MUX2_X1
X$29437 \$19688 \$9689 \$19609 \$18341 NWELL PWELL BULK MUX2_X1
X$29439 \$15844 \$9689 \$15562 \$16059 NWELL PWELL BULK MUX2_X1
X$29442 \$15298 \$9689 \$15551 \$15566 NWELL PWELL BULK MUX2_X1
X$29445 \$16624 \$9689 \$17562 \$16882 NWELL PWELL BULK MUX2_X1
X$29479 \$9693 \$10084 NWELL PWELL BULK BUF_X16
X$29518 \$I175367 \$9694 \$10100 \$10601 NWELL PWELL BULK DFF_X1
X$29523 \$I175107 \$10110 \$9699 \$9967 NWELL PWELL BULK DFF_X1
X$29526 \$I174401 \$9703 \$9702 \$9967 NWELL PWELL BULK DFF_X1
X$29546 \$24933 \$24168 \$24450 \$9707 NWELL PWELL BULK NOR3_X4
X$29559 \$18371 \$9707 NWELL PWELL BULK BUF_X8
X$29620 \$9718 \$20084 NWELL PWELL BULK BUF_X8
X$29700 \$I176966 \$12096 \$12692 \$9747 NWELL PWELL BULK DFF_X1
X$29703 \$I174584 \$13390 \$12968 \$9747 NWELL PWELL BULK DFF_X1
X$29705 \$I177509 \$11420 \$12597 \$9747 NWELL PWELL BULK DFF_X1
X$29707 \$I177273 \$12817 \$12818 \$9747 NWELL PWELL BULK DFF_X1
X$29710 \$I175630 \$14187 \$14012 \$9747 NWELL PWELL BULK DFF_X1
X$29712 \$I175027 \$10487 \$9883 \$9747 NWELL PWELL BULK DFF_X1
X$29715 \$I175796 \$11040 \$11248 \$9747 NWELL PWELL BULK DFF_X1
X$29718 \$I175935 \$10163 \$9748 \$9747 NWELL PWELL BULK DFF_X1
X$29720 \$I175912 \$11041 \$11043 \$9747 NWELL PWELL BULK DFF_X1
X$29723 \$I175862 \$11247 \$11590 \$9747 NWELL PWELL BULK DFF_X1
X$29725 \$I177113 \$11537 \$11770 \$9747 NWELL PWELL BULK DFF_X1
X$29727 \$I177110 \$12551 \$11427 \$9747 NWELL PWELL BULK DFF_X1
X$29730 \$I178236 \$10349 \$10477 \$9747 NWELL PWELL BULK DFF_X1
X$29732 \$I177162 \$10857 \$11254 \$9747 NWELL PWELL BULK DFF_X1
X$29734 \$I177279 \$10345 \$10500 \$9747 NWELL PWELL BULK DFF_X1
X$29736 \$I178241 \$11044 \$11552 \$9747 NWELL PWELL BULK DFF_X1
X$29739 \$I175716 \$10031 \$10180 \$9747 NWELL PWELL BULK DFF_X1
X$29743 \$I177149 \$10138 \$10037 \$9747 NWELL PWELL BULK DFF_X1
X$29746 \$I177214 \$10036 \$11203 \$9747 NWELL PWELL BULK DFF_X1
X$29748 \$I177212 \$10147 \$10459 \$9747 NWELL PWELL BULK DFF_X1
X$29751 \$I178237 \$12694 \$12815 \$9747 NWELL PWELL BULK DFF_X1
X$29756 \$I175970 \$12695 \$12970 \$9747 NWELL PWELL BULK DFF_X1
X$29758 \$I175456 \$10666 \$10664 \$9747 NWELL PWELL BULK DFF_X1
X$29760 \$I175457 \$10356 \$10034 \$9747 NWELL PWELL BULK DFF_X1
X$29762 \$I176001 \$10668 \$11213 \$9747 NWELL PWELL BULK DFF_X1
X$29765 \$I177180 \$11049 \$11219 \$9747 NWELL PWELL BULK DFF_X1
X$29767 \$I175971 \$12100 \$12571 \$9747 NWELL PWELL BULK DFF_X1
X$29858 \$10392 \$9955 \$9954 \$9777 NWELL PWELL BULK AOI21_X1
X$29867 \$10266 \$9782 \$10392 NWELL PWELL BULK NOR2_X1
X$29880 \$I175418 \$9804 \$10091 \$10601 NWELL PWELL BULK DFF_X1
X$29882 \$9804 \$10262 \$9966 \$10091 NWELL PWELL BULK MUX2_X1
X$29889 \$I175554 \$9811 \$10782 \$10601 NWELL PWELL BULK DFF_X1
X$29912 \$10099 \$9833 \$10437 NWELL PWELL BULK XNOR2_X2
X$29979 \$I174480 \$9886 \$9884 \$10620 NWELL PWELL BULK DFF_X1
X$29999 \$23104 \$17201 \$10874 \$9911 \$24809 NWELL PWELL BULK NAND4_X1
X$30001 \$9911 \$10874 \$17201 \$23104 \$25911 NWELL PWELL BULK AND4_X1
X$30004 \$20685 \$14798 \$9911 \$10874 \$21738 NWELL PWELL BULK NAND4_X4
X$30007 \$14798 \$20685 \$10874 \$9911 \$21697 NWELL PWELL BULK AND4_X4
X$30012 \$9911 \$10874 \$17201 \$21821 NWELL PWELL BULK AND3_X1
X$30015 \$17201 \$10874 \$9911 \$23205 NWELL PWELL BULK NAND3_X2
X$30026 \$9915 \$10003 NWELL PWELL BULK INV_X1
X$30028 \$9915 \$13798 \$16206 NWELL PWELL BULK OR2_X2
X$30066 \$9954 \$10266 NWELL PWELL BULK BUF_X8
X$30070 \$9954 \$10948 \$11355 NWELL PWELL BULK NOR2_X1
X$30072 \$11355 \$11356 \$9954 \$11470 NWELL PWELL BULK AOI21_X1
X$30074 \$14367 \$12612 \$9954 \$14366 NWELL PWELL BULK AOI21_X1
X$30077 \$9954 \$13743 \$14367 NWELL PWELL BULK NOR2_X1
X$30080 \$20882 \$20886 \$9954 \$21920 NWELL PWELL BULK AOI21_X1
X$30082 \$9954 \$21325 \$20882 NWELL PWELL BULK NOR2_X1
X$30084 \$16598 \$14951 \$9954 \$16331 NWELL PWELL BULK AOI21_X1
X$30087 \$9954 \$16148 \$16598 NWELL PWELL BULK NOR2_X1
X$30090 \$15439 \$15437 \$9954 \$15808 NWELL PWELL BULK AOI21_X1
X$30093 \$9954 \$16152 \$15439 NWELL PWELL BULK NOR2_X1
X$30096 \$17676 \$18303 \$9954 \$17673 NWELL PWELL BULK AOI21_X1
X$30099 \$9954 \$17893 \$17676 NWELL PWELL BULK NOR2_X1
X$30102 \$9954 \$18024 \$18717 NWELL PWELL BULK NOR2_X1
X$30104 \$9954 \$19413 \$19526 NWELL PWELL BULK NOR2_X1
X$30106 \$18717 \$17156 \$9954 \$18450 NWELL PWELL BULK AOI21_X1
X$30108 \$19526 \$18845 \$9954 \$19184 NWELL PWELL BULK AOI21_X1
X$30110 \$12162 \$11674 \$9954 \$12604 NWELL PWELL BULK AOI21_X1
X$30112 \$9954 \$11957 \$12162 NWELL PWELL BULK NOR2_X1
X$30114 \$10944 \$10581 \$9954 \$10709 NWELL PWELL BULK AOI21_X1
X$30117 \$9954 \$10717 \$10944 NWELL PWELL BULK NOR2_X1
X$30120 \$9954 \$11972 \$11837 NWELL PWELL BULK NOR2_X1
X$30123 \$11837 \$11352 \$9954 \$11349 NWELL PWELL BULK AOI21_X1
X$30126 \$11081 \$9954 \$11079 NWELL PWELL BULK OR2_X1
X$30128 \$9954 \$11677 \$11676 NWELL PWELL BULK NOR2_X1
X$30131 \$11676 \$12610 \$9954 \$12173 NWELL PWELL BULK AOI21_X1
X$30134 \$9954 \$13413 \$12881 NWELL PWELL BULK NOR2_X1
X$30137 \$15453 \$9954 \$14368 \$15455 NWELL PWELL BULK MUX2_X1
X$30139 \$12881 \$14095 \$9954 \$13537 NWELL PWELL BULK AOI21_X1
X$30142 \$9954 \$14569 \$14568 NWELL PWELL BULK NOR2_X1
X$30145 \$14568 \$13738 \$9954 \$14355 NWELL PWELL BULK AOI21_X1
X$30177 \$10268 \$10262 \$9955 \$9958 NWELL PWELL BULK AOI21_X1
X$30180 \$10404 \$9955 \$10406 \$10734 NWELL PWELL BULK AOI21_X1
X$30183 \$9955 \$35209 \$26622 \$32461 NWELL PWELL BULK AOI21_X4
X$30192 \$I176572 \$10270 \$9958 \$9959 NWELL PWELL BULK DFF_X1
X$30195 \$I176305 \$10952 \$11851 \$9959 NWELL PWELL BULK DFF_X1
X$30197 \$I178378 \$13891 \$13555 \$9959 NWELL PWELL BULK DFF_X1
X$30199 \$I175530 \$14105 \$14633 \$9959 NWELL PWELL BULK DFF_X1
X$30201 \$I178344 \$14374 \$14630 \$9959 NWELL PWELL BULK DFF_X1
X$30204 \$I178388 \$14370 \$14619 \$9959 NWELL PWELL BULK DFF_X1
X$30207 \$I177833 \$14380 \$14270 \$9959 NWELL PWELL BULK DFF_X1
X$30209 \$I177838 \$13751 \$13562 \$9959 NWELL PWELL BULK DFF_X1
X$30211 \$I177771 \$13755 \$12895 \$9959 NWELL PWELL BULK DFF_X1
X$30213 \$I176591 \$13753 \$13752 \$9959 NWELL PWELL BULK DFF_X1
X$30217 \$I176509 \$13428 \$13757 \$9959 NWELL PWELL BULK DFF_X1
X$30220 \$I177730 \$13105 \$13906 \$9959 NWELL PWELL BULK DFF_X1
X$30222 \$I176457 \$13096 \$12899 \$9959 NWELL PWELL BULK DFF_X1
X$30225 \$I176548 \$10408 \$10734 \$9959 NWELL PWELL BULK DFF_X1
X$30227 \$I176507 \$12257 \$12244 \$9959 NWELL PWELL BULK DFF_X1
X$30230 \$I176533 \$11981 \$12616 \$9959 NWELL PWELL BULK DFF_X1
X$30233 \$I176588 \$12787 \$13080 \$9959 NWELL PWELL BULK DFF_X1
X$30235 \$I177697 \$11491 \$11481 \$9959 NWELL PWELL BULK DFF_X1
X$30238 \$I178114 \$16611 \$17320 \$9959 NWELL PWELL BULK DFF_X1
X$30241 \$I175726 \$15277 \$15470 \$9959 NWELL PWELL BULK DFF_X1
X$30244 \$I178117 \$14962 \$14963 \$9959 NWELL PWELL BULK DFF_X1
X$30247 \$I178187 \$15453 \$15455 \$9959 NWELL PWELL BULK DFF_X1
X$30249 \$I175780 \$15275 \$15273 \$9959 NWELL PWELL BULK DFF_X1
X$30252 \$I178178 \$15279 \$16004 \$9959 NWELL PWELL BULK DFF_X1
X$30254 \$I178116 \$15991 \$15999 \$9959 NWELL PWELL BULK DFF_X1
X$30257 \$I178227 \$16811 \$17324 \$9959 NWELL PWELL BULK DFF_X1
X$30260 \$I178380 \$11690 \$11687 \$9959 NWELL PWELL BULK DFF_X1
X$30263 \$I176296 \$14112 \$14662 \$9959 NWELL PWELL BULK DFF_X1
X$30265 \$I177786 \$15282 \$14379 \$9959 NWELL PWELL BULK DFF_X1
X$30268 \$I177755 \$11699 \$11695 \$9959 NWELL PWELL BULK DFF_X1
X$30299 \$9964 \$10282 \$9966 \$10441 NWELL PWELL BULK MUX2_X1
X$30303 \$10093 \$9965 \$9966 \$10097 NWELL PWELL BULK MUX2_X1
X$30305 \$9965 \$11998 \$11707 NWELL PWELL BULK NOR2_X1
X$30308 \$9965 \$12004 \$12626 NWELL PWELL BULK NOR2_X1
X$30310 \$14116 \$13766 \$9965 \$14684 NWELL PWELL BULK AOI21_X1
X$30313 \$9965 \$14117 \$14116 NWELL PWELL BULK NOR2_X1
X$30316 \$13113 \$13430 \$9965 \$12904 NWELL PWELL BULK AOI21_X1
X$30320 \$9965 \$13432 \$13113 NWELL PWELL BULK NOR2_X1
X$30322 \$12626 \$10789 \$9965 \$11711 NWELL PWELL BULK AOI21_X1
X$30325 \$13436 \$13117 \$9965 \$13925 NWELL PWELL BULK AOI21_X1
X$30328 \$9965 \$13762 \$13436 NWELL PWELL BULK NOR2_X1
X$30331 \$9965 \$10266 NWELL PWELL BULK BUF_X8
X$30334 \$11707 \$10965 \$9965 \$12287 NWELL PWELL BULK AOI21_X1
X$30336 \$9965 \$17911 \$17913 NWELL PWELL BULK NOR2_X1
X$30338 \$17913 \$18329 \$9965 \$18130 NWELL PWELL BULK AOI21_X1
X$30341 \$17759 \$17755 \$9965 \$17915 NWELL PWELL BULK AOI21_X1
X$30344 \$9965 \$18337 \$18560 NWELL PWELL BULK NOR2_X1
X$30347 \$18560 \$19433 \$9965 \$18556 NWELL PWELL BULK AOI21_X1
X$30350 \$20351 \$18745 \$9965 \$20345 NWELL PWELL BULK AOI21_X1
X$30353 \$9965 \$20048 \$20351 NWELL PWELL BULK NOR2_X1
X$30355 \$16050 \$14973 \$9965 \$16434 NWELL PWELL BULK AOI21_X1
X$30358 \$9965 \$15298 \$16050 NWELL PWELL BULK NOR2_X1
X$30361 \$9965 \$17360 \$17759 NWELL PWELL BULK NOR2_X1
X$30363 \$9965 \$16166 \$16851 NWELL PWELL BULK NOR2_X1
X$30365 \$16851 \$15525 \$9965 \$16428 NWELL PWELL BULK AOI21_X1
X$30367 \$21770 \$21359 \$9965 \$21357 NWELL PWELL BULK AOI21_X1
X$30370 \$9965 \$21361 \$21770 NWELL PWELL BULK NOR2_X1
X$30373 \$15835 \$14390 \$9965 \$15504 NWELL PWELL BULK AOI21_X1
X$30376 \$16162 \$15832 \$9965 \$16412 NWELL PWELL BULK AOI21_X1
X$30378 \$9965 \$16163 \$16162 NWELL PWELL BULK NOR2_X1
X$30380 \$9965 \$15517 \$15835 NWELL PWELL BULK NOR2_X1
X$30404 \$33352 \$33061 \$9966 NWELL PWELL BULK NOR2_X2
X$30417 \$I174313 \$13777 \$13966 \$9967 NWELL PWELL BULK DFF_X1
X$30419 \$I175113 \$12921 \$13159 \$9967 NWELL PWELL BULK DFF_X1
X$30422 \$I177510 \$13779 \$13778 \$9967 NWELL PWELL BULK DFF_X1
X$30425 \$I175126 \$13175 \$13172 \$9967 NWELL PWELL BULK DFF_X1
X$30428 \$I177561 \$10610 \$11188 \$9967 NWELL PWELL BULK DFF_X1
X$30430 \$I174348 \$12014 \$12630 \$9967 NWELL PWELL BULK DFF_X1
X$30433 \$I174309 \$9968 \$10105 \$9967 NWELL PWELL BULK DFF_X1
X$30436 \$I177489 \$10973 \$11577 \$9967 NWELL PWELL BULK DFF_X1
X$30438 \$I174284 \$11373 \$11572 \$9967 NWELL PWELL BULK DFF_X1
X$30441 \$I177559 \$12915 \$13149 \$9967 NWELL PWELL BULK DFF_X1
X$30444 \$I174353 \$12634 \$12918 \$9967 NWELL PWELL BULK DFF_X1
X$30447 \$I177296 \$16185 \$16464 \$9967 NWELL PWELL BULK DFF_X1
X$30449 \$I177517 \$15190 \$15607 \$9967 NWELL PWELL BULK DFF_X1
X$30451 \$I175301 \$15314 \$16084 \$9967 NWELL PWELL BULK DFF_X1
X$30454 \$I175106 \$13647 \$13975 \$9967 NWELL PWELL BULK DFF_X1
X$30458 \$I175128 \$13656 \$13782 \$9967 NWELL PWELL BULK DFF_X1
X$30461 \$I177483 \$12015 \$12344 \$9967 NWELL PWELL BULK DFF_X1
X$30464 \$I177478 \$11374 \$11934 \$9967 NWELL PWELL BULK DFF_X1
X$30467 \$I176788 \$11377 \$11722 \$9967 NWELL PWELL BULK DFF_X1
X$30471 \$I177393 \$10288 \$10471 \$9967 NWELL PWELL BULK DFF_X1
X$30473 \$I174305 \$11561 \$11562 \$9967 NWELL PWELL BULK DFF_X1
X$30477 \$I174627 \$11208 \$11587 \$9967 NWELL PWELL BULK DFF_X1
X$30479 \$I177428 \$10828 \$10976 \$9967 NWELL PWELL BULK DFF_X1
X$30481 \$I175714 \$14984 \$14713 \$9967 NWELL PWELL BULK DFF_X1
X$30484 \$I176072 \$13784 \$13447 \$9967 NWELL PWELL BULK DFF_X1
X$30487 \$I175675 \$14985 \$14717 \$9967 NWELL PWELL BULK DFF_X1
X$30490 \$I175791 \$14728 \$14407 \$9967 NWELL PWELL BULK DFF_X1
X$30493 \$I175722 \$13448 \$13667 \$9967 NWELL PWELL BULK DFF_X1
X$30588 \$I177724 \$10029 \$10508 \$11033 NWELL PWELL BULK DFF_X1
X$30607 \$10365 \$10682 \$10045 NWELL PWELL BULK XNOR2_X2
X$30609 \$10437 \$10046 \$10045 \$11798 NWELL PWELL BULK AND3_X4
X$30611 \$10046 \$10045 \$10437 \$10792 NWELL PWELL BULK NAND3_X4
X$30626 \$12142 \$11814 \$10058 \$I241539 NWELL PWELL BULK HA_X1
X$30628 \$10369 \$10058 \$10059 \$10090 NWELL PWELL BULK MUX2_X1
X$30630 \$10058 \$11067 \$11110 NWELL PWELL BULK NOR2_X1
X$30633 \$11110 \$10370 \$10058 \$10690 NWELL PWELL BULK AOI21_X1
X$30635 \$11133 \$10058 \$11804 NWELL PWELL BULK NOR2_X1
X$30641 \$10370 \$11135 \$11067 \$11132 \$10059 NWELL PWELL BULK FA_X1
X$30661 \$I177107 \$10374 \$10064 \$10373 NWELL PWELL BULK DFF_X1
X$30664 \$I178750 \$10375 \$10065 \$10373 NWELL PWELL BULK DFF_X1
X$30678 \$10083 M1_AXI_BID[0] NWELL PWELL BULK BUF_X1
X$30687 \$19249 \$10084 \$20316 \$20045 NWELL PWELL BULK MUX2_X1
X$30689 \$20297 \$10084 \$20900 \$23134 NWELL PWELL BULK MUX2_X1
X$30692 \$19086 \$10084 \$21135 \$21138 NWELL PWELL BULK MUX2_X1
X$30694 \$20904 \$10084 \$20906 \$21570 NWELL PWELL BULK MUX2_X1
X$30697 \$21936 \$10084 \$21944 \$22836 NWELL PWELL BULK MUX2_X1
X$30699 \$18473 \$10084 \$18854 \$18863 NWELL PWELL BULK MUX2_X1
X$30702 \$18029 \$10084 \$16601 \$18034 NWELL PWELL BULK MUX2_X1
X$30704 \$19807 \$10084 \$20198 \$20193 NWELL PWELL BULK MUX2_X1
X$30706 \$18732 \$10084 \$18500 \$18494 NWELL PWELL BULK MUX2_X1
X$30709 \$16156 \$10084 \$16378 \$16796 NWELL PWELL BULK MUX2_X1
X$30711 \$12872 \$10084 \$12607 \$13026 NWELL PWELL BULK MUX2_X1
X$30714 \$11348 \$10084 \$11681 \$11833 NWELL PWELL BULK MUX2_X1
X$30716 \$16757 \$10084 \$16761 \$16759 NWELL PWELL BULK MUX2_X1
X$30724 \$17720 \$10084 \$18093 \$19076 NWELL PWELL BULK MUX2_X1
X$30728 \$11683 \$10084 \$12775 \$12884 NWELL PWELL BULK MUX2_X1
X$30731 \$14257 \$10084 \$14101 \$14253 NWELL PWELL BULK MUX2_X1
X$30734 \$13744 \$10084 \$13060 \$13544 NWELL PWELL BULK MUX2_X1
X$30736 \$20629 \$10084 \$21524 \$24417 NWELL PWELL BULK MUX2_X1
X$30738 \$16793 \$10084 \$16155 \$16791 NWELL PWELL BULK MUX2_X1
X$30741 \$16607 \$10084 \$16780 \$16775 NWELL PWELL BULK MUX2_X1
X$30744 \$15481 \$10084 \$15281 \$16157 NWELL PWELL BULK MUX2_X1
X$30746 \$19547 \$10084 \$18729 \$20231 NWELL PWELL BULK MUX2_X1
X$30748 \$10941 \$10084 \$10703 \$11459 NWELL PWELL BULK MUX2_X1
X$30750 \$13741 \$10084 \$14604 \$14242 NWELL PWELL BULK MUX2_X1
X$30753 \$20273 \$10084 \$20803 \$20641 NWELL PWELL BULK MUX2_X1
X$30755 \$13036 \$10084 \$12879 \$15095 NWELL PWELL BULK MUX2_X1
X$30757 \$14578 \$10084 \$14586 \$15085 NWELL PWELL BULK MUX2_X1
X$30759 \$14381 \$10084 \$16401 \$16020 NWELL PWELL BULK MUX2_X1
X$30762 \$21341 \$10084 \$21342 \$21982 NWELL PWELL BULK MUX2_X1
X$30764 \$18518 \$10084 \$16618 \$19245 NWELL PWELL BULK MUX2_X1
X$30766 \$20632 \$10084 \$21535 \$21091 NWELL PWELL BULK MUX2_X1
X$30827 \$I175558 \$10093 \$10097 \$10601 NWELL PWELL BULK DFF_X1
X$30840 \$10099 \$10772 NWELL PWELL BULK INV_X2
X$30843 \$10685 \$10681 \$I245740 \$10099 NWELL PWELL BULK DFF_X2
X$30862 \$12727 \$10106 \$11447 \$12763 NWELL PWELL BULK MUX2_X1
X$30864 \$12328 \$10106 \$12731 \$13923 NWELL PWELL BULK MUX2_X1
X$30867 \$13505 \$10106 \$13585 \$13924 NWELL PWELL BULK MUX2_X1
X$30869 \$13007 \$10106 \$13082 \$13509 NWELL PWELL BULK MUX2_X1
X$30872 \$12737 \$10106 \$12307 \$13079 NWELL PWELL BULK MUX2_X1
X$30875 \$17315 \$10106 \$17275 \$16783 NWELL PWELL BULK MUX2_X1
X$30877 \$14536 \$10106 \$15058 \$14540 NWELL PWELL BULK MUX2_X1
X$30879 \$16439 \$10106 \$16012 \$16295 NWELL PWELL BULK MUX2_X1
X$30881 \$17713 \$10106 \$18009 \$17365 NWELL PWELL BULK MUX2_X1
X$30883 \$14552 \$10106 \$14553 \$14649 NWELL PWELL BULK MUX2_X1
X$30885 \$16317 \$10106 \$16355 \$16789 NWELL PWELL BULK MUX2_X1
X$30888 \$12350 \$10106 \$12134 \$12724 NWELL PWELL BULK MUX2_X1
X$30890 \$13501 \$10106 \$13849 \$15060 NWELL PWELL BULK MUX2_X1
X$30892 \$12318 \$10106 \$11450 \$12734 NWELL PWELL BULK MUX2_X1
X$30896 \$14543 \$10106 \$14677 \$15066 NWELL PWELL BULK MUX2_X1
X$30898 \$14667 \$10106 \$14660 \$14672 NWELL PWELL BULK MUX2_X1
X$31012 \$11081 \$10578 \$10261 \$10941 NWELL PWELL BULK MUX2_X1
X$31015 \$I178030 \$10261 \$10380 \$10263 NWELL PWELL BULK DFF_X1
X$31018 \$15991 \$10262 \$14368 \$15999 NWELL PWELL BULK MUX2_X1
X$31021 \$10262 \$11976 \$11353 NWELL PWELL BULK NOR2_X1
X$31024 \$11353 \$10262 \$11352 \$11469 NWELL PWELL BULK AOI21_X1
X$31027 \$10262 \$13620 \$12912 NWELL PWELL BULK NOR2_X1
X$31029 \$10960 \$10262 \$10272 \$10594 NWELL PWELL BULK AOI21_X1
X$31032 \$10262 \$10756 \$10960 NWELL PWELL BULK NOR2_X1
X$31035 \$10262 \$12885 \$13420 NWELL PWELL BULK NOR2_X1
X$31037 \$10262 \$11971 \$13052 NWELL PWELL BULK NOR2_X1
X$31039 \$13052 \$10262 \$12612 \$13054 NWELL PWELL BULK AOI21_X1
X$31041 \$12912 \$10262 \$13766 \$13618 NWELL PWELL BULK AOI21_X1
X$31043 \$14114 \$10262 \$13117 \$13764 NWELL PWELL BULK AOI21_X1
X$31046 \$13420 \$10262 \$13419 \$13061 NWELL PWELL BULK AOI21_X1
X$31048 \$10262 \$13610 \$14114 NWELL PWELL BULK NOR2_X1
X$31051 \$10262 \$21754 \$21751 NWELL PWELL BULK NOR2_X1
X$31054 \$21751 \$10262 \$20027 \$21953 NWELL PWELL BULK AOI21_X1
X$31057 \$13911 \$10262 \$13430 \$12901 NWELL PWELL BULK AOI21_X1
X$31059 \$14665 \$10262 \$14390 \$14662 NWELL PWELL BULK AOI21_X1
X$31062 \$10262 \$12903 \$13911 NWELL PWELL BULK NOR2_X1
X$31065 \$20625 \$10262 \$20886 \$21069 NWELL PWELL BULK AOI21_X1
X$31068 \$10262 \$20887 \$20625 NWELL PWELL BULK NOR2_X1
X$31071 \$12621 \$10262 \$11982 \$12899 NWELL PWELL BULK AOI21_X1
X$31074 \$10262 \$13096 \$12621 NWELL PWELL BULK NOR2_X1
X$31077 \$10262 \$10270 \$10268 NWELL PWELL BULK NOR2_X1
X$31079 \$10262 \$12787 \$13086 NWELL PWELL BULK NOR2_X1
X$31081 \$13086 \$10262 \$11358 \$13080 NWELL PWELL BULK AOI21_X1
X$31083 \$15807 \$10262 \$14951 \$15973 NWELL PWELL BULK AOI21_X1
X$31085 \$10262 \$16608 \$16772 NWELL PWELL BULK NOR2_X1
X$31087 \$16772 \$10262 \$15437 \$17159 NWELL PWELL BULK AOI21_X1
X$31089 \$17552 \$10262 \$17898 \$17320 NWELL PWELL BULK AOI21_X1
X$31092 \$15815 \$10262 \$15813 \$16367 NWELL PWELL BULK AOI21_X1
X$31094 \$10262 \$15818 \$15815 NWELL PWELL BULK NOR2_X1
X$31096 \$17157 \$10262 \$17156 \$17664 NWELL PWELL BULK AOI21_X1
X$31098 \$10262 \$16149 \$15807 NWELL PWELL BULK NOR2_X1
X$31100 \$10262 \$14956 \$14955 NWELL PWELL BULK NOR2_X1
X$31102 \$12609 \$10262 \$11674 \$12163 NWELL PWELL BULK AOI21_X1
X$31104 \$14959 \$10262 \$14095 \$15103 NWELL PWELL BULK AOI21_X1
X$31106 \$10262 \$17895 \$17685 NWELL PWELL BULK NOR2_X1
X$31109 \$17685 \$10262 \$17896 \$17682 NWELL PWELL BULK AOI21_X1
X$31112 \$16390 \$10262 \$14104 \$16004 NWELL PWELL BULK AOI21_X1
X$31114 \$10262 \$15279 \$16390 NWELL PWELL BULK NOR2_X1
X$31117 \$10262 \$20024 \$20204 NWELL PWELL BULK NOR2_X1
X$31120 \$20204 \$10262 \$18845 \$19814 NWELL PWELL BULK AOI21_X1
X$31122 \$10262 \$19074 \$18302 NWELL PWELL BULK NOR2_X1
X$31125 \$18302 \$10262 \$18303 \$18041 NWELL PWELL BULK AOI21_X1
X$31128 \$10262 \$16602 \$17157 NWELL PWELL BULK NOR2_X1
X$31130 \$10262 \$17555 \$18317 NWELL PWELL BULK NOR2_X1
X$31133 \$10262 \$16611 \$17552 NWELL PWELL BULK NOR2_X1
X$31136 \$10262 \$12168 \$12609 NWELL PWELL BULK NOR2_X1
X$31139 \$11715 \$10262 \$10789 \$10607 NWELL PWELL BULK AOI21_X1
X$31142 \$10262 \$11163 \$11715 NWELL PWELL BULK NOR2_X1
X$31145 \$11143 \$10262 \$10965 \$10603 NWELL PWELL BULK AOI21_X1
X$31148 \$11692 \$10262 \$11356 \$11851 NWELL PWELL BULK AOI21_X1
X$31150 \$10262 \$10952 \$11692 NWELL PWELL BULK NOR2_X1
X$31152 \$10262 \$10780 \$11143 NWELL PWELL BULK NOR2_X1
X$31155 \$10384 \$10262 \$10580 NWELL PWELL BULK OR2_X1
X$31158 \$10262 \$20270 \$20269 NWELL PWELL BULK NOR2_X1
X$31160 \$20269 \$10262 \$19563 \$20264 NWELL PWELL BULK AOI21_X1
X$31162 \$10262 \$13410 \$13874 NWELL PWELL BULK NOR2_X1
X$31164 \$14955 \$10262 \$13738 \$14361 NWELL PWELL BULK AOI21_X1
X$31166 \$11964 \$10262 \$10581 \$12184 NWELL PWELL BULK AOI21_X1
X$31168 \$10262 \$11965 \$11964 NWELL PWELL BULK NOR2_X1
X$31171 \$18317 \$10262 \$17326 \$18102 NWELL PWELL BULK AOI21_X1
X$31173 \$13874 \$10262 \$12610 \$13033 NWELL PWELL BULK AOI21_X1
X$31175 \$10262 \$14364 \$14959 NWELL PWELL BULK NOR2_X1
X$31177 \$17910 \$10262 \$18329 \$18124 NWELL PWELL BULK AOI21_X1
X$31179 \$10262 \$18335 \$18942 NWELL PWELL BULK NOR2_X1
X$31181 \$18942 \$10262 \$18745 \$19094 NWELL PWELL BULK AOI21_X1
X$31183 \$15839 \$10262 \$15525 \$15292 NWELL PWELL BULK AOI21_X1
X$31186 \$16884 \$10262 \$14973 \$15845 NWELL PWELL BULK AOI21_X1
X$31189 \$10262 \$15562 \$16884 NWELL PWELL BULK NOR2_X1
X$31192 \$10262 \$15841 \$15839 NWELL PWELL BULK NOR2_X1
X$31195 \$10262 \$18131 \$17910 NWELL PWELL BULK NOR2_X1
X$31197 \$21776 \$10262 \$21359 \$22046 NWELL PWELL BULK AOI21_X1
X$31199 \$10262 \$21777 \$21776 NWELL PWELL BULK NOR2_X1
X$31201 \$10262 \$19609 \$19605 NWELL PWELL BULK NOR2_X1
X$31203 \$18158 \$10262 \$17755 \$17560 NWELL PWELL BULK AOI21_X1
X$31205 \$10262 \$17562 \$18158 NWELL PWELL BULK NOR2_X1
X$31207 \$19605 \$10262 \$19433 \$19903 NWELL PWELL BULK AOI21_X1
X$31209 \$10262 \$20650 \$21574 NWELL PWELL BULK NOR2_X1
X$31211 \$21574 \$10262 \$20820 \$20905 NWELL PWELL BULK AOI21_X1
X$31214 \$10262 \$15282 \$14646 NWELL PWELL BULK NOR2_X1
X$31217 \$14646 \$10262 \$13750 \$14379 NWELL PWELL BULK AOI21_X1
X$31220 \$21763 \$10262 \$19425 \$21557 NWELL PWELL BULK AOI21_X1
X$31222 \$10262 \$20309 \$21763 NWELL PWELL BULK NOR2_X1
X$31224 \$10262 \$20899 \$20898 NWELL PWELL BULK NOR2_X1
X$31226 \$10262 \$18738 \$18523 NWELL PWELL BULK NOR2_X1
X$31228 \$18523 \$10262 \$18526 \$18115 NWELL PWELL BULK AOI21_X1
X$31231 \$20898 \$10262 \$20283 \$21122 NWELL PWELL BULK AOI21_X1
X$31233 \$20633 \$10262 \$20254 \$20790 NWELL PWELL BULK AOI21_X1
X$31236 \$10262 \$20893 \$20633 NWELL PWELL BULK NOR2_X1
X$31239 \$10262 \$16836 \$17556 NWELL PWELL BULK NOR2_X1
X$31242 \$17556 \$10262 \$17336 \$16160 NWELL PWELL BULK AOI21_X1
X$31245 \$10262 \$14112 \$14665 NWELL PWELL BULK NOR2_X1
X$31248 \$21758 \$10262 \$20229 \$21756 NWELL PWELL BULK AOI21_X1
X$31251 \$10262 \$15285 \$16023 NWELL PWELL BULK NOR2_X1
X$31253 \$16023 \$10262 \$12894 \$15829 NWELL PWELL BULK AOI21_X1
X$31255 \$10262 \$21974 \$21758 NWELL PWELL BULK NOR2_X1
X$31258 \$10262 \$17909 \$18126 NWELL PWELL BULK NOR2_X1
X$31260 \$18126 \$10262 \$15832 \$18120 NWELL PWELL BULK AOI21_X1
X$31348 \$I178420 \$10948 \$11470 \$10263 NWELL PWELL BULK DFF_X1
X$31350 \$I178400 \$10726 \$10586 \$10263 NWELL PWELL BULK DFF_X1
X$31353 \$I175373 \$11972 \$11349 \$10263 NWELL PWELL BULK DFF_X1
X$31355 \$I178381 \$13072 \$13070 \$10263 NWELL PWELL BULK DFF_X1
X$31359 \$I175516 \$11684 \$12205 \$10263 NWELL PWELL BULK DFF_X1
X$31361 \$I175513 \$12885 \$13061 \$10263 NWELL PWELL BULK DFF_X1
X$31363 \$I178436 \$11971 \$13054 \$10263 NWELL PWELL BULK DFF_X1
X$31365 \$I175509 \$13745 \$13885 \$10263 NWELL PWELL BULK DFF_X1
X$31367 \$I178395 \$13416 \$13541 \$10263 NWELL PWELL BULK DFF_X1
X$31369 \$I178040 \$11671 \$11823 \$10263 NWELL PWELL BULK DFF_X1
X$31371 \$I176071 \$12874 \$13030 \$10263 NWELL PWELL BULK DFF_X1
X$31373 \$I175898 \$12168 \$12163 \$10263 NWELL PWELL BULK DFF_X1
X$31376 \$I175904 \$10942 \$11088 \$10263 NWELL PWELL BULK DFF_X1
X$31379 \$I176075 \$10384 \$10580 \$10263 NWELL PWELL BULK DFF_X1
X$31382 \$I175925 \$12868 \$12866 \$10263 NWELL PWELL BULK DFF_X1
X$31384 \$I175927 \$14088 \$13867 \$10263 NWELL PWELL BULK DFF_X1
X$31386 \$I178007 \$14569 \$14355 \$10263 NWELL PWELL BULK DFF_X1
X$31389 \$I175937 \$11957 \$12604 \$10263 NWELL PWELL BULK DFF_X1
X$31392 \$I175957 \$11680 \$11463 \$10263 NWELL PWELL BULK DFF_X1
X$31394 \$I178081 \$10717 \$10709 \$10263 NWELL PWELL BULK DFF_X1
X$31397 \$I178379 \$11976 \$11469 \$10263 NWELL PWELL BULK DFF_X1
X$31400 \$I178340 \$12199 \$12195 \$10263 NWELL PWELL BULK DFF_X1
X$31404 \$I178107 \$11081 \$11079 \$10263 NWELL PWELL BULK DFF_X1
X$31406 \$I178341 \$10585 \$10264 \$10263 NWELL PWELL BULK DFF_X1
X$31409 \$I178046 \$11962 \$12176 \$10263 NWELL PWELL BULK DFF_X1
X$31412 \$I176037 \$11965 \$12184 \$10263 NWELL PWELL BULK DFF_X1
X$31415 \$I178019 \$14584 \$14089 \$10263 NWELL PWELL BULK DFF_X1
X$31420 \$I176009 \$11677 \$12173 \$10263 NWELL PWELL BULK DFF_X1
X$31451 \$13573 \$12894 \$10266 \$13752 NWELL PWELL BULK AOI21_X1
X$31453 \$10266 \$13753 \$13573 NWELL PWELL BULK NOR2_X1
X$31455 \$12889 \$10266 NWELL PWELL BULK BUF_X8
X$31457 \$10266 \$12257 \$12898 NWELL PWELL BULK NOR2_X1
X$31459 \$11860 \$11358 \$10266 \$11695 NWELL PWELL BULK AOI21_X1
X$31461 \$10266 \$10590 \$10955 NWELL PWELL BULK NOR2_X1
X$31464 \$10955 \$10272 \$10266 \$10417 NWELL PWELL BULK AOI21_X1
X$31467 \$12898 \$11982 \$10266 \$12244 NWELL PWELL BULK AOI21_X1
X$31469 \$10266 \$11699 \$11860 NWELL PWELL BULK NOR2_X1
X$31496 \$10272 \$33290 \$24913 \$32461 NWELL PWELL BULK AOI21_X4
X$31499 \$11502 \$10272 \$10406 \$10956 NWELL PWELL BULK AOI21_X1
X$31513 \$33866 \$33770 \$33868 \$10277 NWELL PWELL BULK OR3_X4
X$31532 \$10282 \$13943 \$13940 NWELL PWELL BULK NOR2_X1
X$31534 \$13940 \$13766 \$10282 \$13126 NWELL PWELL BULK AOI21_X1
X$31536 \$10282 \$12910 \$12625 NWELL PWELL BULK NOR2_X1
X$31539 \$12625 \$13117 \$10282 \$12908 NWELL PWELL BULK AOI21_X1
X$31543 \$11533 \$10789 \$10282 \$10606 NWELL PWELL BULK AOI21_X1
X$31546 \$10282 \$10968 \$11533 NWELL PWELL BULK NOR2_X1
X$31548 \$10406 \$10282 NWELL PWELL BULK BUF_X8
X$31551 \$11515 \$10965 \$10282 \$11129 NWELL PWELL BULK AOI21_X1
X$31554 \$10282 \$10602 \$11515 NWELL PWELL BULK NOR2_X1
X$31558 \$10282 \$15526 \$15151 NWELL PWELL BULK NOR2_X1
X$31561 \$15151 \$15525 \$10282 \$15148 NWELL PWELL BULK AOI21_X1
X$31564 \$10282 \$21603 \$20911 NWELL PWELL BULK NOR2_X1
X$31567 \$20911 \$21359 \$10282 \$20910 NWELL PWELL BULK AOI21_X1
X$31570 \$10282 \$19688 \$19602 NWELL PWELL BULK NOR2_X1
X$31573 \$19602 \$19433 \$10282 \$19895 NWELL PWELL BULK AOI21_X1
X$31576 \$10282 \$16624 \$17177 NWELL PWELL BULK NOR2_X1
X$31578 \$17177 \$17755 \$10282 \$17361 NWELL PWELL BULK AOI21_X1
X$31580 \$15843 \$14973 \$10282 \$16171 NWELL PWELL BULK AOI21_X1
X$31582 \$10282 \$15844 \$15843 NWELL PWELL BULK NOR2_X1
X$31608 \$10290 \$10920 NWELL PWELL BULK INV_X1
X$31623 \$10300 \$10301 \$10303 \$10626 NWELL PWELL BULK MUX2_X1
X$31627 \$18615 \$10301 \$18760 \$19112 NWELL PWELL BULK MUX2_X1
X$31629 \$18280 \$10301 \$17955 \$17857 NWELL PWELL BULK MUX2_X1
X$31632 \$18771 \$10301 \$18772 \$18367 NWELL PWELL BULK MUX2_X1
X$31634 \$18775 \$10301 \$19121 \$18776 NWELL PWELL BULK MUX2_X1
X$31637 \$18376 \$10301 \$18377 \$18693 NWELL PWELL BULK MUX2_X1
X$31640 \$12939 \$10301 \$12660 \$13278 NWELL PWELL BULK MUX2_X1
X$31642 \$13226 \$10301 \$12932 \$14026 NWELL PWELL BULK MUX2_X1
X$31644 \$18768 \$10301 \$17938 \$20452 NWELL PWELL BULK MUX2_X1
X$31647 \$16202 \$10301 \$16987 \$16657 NWELL PWELL BULK MUX2_X1
X$31650 \$23187 \$10301 NWELL PWELL BULK BUF_X16
X$31652 \$15328 \$10301 \$15002 \$15675 NWELL PWELL BULK MUX2_X1
X$31654 \$15860 \$10301 \$15859 \$15677 NWELL PWELL BULK MUX2_X1
X$31656 \$10990 \$10301 \$11660 \$11290 NWELL PWELL BULK MUX2_X1
X$31659 \$21644 \$10301 \$21648 \$21376 NWELL PWELL BULK MUX2_X1
X$31662 \$23798 \$10301 \$24519 \$25162 NWELL PWELL BULK MUX2_X1
X$31664 \$19474 \$10301 \$19634 \$20559 NWELL PWELL BULK MUX2_X1
X$31667 \$24820 \$10301 \$24980 \$24816 NWELL PWELL BULK MUX2_X1
X$31669 \$19979 \$10301 \$20068 \$20679 NWELL PWELL BULK MUX2_X1
X$31672 \$20411 \$10301 \$20409 \$21247 NWELL PWELL BULK MUX2_X1
X$31675 \$14995 \$10301 \$14421 \$15223 NWELL PWELL BULK MUX2_X1
X$31677 \$24057 \$10301 \$24061 \$25398 NWELL PWELL BULK MUX2_X1
X$31679 \$19728 \$10301 \$20110 \$20813 NWELL PWELL BULK MUX2_X1
X$31682 \$20106 \$10301 \$19725 \$20816 NWELL PWELL BULK MUX2_X1
X$31685 \$23707 \$10301 \$23789 \$23790 NWELL PWELL BULK MUX2_X1
X$31688 \$22816 \$10301 \$22925 \$22821 NWELL PWELL BULK MUX2_X1
X$31690 \$21796 \$10301 \$21662 \$21797 NWELL PWELL BULK MUX2_X1
X$31693 \$16668 \$10301 \$16226 \$17053 NWELL PWELL BULK MUX2_X1
X$31695 \$19958 \$10301 \$19125 \$19955 NWELL PWELL BULK MUX2_X1
X$31699 \$22784 \$10301 \$22920 \$22921 NWELL PWELL BULK MUX2_X1
X$31702 \$14423 \$10301 \$14139 \$14140 NWELL PWELL BULK MUX2_X1
X$31704 \$14427 \$10301 \$14144 \$15662 NWELL PWELL BULK MUX2_X1
X$31706 \$14418 \$10301 \$14019 \$14768 NWELL PWELL BULK MUX2_X1
X$31708 \$12041 \$10301 \$12659 \$12661 NWELL PWELL BULK MUX2_X1
X$31710 \$23685 \$10301 \$24083 \$23233 NWELL PWELL BULK MUX2_X1
X$31712 \$22806 \$10301 \$22810 \$21855 NWELL PWELL BULK MUX2_X1
X$31714 \$24979 \$10301 \$26982 \$25397 NWELL PWELL BULK MUX2_X1
X$31716 \$24782 \$10301 \$24516 \$24781 NWELL PWELL BULK MUX2_X1
X$31718 \$17585 \$10301 \$17939 \$18267 NWELL PWELL BULK MUX2_X1
X$31720 \$15652 \$10301 \$15326 \$15000 NWELL PWELL BULK MUX2_X1
X$31722 \$20708 \$10301 \$22095 \$21856 NWELL PWELL BULK MUX2_X1
X$31725 \$17937 \$10301 \$18628 \$17844 NWELL PWELL BULK MUX2_X1
X$31727 \$21638 \$10301 \$20712 \$21423 NWELL PWELL BULK MUX2_X1
X$31729 \$19706 \$10301 \$19452 \$19707 NWELL PWELL BULK MUX2_X1
X$31731 \$18756 \$10301 \$19448 \$19651 NWELL PWELL BULK MUX2_X1
X$31783 \$I174403 \$10303 \$10884 \$10636 NWELL PWELL BULK DFF_X1
X$31790 \$I178836 \$10320 \$11327 \$10636 NWELL PWELL BULK DFF_X1
X$31801 \$I175903 \$10327 \$10325 \$10636 NWELL PWELL BULK DFF_X1
X$31901 \$11058 \$10801 \$10359 \$11438 NWELL PWELL BULK AOI21_X1
X$31904 \$11172 \$10359 \$10677 \$11170 \$11435 NWELL PWELL BULK OAI22_X1
X$31907 \$11184 \$10677 \$10360 NWELL PWELL BULK NOR2_X1
X$31909 \$10804 \$10360 \$11176 \$10450 NWELL PWELL BULK OAI21_X1
X$31913 \$11486 \$10361 \$11862 NWELL PWELL BULK NAND2_X1
X$31915 \$10361 \$11443 \$11840 NWELL PWELL BULK NOR2_X1
X$31918 \$10361 \$10801 \$11058 NWELL PWELL BULK NOR2_X1
X$31921 \$11441 \$11857 \$10361 \$11789 NWELL PWELL BULK AOI21_X1
X$31924 \$11496 \$11788 \$10361 \$12777 NWELL PWELL BULK NAND3_X1
X$31934 \$10364 \$10681 \$I245642 \$12769 NWELL PWELL BULK DFF_X2
X$31937 \$I178177 \$10682 \$10364 \$10681 NWELL PWELL BULK DFF_X1
X$31962 \$14552 \$15487 \$15985 \$10373 NWELL PWELL BULK DFF_X1
X$31964 \$I175098 \$15954 \$15976 \$10373 NWELL PWELL BULK DFF_X1
X$31967 \$I174841 \$15971 \$15472 \$10373 NWELL PWELL BULK DFF_X1
X$31969 \$I174840 \$15956 \$16320 \$10373 NWELL PWELL BULK DFF_X1
X$31972 \$I175170 \$17279 \$17306 \$10373 NWELL PWELL BULK DFF_X1
X$31974 \$I175315 \$16319 \$16349 \$10373 NWELL PWELL BULK DFF_X1
X$31977 \$I178438 \$10713 \$10394 \$10373 NWELL PWELL BULK DFF_X1
X$31980 \$I178731 \$10376 \$11084 \$10373 NWELL PWELL BULK DFF_X1
X$31982 \$I174561 \$10697 \$10739 \$10373 NWELL PWELL BULK DFF_X1
X$31985 \$11454 \$11813 \$11460 \$10373 NWELL PWELL BULK DFF_X1
X$31988 \$I176863 \$10395 \$10400 \$10373 NWELL PWELL BULK DFF_X1
X$31996 \$I176029 \$11816 \$11072 \$10373 NWELL PWELL BULK DFF_X1
X$31999 \$I177057 \$10694 \$11106 \$10373 NWELL PWELL BULK DFF_X1
X$32001 \$13564 \$13513 \$13565 \$10373 NWELL PWELL BULK DFF_X1
X$32003 \$I175895 \$13520 \$13859 \$10373 NWELL PWELL BULK DFF_X1
X$32005 \$13545 \$10373 \$I245748 \$13516 NWELL PWELL BULK DFF_X2
X$32007 \$I177129 \$12178 \$12151 \$10373 NWELL PWELL BULK DFF_X1
X$32012 \$13521 \$10373 \$I245571 \$13014 NWELL PWELL BULK DFF_X2
X$32015 \$I174474 \$12750 \$13008 \$10373 NWELL PWELL BULK DFF_X1
X$32018 \$I175835 \$12148 \$12260 \$10373 NWELL PWELL BULK DFF_X1
X$32020 \$I176750 \$12154 \$11456 \$10373 NWELL PWELL BULK DFF_X1
X$32022 \$13859 \$10373 \$I245746 \$15076 NWELL PWELL BULK DFF_X2
X$32024 \$I177090 \$13862 \$13521 \$10373 NWELL PWELL BULK DFF_X1
X$32026 \$14553 \$15068 \$14647 \$10373 NWELL PWELL BULK DFF_X1
X$32028 \$14554 \$10373 \$I245610 \$13860 NWELL PWELL BULK DFF_X2
X$32030 \$I175251 \$15077 \$15075 \$10373 NWELL PWELL BULK DFF_X1
X$32033 \$I175250 \$14590 \$14223 \$10373 NWELL PWELL BULK DFF_X1
X$32078 \$10942 \$10578 \$10384 \$10703 NWELL PWELL BULK MUX2_X1
X$32103 \$10406 \$10408 \$10404 NWELL PWELL BULK NOR2_X1
X$32107 \$10406 \$11690 \$11474 NWELL PWELL BULK NOR2_X1
X$32109 \$11474 \$11356 \$10406 \$11687 NWELL PWELL BULK AOI21_X1
X$32111 \$10406 \$10961 \$11502 NWELL PWELL BULK NOR2_X1
X$32116 \$10406 \$12199 \$11968 NWELL PWELL BULK NOR2_X1
X$32119 \$10406 \$13072 \$12888 NWELL PWELL BULK NOR2_X1
X$32122 \$12888 \$11352 \$10406 \$13070 NWELL PWELL BULK AOI21_X1
X$32125 \$13418 \$13419 \$10406 \$13885 NWELL PWELL BULK AOI21_X1
X$32128 \$10406 \$13745 \$13418 NWELL PWELL BULK NOR2_X1
X$32131 \$14385 \$10406 NWELL PWELL BULK BUF_X8
X$32134 \$10406 \$13428 \$13427 NWELL PWELL BULK NOR2_X1
X$32137 \$14111 \$13430 \$10406 \$13906 NWELL PWELL BULK AOI21_X1
X$32140 \$10406 \$13105 \$14111 NWELL PWELL BULK NOR2_X1
X$32143 \$13427 \$11982 \$10406 \$13757 NWELL PWELL BULK AOI21_X1
X$32150 \$12783 \$11358 \$10406 \$12616 NWELL PWELL BULK AOI21_X1
X$32152 \$10406 \$11981 \$12783 NWELL PWELL BULK NOR2_X1
X$32154 \$10942 \$10406 \$11088 NWELL PWELL BULK OR2_X1
X$32157 \$10406 \$11671 \$11347 NWELL PWELL BULK NOR2_X1
X$32159 \$11347 \$11674 \$10406 \$11823 NWELL PWELL BULK AOI21_X1
X$32161 \$10406 \$11680 \$11094 NWELL PWELL BULK NOR2_X1
X$32164 \$11094 \$10581 \$10406 \$11463 NWELL PWELL BULK AOI21_X1
X$32168 \$11968 \$12612 \$10406 \$12195 NWELL PWELL BULK AOI21_X1
X$32205 \$11801 \$10429 \$11447 \$11803 NWELL PWELL BULK MUX2_X1
X$32209 \$11809 \$10429 \$11810 \$12303 NWELL PWELL BULK MUX2_X1
X$32214 \$15927 \$10429 \$17715 \$17628 NWELL PWELL BULK MUX2_X1
X$32217 \$14548 \$10429 \$15065 \$14211 NWELL PWELL BULK MUX2_X1
X$32220 \$12729 \$10429 \$13583 \$13006 NWELL PWELL BULK MUX2_X1
X$32222 \$13853 \$10429 \$15068 \$14647 NWELL PWELL BULK MUX2_X1
X$32225 \$14210 \$10429 \$13849 \$13931 NWELL PWELL BULK MUX2_X1
X$32229 \$16356 \$10429 \$17311 \$17678 NWELL PWELL BULK MUX2_X1
X$32249 \$11439 \$11496 \$10449 \$11872 NWELL PWELL BULK AOI21_X1
X$32255 \$11514 \$10449 \$11184 NWELL PWELL BULK NOR2_X1
X$32257 \$11794 \$10449 \$11054 \$12366 \$11442 NWELL PWELL BULK OAI22_X2
X$32259 \$10449 \$12995 \$13206 NWELL PWELL BULK NAND2_X1
X$32262 \$11172 \$12366 \$10449 \$12493 NWELL PWELL BULK AOI21_X1
X$32264 \$12986 \$10449 \$12366 \$13320 NWELL PWELL BULK OAI21_X1
X$32267 \$11054 \$12711 \$13280 \$10449 \$11172 \$12986 \$13972 NWELL PWELL
+ BULK OAI33_X1
X$32317 \$10489 \$12047 NWELL PWELL BULK INV_X1
X$32347 \$I174911 \$10986 \$10519 \$10620 NWELL PWELL BULK DFF_X1
X$32352 \$10521 \$11385 \$12033 NWELL PWELL BULK NOR2_X2
X$32394 \$21760 \$10578 \$20893 \$21342 NWELL PWELL BULK MUX2_X1
X$32396 \$20631 \$10578 \$21974 \$21535 NWELL PWELL BULK MUX2_X1
X$32398 \$21325 \$10578 \$20884 \$21936 NWELL PWELL BULK MUX2_X1
X$32400 \$20889 \$10578 \$21754 \$21524 NWELL PWELL BULK MUX2_X1
X$32402 \$17893 \$10578 \$17892 \$18473 NWELL PWELL BULK MUX2_X1
X$32406 \$14374 \$10578 \$14105 \$15481 NWELL PWELL BULK MUX2_X1
X$32408 \$18024 \$10578 \$17287 \$18029 NWELL PWELL BULK MUX2_X1
X$32411 \$18728 \$10578 \$17895 \$18729 NWELL PWELL BULK MUX2_X1
X$32413 \$20192 \$10578 \$20024 \$20198 NWELL PWELL BULK MUX2_X1
X$32416 \$17902 \$10578 \$16611 \$18500 NWELL PWELL BULK MUX2_X1
X$32419 \$18311 \$10578 \$18731 \$18732 NWELL PWELL BULK MUX2_X1
X$32421 \$19419 \$10578 \$18308 \$19547 NWELL PWELL BULK MUX2_X1
X$32423 \$15453 \$10578 \$15275 \$16156 NWELL PWELL BULK MUX2_X1
X$32425 \$16811 \$10578 \$16613 \$17720 NWELL PWELL BULK MUX2_X1
X$32427 \$14569 \$10578 \$14088 \$14578 NWELL PWELL BULK MUX2_X1
X$32429 \$11957 \$10578 \$12868 \$12872 NWELL PWELL BULK MUX2_X1
X$32432 \$11677 \$10578 \$11962 \$13036 NWELL PWELL BULK MUX2_X1
X$32435 \$11671 \$10578 \$12168 \$12607 NWELL PWELL BULK MUX2_X1
X$32437 \$16148 \$10578 \$15805 \$16757 NWELL PWELL BULK MUX2_X1
X$32440 \$16152 \$10578 \$16606 \$16607 NWELL PWELL BULK MUX2_X1
X$32443 \$17155 \$10578 \$16602 \$16601 NWELL PWELL BULK MUX2_X1
X$32445 \$15270 \$10578 \$16149 \$16761 NWELL PWELL BULK MUX2_X1
X$32448 \$13413 \$10578 \$13879 \$13741 NWELL PWELL BULK MUX2_X1
X$32451 \$12874 \$10578 \$13410 \$12879 NWELL PWELL BULK MUX2_X1
X$32454 \$14097 \$10578 \$14364 \$14604 NWELL PWELL BULK MUX2_X1
X$32457 \$18095 \$10578 \$17555 \$18093 NWELL PWELL BULK MUX2_X1
X$32460 \$13891 \$10578 \$14370 \$14257 NWELL PWELL BULK MUX2_X1
X$32463 \$13743 \$10578 \$13416 \$13744 NWELL PWELL BULK MUX2_X1
X$32466 \$13745 \$10578 \$12885 \$14101 NWELL PWELL BULK MUX2_X1
X$32471 \$14380 \$10578 \$13751 \$14381 NWELL PWELL BULK MUX2_X1
X$32474 \$21750 \$10578 \$20887 \$21944 NWELL PWELL BULK MUX2_X1
X$32476 \$15272 \$10578 \$15818 \$16155 NWELL PWELL BULK MUX2_X1
X$32479 \$17547 \$10578 \$17162 \$16793 NWELL PWELL BULK MUX2_X1
X$32481 \$19663 \$10578 \$20033 \$20632 NWELL PWELL BULK MUX2_X1
X$32483 \$19842 \$10578 \$20034 \$21341 NWELL PWELL BULK MUX2_X1
X$32485 \$15980 \$10578 \$16608 \$16780 NWELL PWELL BULK MUX2_X1
X$32488 \$19413 \$10578 \$18722 \$19807 NWELL PWELL BULK MUX2_X1
X$32490 \$15277 \$10578 \$15279 \$15281 NWELL PWELL BULK MUX2_X1
X$32492 \$20026 \$10578 \$20030 \$20629 NWELL PWELL BULK MUX2_X1
X$32494 \$18726 \$10578 \$19074 \$18854 NWELL PWELL BULK MUX2_X1
X$32496 \$14962 \$10578 \$15991 \$16378 NWELL PWELL BULK MUX2_X1
X$32501 \$19233 \$10578 \$19081 \$20273 NWELL PWELL BULK MUX2_X1
X$32503 \$14584 \$10578 \$14956 \$14586 NWELL PWELL BULK MUX2_X1
X$32505 \$20896 \$10578 \$20270 \$20803 NWELL PWELL BULK MUX2_X1
X$32507 \$16159 \$10578 \$15282 \$16401 NWELL PWELL BULK MUX2_X1
X$32564 \$32460 \$33392 \$10581 \$33395 \$32461 NWELL PWELL BULK AOI22_X4
X$32591 \$I176912 \$11718 \$12011 \$10601 NWELL PWELL BULK DFF_X1
X$32594 \$I178296 \$12004 \$11711 \$10601 NWELL PWELL BULK DFF_X1
X$32596 \$I178289 \$13620 \$13618 \$10601 NWELL PWELL BULK DFF_X1
X$32598 \$I176530 \$13773 \$13959 \$10601 NWELL PWELL BULK DFF_X1
X$32600 \$I178297 \$11998 \$12287 \$10601 NWELL PWELL BULK DFF_X1
X$32602 \$I175706 \$13762 \$13925 \$10601 NWELL PWELL BULK DFF_X1
X$32604 \$I177822 \$14113 \$13916 \$10601 NWELL PWELL BULK DFF_X1
X$32606 \$I177819 \$13432 \$12904 \$10601 NWELL PWELL BULK DFF_X1
X$32609 \$I178265 \$10780 \$10603 \$10601 NWELL PWELL BULK DFF_X1
X$32611 \$I175704 \$12910 \$12908 \$10601 NWELL PWELL BULK DFF_X1
X$32613 \$11993 \$10601 \$I245615 \$11997 NWELL PWELL BULK DFF_X2
X$32616 \$I175705 \$11999 \$12293 \$10601 NWELL PWELL BULK DFF_X1
X$32619 \$I175548 \$12914 \$13137 \$10601 NWELL PWELL BULK DFF_X1
X$32622 \$I175546 \$12010 \$12317 \$10601 NWELL PWELL BULK DFF_X1
X$32627 \$I175680 \$12823 \$12302 \$10601 NWELL PWELL BULK DFF_X1
X$32630 \$I176451 \$12903 \$12901 \$10601 NWELL PWELL BULK DFF_X1
X$32632 \$I176643 \$11881 \$11507 \$10601 NWELL PWELL BULK DFF_X1
X$32634 \$I176442 \$14121 \$14699 \$10601 NWELL PWELL BULK DFF_X1
X$32636 \$I176551 \$10971 \$10808 \$10601 NWELL PWELL BULK DFF_X1
X$32638 \$I176943 \$10970 \$11547 \$10601 NWELL PWELL BULK DFF_X1
X$32643 \$I178426 \$10968 \$10606 \$10601 NWELL PWELL BULK DFF_X1
X$32645 \$I175368 \$11163 \$10607 \$10601 NWELL PWELL BULK DFF_X1
X$32650 \$I175422 \$10602 \$11129 \$10601 NWELL PWELL BULK DFF_X1
X$32653 \$I176281 \$14691 \$15171 \$10601 NWELL PWELL BULK DFF_X1
X$32655 \$11989 \$11703 \$12265 \$10601 NWELL PWELL BULK DFF_X1
X$32705 \$I177411 \$12026 \$11947 \$10620 NWELL PWELL BULK DFF_X1
X$32707 \$I178661 \$12393 \$12652 \$10620 NWELL PWELL BULK DFF_X1
X$32710 \$I178646 \$12932 \$13455 \$10620 NWELL PWELL BULK DFF_X1
X$32713 \$I177892 \$13226 \$13224 \$10620 NWELL PWELL BULK DFF_X1
X$32715 \$I174484 \$14019 \$14021 \$10620 NWELL PWELL BULK DFF_X1
X$32717 \$I177458 \$14418 \$14748 \$10620 NWELL PWELL BULK DFF_X1
X$32720 \$I178502 \$12857 \$13239 \$10620 NWELL PWELL BULK DFF_X1
X$32722 \$I175210 \$12657 \$13249 \$10620 NWELL PWELL BULK DFF_X1
X$32725 \$I174786 \$14144 \$14029 \$10620 NWELL PWELL BULK DFF_X1
X$32727 \$I174441 \$12650 \$12930 \$10620 NWELL PWELL BULK DFF_X1
X$32730 \$I177470 \$13788 \$13450 \$10620 NWELL PWELL BULK DFF_X1
X$32732 \$I177404 \$12367 \$12645 \$10620 NWELL PWELL BULK DFF_X1
X$32734 \$I177877 \$10621 \$11250 \$10620 NWELL PWELL BULK DFF_X1
X$32740 \$I175864 \$14133 \$14414 \$10620 NWELL PWELL BULK DFF_X1
X$32742 \$I174430 \$15002 \$14809 \$10620 NWELL PWELL BULK DFF_X1
X$32744 \$I174410 \$14423 \$14353 \$10620 NWELL PWELL BULK DFF_X1
X$32747 \$I174449 \$14421 \$14770 \$10620 NWELL PWELL BULK DFF_X1
X$32750 \$I179268 \$14139 \$15236 \$10620 NWELL PWELL BULK DFF_X1
X$32753 \$I178937 \$15652 \$15325 \$10620 NWELL PWELL BULK DFF_X1
X$32756 \$I176146 \$11384 \$11618 \$10620 NWELL PWELL BULK DFF_X1
X$32758 \$I176975 \$11241 \$10981 \$10620 NWELL PWELL BULK DFF_X1
X$32760 \$I174369 \$13787 \$14006 \$10620 NWELL PWELL BULK DFF_X1
X$32762 \$I177874 \$12029 \$11946 \$10620 NWELL PWELL BULK DFF_X1
X$32764 \$I179222 \$14427 \$14786 \$10620 NWELL PWELL BULK DFF_X1
X$32767 \$I174382 \$12648 \$13215 \$10620 NWELL PWELL BULK DFF_X1
X$32770 \$I174296 \$16202 \$16977 \$10620 NWELL PWELL BULK DFF_X1
X$32772 \$I178983 \$15326 \$16511 \$10620 NWELL PWELL BULK DFF_X1
X$32774 \$I175179 \$15328 \$15666 \$10620 NWELL PWELL BULK DFF_X1
X$32813 \$10631 \$13790 \$12035 NWELL PWELL BULK NOR2_X2
X$32826 \$I178785 \$11398 \$12482 \$10636 NWELL PWELL BULK DFF_X1
X$32829 \$I178794 \$13811 \$13810 \$10636 NWELL PWELL BULK DFF_X1
X$32831 \$I178809 \$14165 \$14873 \$10636 NWELL PWELL BULK DFF_X1
X$32833 \$I178846 \$12950 \$13732 \$10636 NWELL PWELL BULK DFF_X1
X$32837 \$I174575 \$12954 \$13807 \$10636 NWELL PWELL BULK DFF_X1
X$32839 \$I178837 \$12667 \$12951 \$10636 NWELL PWELL BULK DFF_X1
X$32842 \$I176299 \$12065 \$12486 \$10636 NWELL PWELL BULK DFF_X1
X$32844 \$I175729 \$13338 \$13337 \$10636 NWELL PWELL BULK DFF_X1
X$32846 \$I178878 \$12479 \$12846 \$10636 NWELL PWELL BULK DFF_X1
X$32848 \$I179046 \$12660 \$13459 \$10636 NWELL PWELL BULK DFF_X1
X$32851 \$I174797 \$12041 \$11938 \$10636 NWELL PWELL BULK DFF_X1
X$32853 \$I174328 \$11396 \$11663 \$10636 NWELL PWELL BULK DFF_X1
X$32857 \$I175465 \$10639 \$10939 \$10636 NWELL PWELL BULK DFF_X1
X$32860 \$I175453 \$11344 \$11655 \$10636 NWELL PWELL BULK DFF_X1
X$32862 \$I175870 \$10933 \$11015 \$10636 NWELL PWELL BULK DFF_X1
X$32867 \$I178315 \$14870 \$15015 \$10636 NWELL PWELL BULK DFF_X1
X$32870 \$I179064 \$15334 \$16550 \$10636 NWELL PWELL BULK DFF_X1
X$32873 \$I174298 \$16668 \$16223 \$10636 NWELL PWELL BULK DFF_X1
X$32875 \$I178902 \$15870 \$16559 \$10636 NWELL PWELL BULK DFF_X1
X$32877 \$I178928 \$16214 \$16536 \$10636 NWELL PWELL BULK DFF_X1
X$32880 \$I178901 \$14863 \$15244 \$10636 NWELL PWELL BULK DFF_X1
X$32883 \$I179062 \$16220 \$17042 \$10636 NWELL PWELL BULK DFF_X1
X$32885 \$I174632 \$18377 \$19385 \$10636 NWELL PWELL BULK DFF_X1
X$32887 \$I174585 \$18280 \$17953 \$10636 NWELL PWELL BULK DFF_X1
X$32889 \$I179010 \$18376 \$17950 \$10636 NWELL PWELL BULK DFF_X1
X$32891 \$I174406 \$15013 \$14861 \$10636 NWELL PWELL BULK DFF_X1
X$32893 \$I179226 \$12939 \$13713 \$10636 NWELL PWELL BULK DFF_X1
X$32976 \$I178692 \$10659 \$11272 \$11033 NWELL PWELL BULK DFF_X1
X$32997 \$10821 \$11055 \$10675 \$10674 NWELL PWELL BULK OAI21_X1
X$33000 \$11056 \$10677 \$10675 NWELL PWELL BULK NAND2_X1
X$33003 \$11431 \$11172 \$10677 \$13245 \$13234 NWELL PWELL BULK OAI22_X1
X$33012 \$11170 \$11054 \$10677 \$11499 NWELL PWELL BULK NOR3_X1
X$33014 \$10677 \$11439 \$12711 NWELL PWELL BULK NOR2_X1
X$33016 \$11862 \$10677 \$11501 NWELL PWELL BULK NOR2_X1
X$33018 \$11501 \$11786 \$11054 \$10677 \$11857 \$11495 NWELL PWELL BULK
+ AOI221_X1
X$33020 \$10677 \$12366 NWELL PWELL BULK INV_X2
X$33032 \$16439 \$16441 \$16014 \$10681 NWELL PWELL BULK DFF_X1
X$33035 \$I177233 \$15058 \$15558 \$10681 NWELL PWELL BULK DFF_X1
X$33037 \$16012 \$15930 \$15553 \$10681 NWELL PWELL BULK DFF_X1
X$33039 \$17713 \$17626 \$17256 \$10681 NWELL PWELL BULK DFF_X1
X$33042 \$18009 \$17715 \$17628 \$10681 NWELL PWELL BULK DFF_X1
X$33045 \$18900 \$19243 \$18899 \$10681 NWELL PWELL BULK DFF_X1
X$33047 \$I175332 \$19512 \$19253 \$10681 NWELL PWELL BULK DFF_X1
X$33049 \$19238 \$19168 \$19248 \$10681 NWELL PWELL BULK DFF_X1
X$33051 \$I179169 \$12350 \$11839 \$10681 NWELL PWELL BULK DFF_X1
X$33054 \$14667 \$14546 \$14240 \$10681 NWELL PWELL BULK DFF_X1
X$33057 \$I178833 \$11797 \$12362 \$10681 NWELL PWELL BULK DFF_X1
X$33060 \$20329 \$20331 \$20335 \$10681 NWELL PWELL BULK DFF_X1
X$33062 \$I179123 \$19781 \$19564 \$10681 NWELL PWELL BULK DFF_X1
X$33064 \$14528 \$14527 \$14775 \$10681 NWELL PWELL BULK DFF_X1
X$33067 \$I179172 \$13501 \$13947 \$10681 NWELL PWELL BULK DFF_X1
X$33070 \$14677 \$15065 \$14211 \$10681 NWELL PWELL BULK DFF_X1
X$33073 \$I176877 \$13849 \$13931 \$10681 NWELL PWELL BULK DFF_X1
X$33076 \$I176504 \$12727 \$13136 \$10681 NWELL PWELL BULK DFF_X1
X$33079 \$I176462 \$12134 \$11802 \$10681 NWELL PWELL BULK DFF_X1
X$33082 \$13505 \$13121 \$13003 \$10681 NWELL PWELL BULK DFF_X1
X$33088 \$13182 \$13171 \$13187 \$10681 NWELL PWELL BULK DFF_X1
X$33090 \$I175125 \$13839 \$14203 \$10681 NWELL PWELL BULK DFF_X1
X$33093 \$14755 \$10681 \$13953 \$11443 NWELL PWELL BULK DFF_X2
X$33096 \$14543 \$14542 \$15118 \$10681 NWELL PWELL BULK DFF_X1
X$33101 \$I179168 \$14536 \$14701 \$10681 NWELL PWELL BULK DFF_X1
X$33104 \$14660 \$14550 \$14653 \$10681 NWELL PWELL BULK DFF_X1
X$33106 \$I174363 \$14202 \$14201 \$10681 NWELL PWELL BULK DFF_X1
X$33152 \$10695 M1_AXI_BID[1] NWELL PWELL BULK BUF_X1
X$33168 \$10700 M1_AXI_BID[2] NWELL PWELL BULK BUF_X1
X$33236 \$12329 \$10787 \$12729 \$12330 NWELL PWELL BULK MUX2_X1
X$33239 \$12137 \$10787 \$11809 \$12315 NWELL PWELL BULK MUX2_X1
X$33241 \$14546 \$10787 \$14548 \$14240 NWELL PWELL BULK MUX2_X1
X$33243 \$16368 \$10787 \$16356 \$16370 NWELL PWELL BULK MUX2_X1
X$33245 \$16441 \$10787 \$15927 \$16014 NWELL PWELL BULK MUX2_X1
X$33247 \$13570 \$10787 \$13853 \$13098 NWELL PWELL BULK MUX2_X1
X$33251 \$12350 \$10787 \$11801 \$11839 NWELL PWELL BULK MUX2_X1
X$33253 \$14536 \$10787 \$14210 \$14701 NWELL PWELL BULK MUX2_X1
X$33265 \$32460 \$40185 \$10789 \$41162 \$33856 NWELL PWELL BULK AOI22_X4
X$33286 \$13145 \$10792 \$12723 \$18954 NWELL PWELL BULK AND3_X2
X$33288 \$17246 \$15407 \$15514 \$10792 \$16449 NWELL PWELL BULK AOI22_X2
X$33294 \$12723 \$10792 \$13145 \$18805 NWELL PWELL BULK NAND3_X2
X$33308 \$12116 \$12118 \$10801 \$12117 NWELL PWELL BULK OAI21_X1
X$33310 \$12710 \$12711 \$10801 \$12989 NWELL PWELL BULK NAND3_X1
X$33324 \$11495 \$11789 \$10804 \$11480 NWELL PWELL BULK OR3_X1
X$33371 \$I176932 \$10865 \$11261 \$11033 NWELL PWELL BULK DFF_X1
X$33383 \$I177993 \$10871 \$11268 \$11033 NWELL PWELL BULK DFF_X1
X$33468 \$32460 \$45952 \$10965 \$45260 \$33856 NWELL PWELL BULK AOI22_X4
X$33511 \$10982 \$12476 NWELL PWELL BULK INV_X1
X$33517 \$14343 \$13261 \$13791 \$10982 \$13452 NWELL PWELL BULK OR4_X4
X$33519 \$13452 \$10982 \$13791 \$13261 \$14798 NWELL PWELL BULK NOR4_X4
X$33550 \$11003 \$11746 \$12044 \$10994 \$12425 NWELL PWELL BULK NOR4_X4
X$33552 \$14065 \$10994 \$12044 \$11746 \$11003 NWELL PWELL BULK OR4_X4
X$33554 \$10994 \$11000 NWELL PWELL BULK INV_X1
X$33571 \$11003 \$11011 NWELL PWELL BULK INV_X1
X$33628 \$I176008 \$14048 \$14051 \$11033 NWELL PWELL BULK DFF_X1
X$33630 \$I178736 \$13479 \$13686 \$11033 NWELL PWELL BULK DFF_X1
X$33632 \$I175531 \$12962 \$13396 \$11033 NWELL PWELL BULK DFF_X1
X$33635 \$I176004 \$12681 \$12831 \$11033 NWELL PWELL BULK DFF_X1
X$33638 \$I175503 \$12686 \$13389 \$11033 NWELL PWELL BULK DFF_X1
X$33641 \$I175734 \$12083 \$12564 \$11033 NWELL PWELL BULK DFF_X1
X$33643 \$I177765 \$12086 \$12688 \$11033 NWELL PWELL BULK DFF_X1
X$33645 \$I175497 \$13823 \$14036 \$11033 NWELL PWELL BULK DFF_X1
X$33650 \$I177980 \$13484 \$13485 \$11033 NWELL PWELL BULK DFF_X1
X$33653 \$I175565 \$11761 \$11891 \$11033 NWELL PWELL BULK DFF_X1
X$33656 \$I175587 \$11609 \$11892 \$11033 NWELL PWELL BULK DFF_X1
X$33659 \$I177502 \$11766 \$12590 \$11033 NWELL PWELL BULK DFF_X1
X$33662 \$I176467 \$13826 \$14024 \$11033 NWELL PWELL BULK DFF_X1
X$33664 \$I176606 \$12091 \$12585 \$11033 NWELL PWELL BULK DFF_X1
X$33666 \$I176607 \$12093 \$13405 \$11033 NWELL PWELL BULK DFF_X1
X$33673 \$I175550 \$11765 \$11764 \$11033 NWELL PWELL BULK DFF_X1
X$33675 \$I175420 \$13820 \$14913 \$11033 NWELL PWELL BULK DFF_X1
X$33678 \$I175682 \$14472 \$14470 \$11033 NWELL PWELL BULK DFF_X1
X$33681 \$I177157 \$14474 \$14177 \$11033 NWELL PWELL BULK DFF_X1
X$33684 \$I176623 \$15343 \$16107 \$11033 NWELL PWELL BULK DFF_X1
X$33686 \$I176897 \$15344 \$16590 \$11033 NWELL PWELL BULK DFF_X1
X$33688 \$I177155 \$17094 \$17093 \$11033 NWELL PWELL BULK DFF_X1
X$33690 \$I176697 \$17091 \$17526 \$11033 NWELL PWELL BULK DFF_X1
X$33693 \$I176614 \$16096 \$16097 \$11033 NWELL PWELL BULK DFF_X1
X$33696 \$I175692 \$14476 \$15770 \$11033 NWELL PWELL BULK DFF_X1
X$33698 \$I177032 \$14478 \$15777 \$11033 NWELL PWELL BULK DFF_X1
X$33749 \$11431 \$11054 \$12446 NWELL PWELL BULK NOR2_X1
X$33751 \$11054 \$12504 \$11486 \$11055 NWELL PWELL BULK AOI21_X1
X$33753 \$11054 \$11791 \$11486 \$11794 NWELL PWELL BULK AOI21_X1
X$33755 \$11054 \$11441 NWELL PWELL BULK INV_X1
X$33758 \$11054 \$11432 \$11486 \$11514 NWELL PWELL BULK AOI21_X1
X$33760 \$11777 \$11054 \$11056 \$11517 NWELL PWELL BULK AOI21_X1
X$33766 \$12777 \$11054 \$11792 \$13196 NWELL PWELL BULK OAI21_X2
X$33769 \$11054 \$13234 \$11486 \$13204 NWELL PWELL BULK AOI21_X2
X$33772 \$11054 \$13218 \$12777 \$13211 NWELL PWELL BULK OAI21_X1
X$33774 \$11486 \$11054 \$12986 NWELL PWELL BULK NOR2_X1
X$33799 \$11056 \$11439 \$11176 NWELL PWELL BULK NAND2_X1
X$33803 \$11056 \$11875 \$11520 NWELL PWELL BULK NAND2_X1
X$33811 \$11444 \$11442 \$11796 \$11060 \$11443 NWELL PWELL BULK AOI22_X4
X$33813 \$11060 \$11160 NWELL PWELL BULK INV_X1
X$33819 \$13494 \$13953 \$11064 \$12122 NWELL PWELL BULK NAND3_X2
X$33823 \$14533 \$11064 \$13844 NWELL PWELL BULK NOR2_X1
X$33826 \$11064 \$15057 NWELL PWELL BULK INV_X1
X$33833 \$11064 \$11804 \$11829 NWELL PWELL BULK XNOR2_X1
X$33836 \$13494 \$11064 \$12995 \$12990 NWELL PWELL BULK NAND3_X1
X$33839 \$12995 \$11064 \$13494 \$11857 NWELL PWELL BULK AND3_X1
X$33855 \$11814 \$11454 \$11070 NWELL PWELL BULK NAND2_X1
X$33860 \$12147 \$11816 \$11073 NWELL PWELL BULK NAND2_X1
X$33863 \$11813 \$11816 \$11075 \$11818 NWELL PWELL BULK HA_X1
X$33865 \$11814 \$11075 \$11095 NWELL PWELL BULK NAND2_X1
X$33902 \$11812 \$12147 \$I241103 \$11102 NWELL PWELL BULK HA_X1
X$33904 \$11102 \$11132 NWELL PWELL BULK INV_X1
X$33907 \$11102 \$11135 \$11133 NWELL PWELL BULK XOR2_X1
X$33948 \$11160 \$11479 \$11480 \$11158 NWELL PWELL BULK OAI21_X1
X$33978 \$13162 \$12996 \$11798 \$12723 \$11172 NWELL PWELL BULK NOR4_X4
X$33982 \$11862 \$11172 \$12710 NWELL PWELL BULK NOR2_X1
X$34019 \$I177482 \$11196 \$11197 \$12700 NWELL PWELL BULK DFF_X1
X$34174 \$11352 \$33405 \$26098 \$32461 NWELL PWELL BULK AOI21_X4
X$34188 \$11356 \$35213 \$29365 \$32461 NWELL PWELL BULK AOI21_X4
X$34206 \$11358 \$35460 \$28915 \$32461 NWELL PWELL BULK AOI21_X4
X$34216 \$11363 \$12280 \$11885 NWELL PWELL BULK NOR2_X1
X$34218 \$11989 \$11363 \$11703 \$12272 NWELL PWELL BULK MUX2_X1
X$34220 \$11991 \$11363 \$11704 NWELL PWELL BULK NOR2_X1
X$34222 \$11885 \$11881 \$11363 \$11512 NWELL PWELL BULK AOI21_X1
X$34246 \$29053 \$11378 \$27916 \$29058 NWELL PWELL BULK MUX2_X1
X$34248 \$11378 \$28515 NWELL PWELL BULK BUF_X8
X$34259 \$32903 \$11378 \$33090 \$32899 NWELL PWELL BULK MUX2_X1
X$34261 \$30547 \$11378 \$30249 \$30046 NWELL PWELL BULK MUX2_X1
X$34264 \$23500 \$11378 \$22240 \$23502 NWELL PWELL BULK MUX2_X1
X$34351 \$11414 \$17801 NWELL PWELL BULK BUF_X4
X$34353 \$11414 \$29749 NWELL PWELL BULK BUF_X4
X$34357 \$24703 \$11414 NWELL PWELL BULK BUF_X4
X$34395 \$11517 \$11428 NWELL PWELL BULK INV_X1
X$34398 \$13491 \$13490 \$11431 NWELL PWELL BULK NOR2_X2
X$34403 \$11431 \$11872 \$11778 \$12504 NWELL PWELL BULK OAI21_X1
X$34405 \$11431 \$11439 \$11791 NWELL PWELL BULK NAND2_X1
X$34407 \$11778 \$11431 \$11432 NWELL PWELL BULK NAND2_X1
X$34413 \$11439 \$11431 \$13245 NWELL PWELL BULK AND2_X1
X$34429 \$12711 \$12446 \$11435 \$12116 NWELL PWELL BULK AOI21_X1
X$34432 \$11499 \$11496 \$11438 \$11861 NWELL PWELL BULK AOI21_X1
X$34435 \$11439 \$12122 \$11787 \$11786 NWELL PWELL BULK OAI21_X1
X$34438 \$11857 \$11788 \$11439 \$11787 NWELL PWELL BULK NAND3_X1
X$34448 \$11788 \$11439 \$12985 NWELL PWELL BULK NOR2_X1
X$34451 \$11439 \$12493 \$11788 \$12503 NWELL PWELL BULK OAI21_X1
X$34460 \$11792 \$12118 \$11441 \$11841 NWELL PWELL BULK OAI21_X1
X$34473 \$11496 \$11443 \$11444 NWELL PWELL BULK NOR2_X1
X$34478 \$11840 \$11841 \$13165 \$11797 \$11443 NWELL PWELL BULK AOI22_X4
X$34480 \$11443 \$12995 NWELL PWELL BULK INV_X2
X$34482 \$13840 \$13972 \$14208 \$13839 \$11443 NWELL PWELL BULK AOI22_X4
X$34485 \$11788 \$11443 \$13840 NWELL PWELL BULK NOR2_X1
X$34487 \$11443 \$13494 \$13843 \$13497 NWELL PWELL BULK OAI21_X1
X$34489 \$11486 \$11443 \$13601 NWELL PWELL BULK NOR2_X1
X$34507 \$12143 \$12291 \$11452 NWELL PWELL BULK XNOR2_X1
X$34514 \$12147 \$11813 \$11455 NWELL PWELL BULK NAND2_X1
X$34523 \$11459 S1_AXI_AWID[7] NWELL PWELL BULK BUF_X1
X$34534 \$12139 \$11800 \$11809 \$11467 NWELL PWELL BULK MUX2_X1
X$34552 \$11846 \$12122 \$12131 \$11479 \$12362 NWELL PWELL BULK OAI22_X1
X$34555 \$14529 \$11479 \$13838 \$14203 NWELL PWELL BULK OAI21_X1
X$34557 \$13198 \$12122 \$13179 \$11479 \$13187 NWELL PWELL BULK OAI22_X1
X$34577 \$11486 \$17376 \$20159 \$20160 \$19778 NWELL PWELL BULK OR4_X4
X$34610 \$11788 \$11496 \$11791 \$12366 \$11792 NWELL PWELL BULK AOI22_X2
X$34612 \$11496 \$12723 \$11798 \$12996 \$13162 NWELL PWELL BULK OR4_X4
X$34617 \$12366 \$11496 \$11788 \$13218 NWELL PWELL BULK AOI21_X1
X$34619 \$11496 \$12366 \$13280 NWELL PWELL BULK NOR2_X1
X$34623 \$13320 \$11496 \$13321 NWELL PWELL BULK NAND2_X1
X$34653 \$11508 \$12271 \$11991 NWELL PWELL BULK XOR2_X1
X$34655 \$11508 \$12276 NWELL PWELL BULK INV_X1
X$34798 \$32460 \$52066 \$11674 \$50986 \$32461 NWELL PWELL BULK AOI22_X4
X$34847 \$11881 \$12271 \$12280 \$12276 \$11703 NWELL PWELL BULK FA_X1
X$34853 \$11997 \$11704 \$12281 NWELL PWELL BULK XNOR2_X1
X$34879 \$12035 \$11730 \$12033 \$12397 \$16197 NWELL PWELL BULK NAND4_X4
X$34882 \$11730 \$12035 \$12397 \$12033 \$14141 NWELL PWELL BULK AND4_X4
X$34890 \$14155 \$11736 \$13284 \$14424 \$16650 NWELL PWELL BULK NOR4_X4
X$34901 \$12044 \$11741 NWELL PWELL BULK INV_X2
X$34908 \$11746 \$12059 NWELL PWELL BULK INV_X1
X$34931 \$11765 \$12088 \$11763 \$11764 NWELL PWELL BULK MUX2_X1
X$34969 \$I178893 \$11875 \$11775 \$12700 NWELL PWELL BULK DFF_X1
X$34972 \$11871 \$12503 \$11778 \$11777 NWELL PWELL BULK AOI21_X1
X$34974 \$12701 \$11875 \$11778 NWELL PWELL BULK NOR2_X1
X$34991 \$13490 \$13491 \$11788 NWELL PWELL BULK OR2_X2
X$35022 \$16730 \$16724 \$11796 \$16732 NWELL PWELL BULK OR3_X4
X$35024 \$11796 \$16724 \$13596 \$13165 \$16860 NWELL PWELL BULK AND4_X1
X$35026 \$13596 \$13165 \$11796 \$14208 \$13494 NWELL PWELL BULK NAND4_X4
X$35029 \$17376 \$13596 \$11798 \$11796 \$17250 NWELL PWELL BULK OAI22_X1
X$35033 \$13596 \$16724 \$11796 \$13165 \$16737 NWELL PWELL BULK NAND4_X2
X$35035 \$13596 \$15399 \$11796 \$14208 \$15926 NWELL PWELL BULK NAND4_X4
X$35037 \$14208 \$11796 \$15925 \$16313 NWELL PWELL BULK NAND3_X4
X$35046 \$11797 \$12131 NWELL PWELL BULK INV_X1
X$35057 \$11798 \$15398 \$16463 \$14530 \$15919 NWELL PWELL BULK OAI22_X1
X$35060 \$13145 \$11798 \$14696 \$15130 \$14514 NWELL PWELL BULK NOR4_X4
X$35073 \$12134 \$11800 \$11801 \$11802 NWELL PWELL BULK MUX2_X1
X$35076 \$13004 \$11800 \$12729 \$13107 NWELL PWELL BULK MUX2_X1
X$35079 \$13907 \$11800 \$13853 \$13568 NWELL PWELL BULK MUX2_X1
X$35082 \$15930 \$11800 \$15927 \$15553 NWELL PWELL BULK MUX2_X1
X$35084 \$16353 \$11800 \$16356 \$16361 NWELL PWELL BULK MUX2_X1
X$35086 \$14550 \$11800 \$14548 \$14653 NWELL PWELL BULK MUX2_X1
X$35089 \$15058 \$11800 \$14210 \$15558 NWELL PWELL BULK MUX2_X1
X$35103 S2_AXI_BID[4] \$11801 NWELL PWELL BULK BUF_X1
X$35110 \$11801 \$12725 \$12727 \$13136 NWELL PWELL BULK MUX2_X1
X$35124 S2_AXI_BRESP[0] \$11809 NWELL PWELL BULK BUF_X1
X$35127 \$11809 \$12725 \$12755 \$12735 NWELL PWELL BULK MUX2_X1
X$35141 \$13860 \$15069 \$11812 \$15070 NWELL PWELL BULK AND3_X2
X$35144 \$11812 \$12750 \$13895 NWELL PWELL BULK NAND2_X1
X$35147 \$11812 \$13513 \$14219 NWELL PWELL BULK NAND2_X1
X$35150 \$11812 \$13554 \$13557 NWELL PWELL BULK NAND2_X1
X$35152 \$13860 \$13516 \$11812 \$14221 NWELL PWELL BULK AND3_X2
X$35155 \$11812 \$12143 \$12284 NWELL PWELL BULK NAND2_X1
X$35157 \$11812 \$13564 \$13069 NWELL PWELL BULK NAND2_X1
X$35160 \$12142 \$11812 NWELL PWELL BULK INV_X2
X$35172 \$11814 \$11813 \$12743 NWELL PWELL BULK NAND2_X1
X$35180 \$11814 \$11818 \$12156 NWELL PWELL BULK NAND2_X1
X$35182 \$12147 \$11814 NWELL PWELL BULK INV_X2
X$35185 \$11814 \$11816 \$12149 NWELL PWELL BULK NAND2_X1
X$35189 \$11814 \$12154 \$12153 NWELL PWELL BULK NAND2_X1
X$35208 \$12154 \$12156 \$11821 NWELL PWELL BULK XNOR2_X1
X$35222 \$11833 S1_AXI_AWADDR[0] NWELL PWELL BULK BUF_X1
X$35264 \$12989 \$12990 \$12122 \$11861 \$12988 NWELL PWELL BULK OAI22_X1
X$35400 \$11982 \$33415 \$28042 \$32461 NWELL PWELL BULK AOI21_X4
X$35430 \$11997 \$33867 \$33866 NWELL PWELL BULK OR2_X1
X$35436 \$33867 \$11997 \$34452 NWELL PWELL BULK NOR2_X2
X$35438 \$11997 \$34449 \$34756 \$35112 NWELL PWELL BULK OR3_X2
X$35550 \$12950 \$12955 \$12062 \$13732 NWELL PWELL BULK MUX2_X1
X$35573 \$I177709 \$12070 \$13349 \$13468 NWELL PWELL BULK DFF_X1
X$35613 \$22310 \$12088 \$22298 \$22819 NWELL PWELL BULK MUX2_X1
X$35616 \$19730 \$12088 \$19729 \$19944 NWELL PWELL BULK MUX2_X1
X$35618 \$25434 \$12088 \$24528 \$26484 NWELL PWELL BULK MUX2_X1
X$35621 \$13823 \$12088 \$13668 \$14036 NWELL PWELL BULK MUX2_X1
X$35627 \$16688 \$12088 \$16686 \$17143 NWELL PWELL BULK MUX2_X1
X$35629 \$16096 \$12088 \$16245 \$16097 NWELL PWELL BULK MUX2_X1
X$35631 \$17224 \$12088 \$17221 \$17518 NWELL PWELL BULK MUX2_X1
X$35633 \$23258 \$12088 \$23806 \$23971 NWELL PWELL BULK MUX2_X1
X$35636 \$27485 \$12088 \$26485 \$27483 NWELL PWELL BULK MUX2_X1
X$35638 \$25431 \$12088 \$25975 \$25428 NWELL PWELL BULK MUX2_X1
X$35642 \$26171 \$12088 \$24990 \$26174 NWELL PWELL BULK MUX2_X1
X$35646 \$12088 \$16670 NWELL PWELL BULK BUF_X8
X$35695 \$I177060 \$12106 \$13341 \$12700 NWELL PWELL BULK DFF_X1
X$35706 \$20159 \$20160 \$19778 \$17376 \$12118 NWELL PWELL BULK NOR4_X2
X$35733 \$13206 \$13204 \$12131 \$15399 \$12995 NWELL PWELL BULK OAI22_X4
X$35751 \$15057 \$16017 \$16293 \$12142 NWELL PWELL BULK OAI21_X4
X$35754 \$13860 \$15069 \$12142 \$15463 NWELL PWELL BULK NOR3_X4
X$35756 \$12142 \$13516 \$13517 NWELL PWELL BULK NAND2_X1
X$35758 \$12142 \$12750 \$13857 NWELL PWELL BULK NAND2_X1
X$35761 \$12142 \$13513 \$13512 NWELL PWELL BULK NAND2_X1
X$35764 \$12142 \$12148 \$12251 NWELL PWELL BULK NAND2_X1
X$35766 \$12142 \$12738 \$12291 NWELL PWELL BULK NOR2_X1
X$35768 \$12142 \$13860 \$14640 NWELL PWELL BULK NAND2_X1
X$35771 \$13860 \$13516 \$12142 \$15071 NWELL PWELL BULK NOR3_X4
X$35789 \$14226 \$14559 \$12147 NWELL PWELL BULK NAND2_X2
X$35793 \$12147 \$12178 \$12182 NWELL PWELL BULK NAND2_X1
X$35801 \$12147 \$13862 \$13533 NWELL PWELL BULK NAND2_X1
X$35803 \$12147 \$13520 \$13888 NWELL PWELL BULK NAND2_X1
X$35814 \$12148 \$12178 \$12152 NWELL PWELL BULK XNOR2_X1
X$35824 \$13870 \$12152 \$13861 \$14226 NWELL PWELL BULK NAND3_X1
X$36052 \$27089 \$12425 \$23579 \$28752 \$29163 NWELL PWELL BULK NAND4_X1
X$36056 \$23194 \$12425 \$26812 NWELL PWELL BULK NAND2_X2
X$36058 \$12425 \$23194 \$27427 NWELL PWELL BULK AND2_X2
X$36064 \$12425 \$20687 \$22707 \$23210 \$22719 NWELL PWELL BULK NAND4_X2
X$36067 \$12425 \$20687 \$20849 NWELL PWELL BULK NAND2_X1
X$36069 \$19704 \$12425 \$23579 \$23195 \$24053 NWELL PWELL BULK NAND4_X2
X$36164 \$I175920 \$12535 \$12540 \$12700 NWELL PWELL BULK DFF_X1
X$36222 \$32460 \$32652 \$12610 \$32462 \$32461 NWELL PWELL BULK AOI22_X4
X$36226 \$13032 \$12610 \$12611 \$13030 NWELL PWELL BULK AOI21_X1
X$36237 \$14962 \$12611 \$14368 \$14963 NWELL PWELL BULK MUX2_X1
X$36239 \$21749 \$20886 \$12611 \$21748 NWELL PWELL BULK AOI21_X1
X$36242 \$12611 \$20889 \$21516 NWELL PWELL BULK NOR2_X1
X$36244 \$21516 \$20027 \$12611 \$21335 NWELL PWELL BULK AOI21_X1
X$36247 \$20624 \$18845 \$12611 \$20019 NWELL PWELL BULK AOI21_X1
X$36250 \$12611 \$21750 \$21749 NWELL PWELL BULK NOR2_X1
X$36253 \$12611 \$15270 \$14954 NWELL PWELL BULK NOR2_X1
X$36256 \$17702 \$17898 \$12611 \$17704 NWELL PWELL BULK AOI21_X1
X$36259 \$14954 \$14951 \$12611 \$15267 NWELL PWELL BULK AOI21_X1
X$36262 \$12611 \$15272 \$15816 NWELL PWELL BULK NOR2_X1
X$36265 \$15816 \$15813 \$12611 \$15448 NWELL PWELL BULK AOI21_X1
X$36268 \$17541 \$17156 \$12611 \$17294 NWELL PWELL BULK AOI21_X1
X$36270 \$15812 \$15437 \$12611 \$15977 NWELL PWELL BULK AOI21_X1
X$36272 \$12611 \$15980 \$15812 NWELL PWELL BULK NOR2_X1
X$36274 \$12611 \$17902 \$17702 NWELL PWELL BULK NOR2_X1
X$36277 \$18876 \$17896 \$12611 \$19201 NWELL PWELL BULK AOI21_X1
X$36279 \$12611 \$18728 \$18876 NWELL PWELL BULK NOR2_X1
X$36281 \$12611 \$14385 NWELL PWELL BULK BUF_X8
X$36284 \$12611 \$20192 \$20624 NWELL PWELL BULK NOR2_X1
X$36286 \$12611 \$18726 \$18305 NWELL PWELL BULK NOR2_X1
X$36289 \$18305 \$18303 \$12611 \$18868 NWELL PWELL BULK AOI21_X1
X$36292 \$12611 \$17155 \$17541 NWELL PWELL BULK NOR2_X1
X$36294 \$16385 \$14104 \$12611 \$15470 NWELL PWELL BULK AOI21_X1
X$36297 \$12611 \$15277 \$16385 NWELL PWELL BULK NOR2_X1
X$36299 \$12611 \$14097 \$14096 NWELL PWELL BULK NOR2_X1
X$36302 \$18735 \$17326 \$12611 \$18504 NWELL PWELL BULK AOI21_X1
X$36304 \$12611 \$18095 \$18735 NWELL PWELL BULK NOR2_X1
X$36306 \$14096 \$14095 \$12611 \$14362 NWELL PWELL BULK AOI21_X1
X$36309 \$12611 \$14584 \$14090 NWELL PWELL BULK NOR2_X1
X$36311 \$14090 \$13738 \$12611 \$14089 NWELL PWELL BULK AOI21_X1
X$36313 \$12611 \$12874 \$13032 NWELL PWELL BULK NOR2_X1
X$36337 \$32460 \$50696 \$12612 \$51021 \$32461 NWELL PWELL BULK AOI22_X4
X$36473 \$I176005 \$13346 \$13835 \$12700 NWELL PWELL BULK DFF_X1
X$36475 \$I177062 \$12977 \$13634 \$12700 NWELL PWELL BULK DFF_X1
X$36477 \$I177076 \$12974 \$13640 \$12700 NWELL PWELL BULK DFF_X1
X$36479 \$I178366 \$17233 \$17610 \$12700 NWELL PWELL BULK DFF_X1
X$36481 \$I178440 \$16537 \$16260 \$12700 NWELL PWELL BULK DFF_X1
X$36484 \$I176641 \$16057 \$16545 \$12700 NWELL PWELL BULK DFF_X1
X$36486 \$I176677 \$15039 \$15357 \$12700 NWELL PWELL BULK DFF_X1
X$36489 \$I176274 \$15036 \$15355 \$12700 NWELL PWELL BULK DFF_X1
X$36492 \$I175529 \$18797 \$18796 \$12700 NWELL PWELL BULK DFF_X1
X$36494 \$I178281 \$18795 \$18981 \$12700 NWELL PWELL BULK DFF_X1
X$36496 \$I178396 \$18171 \$18172 \$12700 NWELL PWELL BULK DFF_X1
X$36499 \$I175643 \$18418 \$18569 \$12700 NWELL PWELL BULK DFF_X1
X$36502 \$I174569 \$16262 \$17106 \$12700 NWELL PWELL BULK DFF_X1
X$36504 \$I178977 \$16263 \$17092 \$12700 NWELL PWELL BULK DFF_X1
X$36509 \$I178443 \$14498 \$15771 \$12700 NWELL PWELL BULK DFF_X1
X$36512 \$I175090 \$17236 \$17477 \$12700 NWELL PWELL BULK DFF_X1
X$36514 \$I175969 \$14004 \$14005 \$12700 NWELL PWELL BULK DFF_X1
X$36518 \$I177074 \$12972 \$13644 \$12700 NWELL PWELL BULK DFF_X1
X$36522 \$I177009 \$16528 \$16266 \$12700 NWELL PWELL BULK DFF_X1
X$36524 \$15764 \$12700 \$15368 \$14517 NWELL PWELL BULK DFF_X2
X$36526 \$I174283 \$16703 \$17086 \$12700 NWELL PWELL BULK DFF_X1
X$36529 \$14273 \$12700 \$14197 \$14193 NWELL PWELL BULK DFF_X2
X$36532 \$13989 \$12700 \$14266 \$14199 NWELL PWELL BULK DFF_X2
X$36535 \$I174638 \$12701 \$13328 \$12700 NWELL PWELL BULK DFF_X1
X$36538 \$I175636 \$14888 \$14897 \$12700 NWELL PWELL BULK DFF_X1
X$36541 \$I175681 \$14191 \$14496 \$12700 NWELL PWELL BULK DFF_X1
X$36567 \$12710 \$12701 \$12981 NWELL PWELL BULK NAND2_X1
X$36583 \$14540 \$15060 \$12769 \$12723 NWELL PWELL BULK MUX2_X2
X$36597 \$12724 \$12763 \$12769 \$13145 NWELL PWELL BULK MUX2_X2
X$36599 \$12724 \$12769 \$13162 NWELL PWELL BULK NOR2_X2
X$36602 \$14210 \$12725 \$13501 \$13947 NWELL PWELL BULK MUX2_X1
X$36606 \$16356 \$12725 \$18018 \$17679 NWELL PWELL BULK MUX2_X1
X$36609 \$15927 \$12725 \$17626 \$17256 NWELL PWELL BULK MUX2_X1
X$36611 \$14548 \$12725 \$14542 \$15118 NWELL PWELL BULK MUX2_X1
X$36613 \$13853 \$12725 \$15487 \$15985 NWELL PWELL BULK MUX2_X1
X$36618 \$12729 \$12725 \$13121 \$13003 NWELL PWELL BULK MUX2_X1
X$36639 S2_AXI_BRESP[1] \$12729 NWELL PWELL BULK BUF_X1
X$36653 \$12769 \$12734 \$12761 NWELL PWELL BULK OR2_X1
X$36659 \$13062 \$12738 NWELL PWELL BULK INV_X1
X$36670 \$13513 \$12750 \$13554 \$13062 NWELL PWELL BULK HA_X1
X$36679 \$12999 \$13079 \$12761 \$14549 NWELL PWELL BULK OAI21_X1
X$36684 \$12763 \$12999 \$12996 NWELL PWELL BULK NOR2_X2
X$36693 \$12769 \$16789 \$16795 NWELL PWELL BULK OR2_X1
X$36695 \$12769 \$16295 \$16897 NWELL PWELL BULK OR2_X1
X$36697 \$12769 \$13509 \$14216 NWELL PWELL BULK OR2_X1
X$36701 \$12769 \$13923 \$14214 NWELL PWELL BULK OR2_X1
X$36704 \$12769 \$12999 NWELL PWELL BULK INV_X4
X$36708 \$14540 \$12769 \$14696 NWELL PWELL BULK NOR2_X1
X$36711 \$12769 \$14672 \$15532 NWELL PWELL BULK OR2_X1
X$36812 \$12884 S1_AXI_AWADDR[21] NWELL PWELL BULK BUF_X1
X$36825 \$12889 \$13891 \$12890 NWELL PWELL BULK NOR2_X1
X$36827 \$12890 \$13419 \$12889 \$13555 NWELL PWELL BULK AOI21_X1
X$36829 \$12889 \$14380 \$14272 NWELL PWELL BULK NOR2_X1
X$36831 \$14272 \$13750 \$12889 \$14270 NWELL PWELL BULK AOI21_X1
X$36833 \$17900 \$17898 \$12889 \$18492 NWELL PWELL BULK AOI21_X1
X$36835 \$12889 \$19419 \$19550 NWELL PWELL BULK NOR2_X1
X$36837 \$12889 \$19842 \$20248 NWELL PWELL BULK NOR2_X1
X$36839 \$19550 \$17896 \$12889 \$19417 NWELL PWELL BULK AOI21_X1
X$36841 \$12889 \$18311 \$17900 NWELL PWELL BULK NOR2_X1
X$36843 \$12889 \$17547 \$18067 NWELL PWELL BULK NOR2_X1
X$36845 \$18067 \$15813 \$12889 \$17544 NWELL PWELL BULK AOI21_X1
X$36847 \$12889 \$20026 \$20211 NWELL PWELL BULK NOR2_X1
X$36849 \$20211 \$20027 \$12889 \$19820 NWELL PWELL BULK AOI21_X1
X$36851 \$12889 \$19663 \$20233 NWELL PWELL BULK NOR2_X1
X$36853 \$20233 \$20229 \$12889 \$19830 NWELL PWELL BULK AOI21_X1
X$36855 \$16808 \$17326 \$12889 \$17324 NWELL PWELL BULK AOI21_X1
X$36857 \$12889 \$16811 \$16808 NWELL PWELL BULK NOR2_X1
X$36859 \$19862 \$20283 \$12889 \$19082 NWELL PWELL BULK AOI21_X1
X$36861 \$12889 \$19572 \$19862 NWELL PWELL BULK NOR2_X1
X$36863 \$20248 \$20254 \$12889 \$19420 NWELL PWELL BULK AOI21_X1
X$36865 \$19078 \$19563 \$12889 \$19229 NWELL PWELL BULK AOI21_X1
X$36868 \$12889 \$19233 \$19078 NWELL PWELL BULK NOR2_X1
X$36871 \$14373 \$14104 \$12889 \$14630 NWELL PWELL BULK AOI21_X1
X$36874 \$12889 \$14374 \$14373 NWELL PWELL BULK NOR2_X1
X$36877 \$22005 \$20820 \$12889 \$21566 NWELL PWELL BULK AOI21_X1
X$36880 \$12889 \$21143 \$22005 NWELL PWELL BULK NOR2_X1
X$36883 \$12889 \$19089 \$19088 NWELL PWELL BULK NOR2_X1
X$36885 \$19088 \$18526 \$12889 \$19087 NWELL PWELL BULK AOI21_X1
X$36889 \$19084 \$19425 \$12889 \$19240 NWELL PWELL BULK AOI21_X1
X$36891 \$12889 \$18321 \$18320 NWELL PWELL BULK NOR2_X1
X$36893 \$18320 \$17336 \$12889 \$18515 NWELL PWELL BULK AOI21_X1
X$36895 \$12889 \$19085 \$19084 NWELL PWELL BULK NOR2_X1
X$36925 \$12894 \$35478 \$24911 \$32461 NWELL PWELL BULK AOI21_X4
X$36932 \$14384 \$12894 \$14385 \$15135 NWELL PWELL BULK AOI21_X1
X$37023 \$15330 \$16216 \$16970 \$12947 \$19115 NWELL PWELL BULK NOR4_X4
X$37044 \$15013 \$12955 \$14163 \$14861 NWELL PWELL BULK MUX2_X1
X$37047 \$14870 \$12955 \$14313 \$15015 NWELL PWELL BULK MUX2_X1
X$37050 \$28951 \$12955 \$28776 \$28952 NWELL PWELL BULK MUX2_X1
X$37053 \$17965 \$12955 \$17826 \$17963 NWELL PWELL BULK MUX2_X1
X$37055 \$16237 \$12955 \$16218 \$16236 NWELL PWELL BULK MUX2_X1
X$37058 \$30790 \$12955 \$27450 \$31454 NWELL PWELL BULK MUX2_X1
X$37060 \$30074 \$12955 \$27101 \$30075 NWELL PWELL BULK MUX2_X1
X$37062 \$14462 \$12955 \$14464 \$15212 NWELL PWELL BULK MUX2_X1
X$37064 \$17594 \$12955 \$17595 \$17851 NWELL PWELL BULK MUX2_X1
X$37068 \$13469 \$12955 \$12957 \$13708 NWELL PWELL BULK MUX2_X1
X$37071 \$29179 \$12955 \$28371 \$29178 NWELL PWELL BULK MUX2_X1
X$37073 \$30077 \$30290 \$30083 \$12955 NWELL PWELL BULK NOR3_X4
X$37076 \$20094 \$12955 \$19463 \$20509 NWELL PWELL BULK MUX2_X1
X$37078 \$16214 \$12955 \$15865 \$16536 NWELL PWELL BULK MUX2_X1
X$37080 \$22929 \$12955 \$23239 \$23051 NWELL PWELL BULK MUX2_X1
X$37113 \$I174737 \$12956 \$14078 \$13468 NWELL PWELL BULK DFF_X1
X$37156 \$I177281 \$12967 \$13655 \$13829 NWELL PWELL BULK DFF_X1
X$37200 \$12995 \$13844 \$12990 \$14741 NWELL PWELL BULK OAI21_X1
X$37209 \$12995 \$13182 \$13605 NWELL PWELL BULK NOR2_X1
X$37228 \$15060 \$12999 \$15130 NWELL PWELL BULK NOR2_X1
X$37230 \$16795 \$12999 \$16783 \$16739 NWELL PWELL BULK OAI21_X2
X$37232 \$16897 \$12999 \$17365 \$16733 NWELL PWELL BULK OAI21_X2
X$37234 \$14216 \$12999 \$14649 \$14239 NWELL PWELL BULK OAI21_X2
X$37237 \$12999 \$13924 \$14214 \$14213 NWELL PWELL BULK OAI21_X1
X$37239 \$15532 \$12999 \$15066 \$15406 NWELL PWELL BULK OAI21_X2
X$37266 \$19521 \$13014 \$19522 \$19528 NWELL PWELL BULK MUX2_X1
X$37268 \$18840 \$13014 \$19795 \$18837 NWELL PWELL BULK MUX2_X1
X$37270 \$16343 \$13014 \$16323 \$16753 NWELL PWELL BULK MUX2_X1
X$37273 \$17302 \$13014 \$17669 \$17655 NWELL PWELL BULK MUX2_X1
X$37275 \$15429 \$13014 \$15415 \$15433 NWELL PWELL BULK MUX2_X1
X$37278 \$18023 \$13014 \$17642 \$18448 NWELL PWELL BULK MUX2_X1
X$37291 \$13026 S1_AXI_AWSIZE[0] NWELL PWELL BULK BUF_X1
X$37301 \$I178048 \$13410 \$13033 \$13875 NWELL PWELL BULK DFF_X1
X$37382 \$32460 \$47539 \$13117 \$47874 \$33856 NWELL PWELL BULK AOI22_X4
X$37404 \$I175552 \$13943 \$13126 \$13438 NWELL PWELL BULK DFF_X1
X$37446 \$13165 \$13596 \$16730 NWELL PWELL BULK NAND2_X1
X$37459 \$13171 \$13179 NWELL PWELL BULK INV_X1
X$37484 \$13596 \$13605 \$13601 \$13196 NWELL PWELL BULK AOI21_X4
X$37545 \$13261 \$14047 NWELL PWELL BULK INV_X1
X$37569 \$13282 \$13461 NWELL PWELL BULK INV_X1
X$37572 \$16208 \$16666 \$16507 \$13282 \$17582 NWELL PWELL BULK OR4_X2
X$37574 \$16208 \$16666 \$16507 \$13282 \$17201 NWELL PWELL BULK NOR4_X4
X$37647 \$I177261 \$13355 \$13471 \$13468 NWELL PWELL BULK DFF_X1
X$37658 \$I177299 \$13365 \$13473 \$13468 NWELL PWELL BULK DFF_X1
X$37699 \$I178056 \$13413 \$13537 \$13875 NWELL PWELL BULK DFF_X1
X$37716 \$13419 \$33614 \$30890 \$32461 NWELL PWELL BULK AOI21_X4
X$37730 \$32460 \$33049 \$13430 \$33856 \$27239 NWELL PWELL BULK AOI22_X4
X$37754 \$I175062 \$17181 \$17396 \$13438 NWELL PWELL BULK DFF_X1
X$37756 \$I177370 \$15597 \$15847 \$13438 NWELL PWELL BULK DFF_X1
X$37758 \$I178291 \$13610 \$13764 \$13438 NWELL PWELL BULK DFF_X1
X$37761 \$I174838 \$18346 \$18579 \$13438 NWELL PWELL BULK DFF_X1
X$37763 \$I177286 \$16627 \$17374 \$13438 NWELL PWELL BULK DFF_X1
X$37766 \$I175216 \$16629 \$17385 \$13438 NWELL PWELL BULK DFF_X1
X$37769 \$I175213 \$14979 \$15305 \$13438 NWELL PWELL BULK DFF_X1
X$37772 \$I174738 \$16908 \$16461 \$13438 NWELL PWELL BULK DFF_X1
X$37774 \$I175349 \$15309 \$15592 \$13438 NWELL PWELL BULK DFF_X1
X$37777 \$I176600 \$15576 \$15573 \$13438 NWELL PWELL BULK DFF_X1
X$37780 \$I174804 \$17924 \$18176 \$13438 NWELL PWELL BULK DFF_X1
X$37782 \$I175205 \$18179 \$17778 \$13438 NWELL PWELL BULK DFF_X1
X$37784 \$I176557 \$17922 \$18168 \$13438 NWELL PWELL BULK DFF_X1
X$37787 \$19620 \$19438 \$19096 \$13438 NWELL PWELL BULK DFF_X1
X$37790 \$I177977 \$17563 \$17768 \$13438 NWELL PWELL BULK DFF_X1
X$37792 \$19916 \$19281 \$19286 \$13438 NWELL PWELL BULK DFF_X1
X$37794 \$I177978 \$15298 \$16434 \$13438 NWELL PWELL BULK DFF_X1
X$37796 \$I176097 \$15841 \$15292 \$13438 NWELL PWELL BULK DFF_X1
X$37798 \$I176518 \$16178 \$16451 \$13438 NWELL PWELL BULK DFF_X1
X$37800 \$19919 \$19613 \$18961 \$13438 NWELL PWELL BULK DFF_X1
X$37803 \$I177975 \$18563 \$18952 \$13438 NWELL PWELL BULK DFF_X1
X$37805 \$I176297 \$15526 \$15148 \$13438 NWELL PWELL BULK DFF_X1
X$37807 \$I176291 \$13763 \$14394 \$13438 NWELL PWELL BULK DFF_X1
X$37809 \$I176300 \$14117 \$14684 \$13438 NWELL PWELL BULK DFF_X1
X$37811 \$I176239 \$15844 \$16171 \$13438 NWELL PWELL BULK DFF_X1
X$37814 \$I177929 \$15562 \$15845 \$13438 NWELL PWELL BULK DFF_X1
X$37816 \$I176217 \$17562 \$17560 \$13438 NWELL PWELL BULK DFF_X1
X$37819 \$I176416 \$15551 \$14972 \$13438 NWELL PWELL BULK DFF_X1
X$37822 \$I177883 \$16624 \$17361 \$13438 NWELL PWELL BULK DFF_X1
X$37862 \$13452 \$14080 NWELL PWELL BULK INV_X1
X$37888 \$13798 \$13464 NWELL PWELL BULK INV_X2
X$37902 \$I176103 \$17072 \$16232 \$13468 NWELL PWELL BULK DFF_X1
X$37905 \$I174285 \$15740 \$15742 \$13468 NWELL PWELL BULK DFF_X1
X$37907 \$I176102 \$17596 \$17838 \$13468 NWELL PWELL BULK DFF_X1
X$37909 \$I176104 \$16123 \$15873 \$13468 NWELL PWELL BULK DFF_X1
X$37911 \$I175745 \$15337 \$16126 \$13468 NWELL PWELL BULK DFF_X1
X$37913 \$I176977 \$17962 \$18713 \$13468 NWELL PWELL BULK DFF_X1
X$37915 \$I177406 \$20096 \$20525 \$13468 NWELL PWELL BULK DFF_X1
X$37917 \$I174464 \$19123 \$19967 \$13468 NWELL PWELL BULK DFF_X1
X$37919 \$I176326 \$18263 \$18268 \$13468 NWELL PWELL BULK DFF_X1
X$37921 \$I175790 \$17955 \$18702 \$13468 NWELL PWELL BULK DFF_X1
X$37923 \$I174527 \$17594 \$17851 \$13468 NWELL PWELL BULK DFF_X1
X$37926 \$I178092 \$16226 \$16669 \$13468 NWELL PWELL BULK DFF_X1
X$37928 \$I174556 \$16672 \$17063 \$13468 NWELL PWELL BULK DFF_X1
X$37934 \$I177254 \$14462 \$15212 \$13468 NWELL PWELL BULK DFF_X1
X$37940 \$I177389 \$13469 \$13708 \$13468 NWELL PWELL BULK DFF_X1
X$37943 \$I175647 \$14463 \$14905 \$13468 NWELL PWELL BULK DFF_X1
X$37945 \$I175419 \$13814 \$14460 \$13468 NWELL PWELL BULK DFF_X1
X$37948 \$I175753 \$14168 \$15233 \$13468 NWELL PWELL BULK DFF_X1
X$37951 \$I175654 \$14458 \$15222 \$13468 NWELL PWELL BULK DFF_X1
X$37954 \$19125 \$18780 \$19043 \$13468 NWELL PWELL BULK DFF_X1
X$37957 \$19958 \$19956 \$19959 \$13468 NWELL PWELL BULK DFF_X1
X$37960 \$19474 \$19472 \$19409 \$13468 NWELL PWELL BULK DFF_X1
X$37962 \$I177473 \$19964 \$18779 \$13468 NWELL PWELL BULK DFF_X1
X$37965 \$I175742 \$19467 \$19721 \$13468 NWELL PWELL BULK DFF_X1
X$37967 \$20708 \$20543 \$20822 \$13468 NWELL PWELL BULK DFF_X1
X$37969 \$20712 \$20988 \$21256 \$13468 NWELL PWELL BULK DFF_X1
X$38015 \$I176514 \$13486 \$13828 \$13829 NWELL PWELL BULK DFF_X1
X$38018 \$14180 \$14487 \$13486 \$13487 NWELL PWELL BULK MUX2_X1
X$38026 \$16921 \$13490 \$17050 \$15910 NWELL PWELL BULK NAND3_X1
X$38029 \$17050 \$13490 \$16921 \$14515 NWELL PWELL BULK AND3_X2
X$38032 \$16921 \$13490 \$18421 \$18804 NWELL PWELL BULK NAND3_X2
X$38035 \$18421 \$13490 \$16921 \$18801 NWELL PWELL BULK AND3_X2
X$38043 \$28864 \$27889 \$13490 \$28860 NWELL PWELL BULK MUX2_X1
X$38046 \$29373 \$25445 \$I245607 \$13490 NWELL PWELL BULK DFF_X2
X$38052 \$16921 \$18421 \$13491 NWELL PWELL BULK NAND2_X1
X$38065 \$13494 \$13953 \$15057 \$13843 NWELL PWELL BULK NAND3_X1
X$38081 \$13844 \$13953 \$13498 NWELL PWELL BULK NOR2_X1
X$38108 \$13516 \$13520 \$13870 NWELL PWELL BULK XNOR2_X1
X$38112 \$13516 \$15069 NWELL PWELL BULK INV_X1
X$38152 \$13544 S1_AXI_AWADDR[11] NWELL PWELL BULK BUF_X1
X$38210 \$15399 \$13596 \$15925 NWELL PWELL BULK NOR2_X1
X$38327 \$32460 \$32457 \$13738 \$32459 \$32461 NWELL PWELL BULK AOI22_X4
X$38345 \$I175521 \$13743 \$14366 \$13875 NWELL PWELL BULK DFF_X1
X$38356 \$16825 \$13750 \$14385 \$16394 NWELL PWELL BULK AOI21_X1
X$38360 \$13750 \$33834 \$23395 \$32461 NWELL PWELL BULK AOI21_X4
X$38402 \$32460 \$49503 \$13766 \$49512 \$33856 NWELL PWELL BULK AOI22_X4
X$38469 \$13791 \$14074 NWELL PWELL BULK INV_X1
X$38490 \$15675 \$15253 \$15677 \$13798 NWELL PWELL BULK MUX2_X1
X$38536 \$13826 \$15887 \$13827 \$14024 NWELL PWELL BULK MUX2_X1
X$38541 \$13826 \$14487 \$14485 \$14290 NWELL PWELL BULK MUX2_X1
X$38556 \$I177529 \$14492 \$14184 \$13829 NWELL PWELL BULK DFF_X1
X$38558 \$I177449 \$14490 \$14182 \$13829 NWELL PWELL BULK DFF_X1
X$38562 \$I178862 \$16072 \$15888 \$13829 NWELL PWELL BULK DFF_X1
X$38565 \$I176409 \$16249 \$16087 \$13829 NWELL PWELL BULK DFF_X1
X$38567 \$I177725 \$14482 \$15783 \$13829 NWELL PWELL BULK DFF_X1
X$38570 \$I179157 \$15351 \$15889 \$13829 NWELL PWELL BULK DFF_X1
X$38573 \$I176524 \$15796 \$15798 \$13829 NWELL PWELL BULK DFF_X1
X$38576 \$I177355 \$16688 \$17143 \$13829 NWELL PWELL BULK DFF_X1
X$38579 \$I174984 \$17151 \$17149 \$13829 NWELL PWELL BULK DFF_X1
X$38581 \$I177238 \$15028 \$15198 \$13829 NWELL PWELL BULK DFF_X1
X$38583 \$I175355 \$18786 \$19393 \$13829 NWELL PWELL BULK DFF_X1
X$38585 \$I177645 \$17976 \$18784 \$13829 NWELL PWELL BULK DFF_X1
X$38587 \$I178328 \$17227 \$17977 \$13829 NWELL PWELL BULK DFF_X1
X$38589 \$I174927 \$20115 \$20596 \$13829 NWELL PWELL BULK DFF_X1
X$38591 \$17801 \$13829 NWELL PWELL BULK BUF_X4
X$38594 \$I178861 \$17507 \$17135 \$13829 NWELL PWELL BULK DFF_X1
X$38596 \$I176439 \$16250 \$16566 \$13829 NWELL PWELL BULK DFF_X1
X$38598 \$I174753 \$18398 \$18624 \$13829 NWELL PWELL BULK DFF_X1
X$38600 \$I178658 \$19738 \$20121 \$13829 NWELL PWELL BULK DFF_X1
X$38602 \$I178585 \$19734 \$19482 \$13829 NWELL PWELL BULK DFF_X1
X$38605 \$I175266 \$19930 \$20613 \$13829 NWELL PWELL BULK DFF_X1
X$38607 \$I179161 \$20612 \$20619 \$13829 NWELL PWELL BULK DFF_X1
X$38609 \$I175228 \$20591 \$19741 \$13829 NWELL PWELL BULK DFF_X1
X$38611 \$I175323 \$18406 \$18608 \$13829 NWELL PWELL BULK DFF_X1
X$38614 \$I179121 \$19378 \$19131 \$13829 NWELL PWELL BULK DFF_X1
X$38617 \$I179208 \$17981 \$18403 \$13829 NWELL PWELL BULK DFF_X1
X$38619 \$I174960 \$20722 \$21210 \$13829 NWELL PWELL BULK DFF_X1
X$38621 \$I175631 \$14485 \$14947 \$13829 NWELL PWELL BULK DFF_X1
X$38623 \$I175683 \$14180 \$14486 \$13829 NWELL PWELL BULK DFF_X1
X$38671 \$13839 \$14529 NWELL PWELL BULK INV_X1
X$38694 S2_AXI_BID[3] \$13853 NWELL PWELL BULK BUF_X1
X$38722 \$13860 \$13862 \$13861 NWELL PWELL BULK XNOR2_X1
X$38750 \$I175856 \$15805 \$15265 \$13875 NWELL PWELL BULK DFF_X1
X$38752 \$I178145 \$16148 \$16331 \$13875 NWELL PWELL BULK DFF_X1
X$38754 \$I175755 \$15270 \$15267 \$13875 NWELL PWELL BULK DFF_X1
X$38757 \$I178205 \$17287 \$17154 \$13875 NWELL PWELL BULK DFF_X1
X$38760 \$I178215 \$16152 \$15808 \$13875 NWELL PWELL BULK DFF_X1
X$38764 \$I176028 \$20033 \$19665 \$13875 NWELL PWELL BULK DFF_X1
X$38767 \$I178211 \$16149 \$15973 \$13875 NWELL PWELL BULK DFF_X1
X$38769 \$I178202 \$14364 \$15103 \$13875 NWELL PWELL BULK DFF_X1
X$38772 \$I176003 \$15980 \$15977 \$13875 NWELL PWELL BULK DFF_X1
X$38774 \$I175761 \$16606 \$16764 \$13875 NWELL PWELL BULK DFF_X1
X$38776 \$I176014 \$17893 \$17673 \$13875 NWELL PWELL BULK DFF_X1
X$38778 \$I175869 \$20024 \$19814 \$13875 NWELL PWELL BULK DFF_X1
X$38781 \$I178160 \$20026 \$19820 \$13875 NWELL PWELL BULK DFF_X1
X$38783 \$I178208 \$17892 \$17889 \$13875 NWELL PWELL BULK DFF_X1
X$38785 \$I175865 \$18726 \$18868 \$13875 NWELL PWELL BULK DFF_X1
X$38787 \$I175868 \$20030 \$20627 \$13875 NWELL PWELL BULK DFF_X1
X$38790 \$I178343 \$19663 \$19830 \$13875 NWELL PWELL BULK DFF_X1
X$38792 \$I174421 \$18722 \$18718 \$13875 NWELL PWELL BULK DFF_X1
X$38795 \$I178207 \$19074 \$18041 \$13875 NWELL PWELL BULK DFF_X1
X$38797 \$I178209 \$16602 \$17664 \$13875 NWELL PWELL BULK DFF_X1
X$38799 \$I175858 \$17155 \$17294 \$13875 NWELL PWELL BULK DFF_X1
X$38801 \$I178147 \$20192 \$20019 \$13875 NWELL PWELL BULK DFF_X1
X$38803 \$I178123 \$19413 \$19184 \$13875 NWELL PWELL BULK DFF_X1
X$38806 \$I175885 \$18024 \$18450 \$13875 NWELL PWELL BULK DFF_X1
X$38809 \$I176039 \$13879 \$14237 \$13875 NWELL PWELL BULK DFF_X1
X$38815 \$I175494 \$14097 \$14362 \$13875 NWELL PWELL BULK DFF_X1
X$38817 \$I175493 \$14956 \$14361 \$13875 NWELL PWELL BULK DFF_X1
X$39010 \$26406 \$14065 \$19714 \$23209 \$26410 NWELL PWELL BULK OR4_X1
X$39012 \$14065 \$21317 \$22902 NWELL PWELL BULK NOR2_X2
X$39014 \$23209 \$19714 \$14065 \$27432 NWELL PWELL BULK NOR3_X2
X$39018 \$14065 \$21317 \$21828 \$20964 \$21729 NWELL PWELL BULK NOR4_X2
X$39021 \$21307 \$14065 \$20079 \$20967 NWELL PWELL BULK NOR3_X2
X$39025 \$23204 \$24104 \$23205 \$21317 \$14065 \$23216 \$23624 NWELL PWELL
+ BULK OAI33_X1
X$39027 \$14065 \$20947 \$20075 \$22192 \$22190 NWELL PWELL BULK OR4_X2
X$39029 \$20689 \$20075 \$20947 \$14065 \$21296 NWELL PWELL BULK NOR4_X1
X$39031 \$20079 \$14065 \$20689 \$20956 NWELL PWELL BULK OR3_X1
X$39033 \$22192 \$20075 \$20947 \$14065 \$22691 NWELL PWELL BULK NOR4_X1
X$39035 \$23209 \$19714 \$14065 \$26406 \$26842 NWELL PWELL BULK NOR4_X1
X$39089 \$32460 \$33209 \$14095 \$33391 \$32461 NWELL PWELL BULK AOI22_X4
X$39112 \$14104 \$37068 \$36275 \$32461 NWELL PWELL BULK AOI21_X4
X$39162 \$I175872 \$14131 \$14410 \$14411 NWELL PWELL BULK DFF_X1
X$39174 \$26399 \$21698 \$14141 \$25365 \$27417 NWELL PWELL BULK AOI211_X2
X$39176 \$21698 \$14141 \$25365 \$27301 NWELL PWELL BULK AOI21_X2
X$39178 \$21698 \$25900 \$14141 \$25365 \$25899 NWELL PWELL BULK AOI211_X2
X$39180 \$21698 \$25906 \$14141 \$25365 \$27081 NWELL PWELL BULK AOI211_X2
X$39183 \$21400 \$20970 \$14141 \$22167 \$21832 NWELL PWELL BULK NAND4_X4
X$39185 \$20967 \$20966 \$20969 \$21723 \$14141 NWELL PWELL BULK AOI22_X4
X$39188 \$21827 \$21697 \$21723 \$14141 \$22172 NWELL PWELL BULK AOI22_X2
X$39191 \$24356 \$14141 \$24488 \$21828 \$23782 NWELL PWELL BULK AOI22_X4
X$39193 \$21400 \$19457 \$14141 \$22167 \$27822 NWELL PWELL BULK NAND4_X4
X$39223 \$14146 \$14156 NWELL PWELL BULK INV_X1
X$39321 \$14504 \$14192 \$15908 NWELL PWELL BULK OR2_X1
X$39323 \$14192 \$14504 \$15360 NWELL PWELL BULK NOR2_X1
X$39325 \$14192 \$15362 \$14515 \$15364 NWELL PWELL BULK AOI21_X1
X$39328 \$14192 \$14193 \$14195 NWELL PWELL BULK NOR2_X1
X$39330 \$14502 \$14864 \$14192 \$14501 \$14867 NWELL PWELL BULK AOI22_X1
X$39332 \$14192 \$14199 \$14505 NWELL PWELL BULK NAND2_X1
X$39335 \$15048 \$14192 \$15683 NWELL PWELL BULK AND2_X1
X$39337 \$14192 \$15380 \$15717 \$15053 NWELL PWELL BULK OAI21_X2
X$39339 \$14515 \$14517 \$14192 \$14199 \$14516 \$15052 NWELL PWELL BULK
+ AOI221_X2
X$39341 \$20742 \$21027 \$21101 \$17376 \$14192 NWELL PWELL BULK NOR4_X4
X$39357 \$15364 \$14193 \$15044 NWELL PWELL BULK NOR2_X1
X$39359 \$15165 \$14848 \$14514 \$14199 \$14193 \$15368 \$16271 NWELL PWELL
+ BULK OAI33_X1
X$39365 \$14515 \$14517 \$14193 \$14199 \$14516 \$15717 NWELL PWELL BULK
+ AOI221_X2
X$39368 \$14193 \$15052 \$15676 NWELL PWELL BULK OR2_X1
X$39370 \$15680 \$14193 \$15052 \$14532 NWELL PWELL BULK OAI21_X2
X$39372 \$14193 \$15048 NWELL PWELL BULK INV_X1
X$39375 \$15050 \$14193 \$14504 \$16714 NWELL PWELL BULK AOI21_X1
X$39377 \$14193 \$14199 \$16711 NWELL PWELL BULK NOR2_X1
X$39379 \$14193 \$15381 \$15375 \$14514 \$14504 \$15683 \$15912 NWELL PWELL
+ BULK OAI33_X1
X$39381 \$16498 \$16711 \$15050 \$14193 \$14504 \$17025 NWELL PWELL BULK
+ AOI221_X1
X$39396 \$14504 \$14195 \$14505 \$14864 NWELL PWELL BULK OAI21_X1
X$39400 \$14195 \$14267 \$14265 NWELL PWELL BULK AND2_X1
X$39406 \$15375 \$14197 \$15373 \$16508 NWELL PWELL BULK NAND3_X1
X$39408 \$14197 \$14266 \$14848 NWELL PWELL BULK AND2_X1
X$39412 \$14197 \$14806 NWELL PWELL BULK INV_X1
X$39418 \$15360 \$14199 \$17071 \$16516 NWELL PWELL BULK AOI21_X1
X$39422 \$14199 \$15045 NWELL PWELL BULK INV_X1
X$39426 \$14504 \$14199 \$14502 \$14507 NWELL PWELL BULK AOI21_X1
X$39429 \$14199 \$14514 \$15381 NWELL PWELL BULK AND2_X1
X$39431 \$14199 \$14517 \$15375 NWELL PWELL BULK NOR2_X1
X$39457 \$14264 \$14776 \$14781 \$14782 \$14201 NWELL PWELL BULK OAI22_X1
X$39460 \$14202 \$15050 \$14531 NWELL PWELL BULK NAND2_X1
X$39463 \$15680 \$15676 \$14530 \$15050 \$14202 \$15142 NWELL PWELL BULK
+ AOI221_X1
X$39466 \$14202 \$14781 NWELL PWELL BULK INV_X1
X$39474 \$14208 \$16724 NWELL PWELL BULK INV_X1
X$39489 S2_AXI_BID[5] \$14210 NWELL PWELL BULK BUF_X1
X$39510 \$14213 \$16005 NWELL PWELL BULK INV_X1
X$39514 \$15514 \$14213 \$15523 NWELL PWELL BULK AND2_X1
X$39516 \$18440 \$18006 \$14213 \$18017 NWELL PWELL BULK AOI21_X1
X$39528 \$15956 \$14221 \$15952 \$16320 NWELL PWELL BULK MUX2_X1
X$39530 \$19796 \$14221 \$18042 \$19179 NWELL PWELL BULK MUX2_X1
X$39533 \$17284 \$14221 \$16747 \$18022 NWELL PWELL BULK MUX2_X1
X$39535 \$17279 \$14221 \$16768 \$17306 NWELL PWELL BULK MUX2_X1
X$39538 \$14590 \$14221 \$15408 \$14223 NWELL PWELL BULK MUX2_X1
X$39540 \$20175 \$14221 \$18046 \$20199 NWELL PWELL BULK MUX2_X1
X$39558 \$14226 M0_AXI_BVALID NWELL PWELL BULK BUF_X1
X$39568 \$15514 \$14239 \$16307 \$15407 \$16813 NWELL PWELL BULK AOI22_X1
X$39570 \$14239 \$16814 NWELL PWELL BULK INV_X1
X$39572 \$18006 \$14239 \$18475 \$18010 \$18474 NWELL PWELL BULK AOI22_X2
X$39583 \$14242 S1_AXI_AWBURST[1] NWELL PWELL BULK BUF_X1
X$39594 \$14253 S1_AXI_AWADDR[17] NWELL PWELL BULK BUF_X1
X$39603 \$14806 \$14265 \$14504 \$14264 NWELL PWELL BULK OAI21_X1
X$39614 \$14266 \$14516 \$14512 \$14267 NWELL PWELL BULK OAI21_X1
X$39669 \$14343 \$20857 \$23204 NWELL PWELL BULK OR2_X1
X$39672 \$20683 \$14343 \$23104 \$20857 \$24085 NWELL PWELL BULK OR4_X1
X$39675 \$24809 \$14343 \$26831 \$26405 \$16197 \$25764 \$26292 NWELL PWELL
+ BULK OAI33_X1
X$39678 \$23104 \$14343 \$20683 \$20857 \$21820 NWELL PWELL BULK NOR4_X2
X$39681 \$20857 \$23104 \$14343 \$21267 \$21391 NWELL PWELL BULK NOR4_X1
X$39714 \$32470 \$33386 \$33384 \$14368 NWELL PWELL BULK AOI21_X2
X$39749 \$14385 \$14387 \$14384 NWELL PWELL BULK NOR2_X1
X$39753 \$20038 \$20283 \$14385 \$20282 NWELL PWELL BULK AOI21_X1
X$39756 \$18332 \$18745 \$14385 \$18936 NWELL PWELL BULK AOI21_X1
X$39759 \$14385 \$18746 \$18332 NWELL PWELL BULK NOR2_X1
X$39762 \$20907 \$20820 \$14385 \$20326 NWELL PWELL BULK AOI21_X1
X$39765 \$14385 \$21155 \$20907 NWELL PWELL BULK NOR2_X1
X$39768 \$14385 \$20292 \$20038 NWELL PWELL BULK NOR2_X1
X$39774 \$20895 \$19563 \$14385 \$20894 NWELL PWELL BULK AOI21_X1
X$39777 \$14385 \$20896 \$20895 NWELL PWELL BULK NOR2_X1
X$39780 \$16616 \$17336 \$14385 \$16826 NWELL PWELL BULK AOI21_X1
X$39782 \$14385 \$16159 \$16825 NWELL PWELL BULK NOR2_X1
X$39784 \$17907 \$18526 \$14385 \$17905 NWELL PWELL BULK AOI21_X1
X$39787 \$14385 \$21760 \$21979 NWELL PWELL BULK NOR2_X1
X$39791 \$14385 \$16617 \$16616 NWELL PWELL BULK NOR2_X1
X$39793 \$21979 \$20254 \$14385 \$21542 NWELL PWELL BULK AOI21_X1
X$39796 \$20300 \$19425 \$14385 \$20811 NWELL PWELL BULK AOI21_X1
X$39800 \$14385 \$20042 \$20300 NWELL PWELL BULK NOR2_X1
X$39802 \$14385 \$20631 \$21531 NWELL PWELL BULK NOR2_X1
X$39805 \$21531 \$20229 \$14385 \$21529 NWELL PWELL BULK AOI21_X1
X$39808 \$15502 \$14390 \$14385 \$15286 NWELL PWELL BULK AOI21_X1
X$39810 \$14385 \$17557 \$17173 NWELL PWELL BULK NOR2_X1
X$39813 \$14385 \$15503 \$15502 NWELL PWELL BULK NOR2_X1
X$39815 \$17173 \$15832 \$14385 \$17341 NWELL PWELL BULK AOI21_X1
X$39818 \$14385 \$18325 \$17907 NWELL PWELL BULK NOR2_X1
X$39821 \$14385 \$18328 \$18541 NWELL PWELL BULK NOR2_X1
X$39824 \$18541 \$18329 \$14385 \$18536 NWELL PWELL BULK AOI21_X1
X$39852 \$I177576 \$14387 \$15135 \$15283 NWELL PWELL BULK DFF_X1
X$39856 \$14390 \$33296 \$24152 \$32461 NWELL PWELL BULK AOI21_X4
X$39884 \$I176695 \$20392 \$20874 \$14411 NWELL PWELL BULK DFF_X1
X$39886 \$20068 \$20867 \$20869 \$14411 NWELL PWELL BULK DFF_X1
X$39888 \$I177323 \$14995 \$15635 \$14411 NWELL PWELL BULK DFF_X1
X$39890 \$I177332 \$16193 \$16494 \$14411 NWELL PWELL BULK DFF_X1
X$39893 \$I174902 \$16643 \$17425 \$14411 NWELL PWELL BULK DFF_X1
X$39895 \$I177311 \$16191 \$17421 \$14411 NWELL PWELL BULK DFF_X1
X$39897 \$I174966 \$14994 \$15319 \$14411 NWELL PWELL BULK DFF_X1
X$39899 \$I177336 \$17569 \$18186 \$14411 NWELL PWELL BULK DFF_X1
X$39902 \$I176698 \$17931 \$17929 \$14411 NWELL PWELL BULK DFF_X1
X$39905 \$I176814 \$18756 \$19004 \$14411 NWELL PWELL BULK DFF_X1
X$39907 \$I176619 \$18995 \$19315 \$14411 NWELL PWELL BULK DFF_X1
X$39909 \$20411 \$20065 \$20403 \$14411 NWELL PWELL BULK DFF_X1
X$39912 \$I176118 \$19696 \$20400 \$14411 NWELL PWELL BULK DFF_X1
X$39914 \$I175303 \$18206 \$18208 \$14411 NWELL PWELL BULK DFF_X1
X$39917 \$I176786 \$16947 \$18232 \$14411 NWELL PWELL BULK DFF_X1
X$39919 \$I174307 \$18210 \$18352 \$14411 NWELL PWELL BULK DFF_X1
X$39923 \$I174318 \$19106 \$19313 \$14411 NWELL PWELL BULK DFF_X1
X$39925 \$I174856 \$16476 \$16186 \$14411 NWELL PWELL BULK DFF_X1
X$39927 \$I174873 \$14988 \$15622 \$14411 NWELL PWELL BULK DFF_X1
X$39930 \$I176843 \$15318 \$15853 \$14411 NWELL PWELL BULK DFF_X1
X$39933 \$I174954 \$16635 \$17408 \$14411 NWELL PWELL BULK DFF_X1
X$39935 \$I177876 \$19448 \$19330 \$14411 NWELL PWELL BULK DFF_X1
X$39938 \$20409 \$20066 \$20407 \$14411 NWELL PWELL BULK DFF_X1
X$39941 \$I176531 \$17574 \$17419 \$14411 NWELL PWELL BULK DFF_X1
X$39943 \$I176769 \$19108 \$19320 \$14411 NWELL PWELL BULK DFF_X1
X$39946 \$I176440 \$16190 \$16487 \$14411 NWELL PWELL BULK DFF_X1
X$39948 \$19979 \$19643 \$19110 \$14411 NWELL PWELL BULK DFF_X1
X$39951 \$I175929 \$17407 \$17571 \$14411 NWELL PWELL BULK DFF_X1
X$39953 \$I177375 \$17399 \$17796 \$14411 NWELL PWELL BULK DFF_X1
X$40024 \$14431 \$15257 NWELL PWELL BULK INV_X2
X$40033 \$14432 \$20947 \$20075 \$20951 NWELL PWELL BULK OR3_X1
X$40043 \$14436 \$16082 \$20685 NWELL PWELL BULK NOR2_X2
X$40048 \$16919 \$16632 \$16633 \$14436 NWELL PWELL BULK MUX2_X2
X$40052 \$14436 \$14825 NWELL PWELL BULK INV_X1
X$40054 \$16082 \$14436 \$20440 \$18754 \$20857 NWELL PWELL BULK OR4_X2
X$40148 \$I177023 \$14480 \$15026 \$15021 NWELL PWELL BULK DFF_X1
X$40163 \$16072 \$14487 \$15351 \$17139 NWELL PWELL BULK MUX2_X1
X$40166 \$19734 \$14487 \$20115 \$20117 NWELL PWELL BULK MUX2_X1
X$40169 \$18398 \$14487 \$18786 \$18400 NWELL PWELL BULK MUX2_X1
X$40172 \$17507 \$14487 \$17980 \$18620 NWELL PWELL BULK MUX2_X1
X$40174 \$21443 \$14487 \$21444 \$20575 NWELL PWELL BULK MUX2_X1
X$40177 \$16250 \$14487 \$16249 \$16251 NWELL PWELL BULK MUX2_X1
X$40180 \$25005 \$14487 \$23921 \$25127 NWELL PWELL BULK MUX2_X1
X$40183 \$23947 \$14487 \$23572 \$24235 NWELL PWELL BULK MUX2_X1
X$40186 \$24533 \$14487 \$23933 \$24237 NWELL PWELL BULK MUX2_X1
X$40188 \$23810 \$14487 \$23808 \$24290 NWELL PWELL BULK MUX2_X1
X$40191 \$19378 \$14487 \$17983 \$18998 NWELL PWELL BULK MUX2_X1
X$40194 \$20591 \$14487 \$20590 \$20130 NWELL PWELL BULK MUX2_X1
X$40196 \$23804 \$14487 \$23805 \$24226 NWELL PWELL BULK MUX2_X1
X$40198 \$21001 \$14487 \$21440 \$21002 NWELL PWELL BULK MUX2_X1
X$40201 \$24223 \$14487 \$23802 \$24225 NWELL PWELL BULK MUX2_X1
X$40208 \$20722 \$14487 \$19738 \$20118 NWELL PWELL BULK MUX2_X1
X$40211 \$17981 \$14487 \$18406 \$19001 NWELL PWELL BULK MUX2_X1
X$40214 \$19930 \$14487 \$20612 \$20125 NWELL PWELL BULK MUX2_X1
X$40216 \$22794 \$14487 \$21871 \$22022 NWELL PWELL BULK MUX2_X1
X$40219 \$22322 \$14487 \$22325 \$22326 NWELL PWELL BULK MUX2_X1
X$40221 \$21873 \$14487 \$22756 \$21876 NWELL PWELL BULK MUX2_X1
X$40223 \$24673 \$16716 \$I245754 \$14487 NWELL PWELL BULK DFF_X2
X$40226 \$22327 \$14487 \$22328 \$22011 NWELL PWELL BULK MUX2_X1
X$40269 \$15900 \$14515 \$15362 \$14501 NWELL PWELL BULK OAI21_X1
X$40272 \$14501 \$14502 \$14857 NWELL PWELL BULK NOR2_X1
X$40276 \$14515 \$14514 \$14502 NWELL PWELL BULK NOR2_X2
X$40279 \$15360 \$14502 \$14517 \$14874 NWELL PWELL BULK NAND3_X1
X$40282 \$15360 \$14502 \$16703 \$16702 NWELL PWELL BULK NAND3_X1
X$40285 \$17071 \$14502 \$16265 \$16520 NWELL PWELL BULK AOI21_X1
X$40301 \$14504 \$14514 \$15048 \$15904 NWELL PWELL BULK NOR3_X1
X$40306 \$15044 \$14504 \$15045 \$15172 NWELL PWELL BULK OAI21_X1
X$40314 \$14516 \$14504 \$15048 \$15380 NWELL PWELL BULK NOR3_X1
X$40331 \$15047 \$15045 \$14512 NWELL PWELL BULK NAND2_X1
X$40336 \$16508 \$15908 \$14514 \$16272 NWELL PWELL BULK NOR3_X1
X$40338 \$17059 \$14514 \$17071 NWELL PWELL BULK NOR2_X1
X$40342 \$15172 \$14514 \$15176 NWELL PWELL BULK NAND2_X1
X$40346 \$14514 \$14515 \$14516 NWELL PWELL BULK OR2_X1
X$40351 \$17022 \$17025 \$14514 \$17437 NWELL PWELL BULK OAI21_X1
X$40355 \$14514 \$16714 \$16279 NWELL PWELL BULK AND2_X1
X$40377 \$14515 \$15368 \$14517 \$15047 NWELL PWELL BULK OAI21_X1
X$40400 \$14517 \$15900 NWELL PWELL BULK INV_X1
X$40403 \$15904 \$14517 \$16267 NWELL PWELL BULK NOR2_X1
X$40407 \$15360 \$15910 \$14517 \$16498 NWELL PWELL BULK NAND3_X1
X$40415 \$14527 \$14773 NWELL PWELL BULK INV_X1
X$40418 \$14528 \$15053 \$15373 \$15145 NWELL PWELL BULK MUX2_X2
X$40421 \$14528 \$15373 \$15647 NWELL PWELL BULK OR2_X1
X$40426 \$14530 \$14531 \$14532 \$15055 NWELL PWELL BULK AND3_X1
X$40429 \$14532 \$14531 \$14530 \$15056 NWELL PWELL BULK NAND3_X2
X$40434 \$16277 \$15912 \$14530 \$17614 \$15050 NWELL PWELL BULK AOI22_X4
X$40436 \$14530 \$15390 \$15145 \$15398 \$15923 NWELL PWELL BULK AND4_X1
X$40440 \$15145 \$15398 \$14530 \$15390 \$16297 NWELL PWELL BULK NAND4_X4
X$40446 \$14532 \$14531 \$15390 NWELL PWELL BULK NAND2_X2
X$40484 S2_AXI_BID[1] \$14548 NWELL PWELL BULK BUF_X1
X$40498 \$14549 \$15948 NWELL PWELL BULK INV_X1
X$40501 \$15514 \$14549 \$15409 NWELL PWELL BULK AND2_X1
X$40504 \$18440 \$18006 \$14549 \$18442 NWELL PWELL BULK AOI21_X1
X$40520 M0_AXI_BREADY \$14559 NWELL PWELL BULK BUF_X1
X$40557 \$15078 \$15076 \$14590 \$15415 NWELL PWELL BULK MUX2_X1
X$40681 \$14759 \$14755 NWELL PWELL BULK INV_X1
X$40698 \$15053 \$14776 \$14773 \$14782 \$14775 NWELL PWELL BULK OAI22_X1
X$40713 \$17437 \$17443 \$17429 \$14782 \$17434 NWELL PWELL BULK OAI22_X1
X$40715 \$17447 \$14782 \$17439 \$17613 NWELL PWELL BULK OAI21_X1
X$40734 \$20685 \$14798 \$25370 \$25753 NWELL PWELL BULK AND3_X1
X$40829 \$32460 \$34693 \$14951 \$35355 \$32461 NWELL PWELL BULK AOI22_X4
X$40862 \$32460 \$46446 \$14973 \$46055 \$33856 NWELL PWELL BULK AOI22_X4
X$40922 \$15662 \$15253 \$15000 \$15003 NWELL PWELL BULK MUX2_X1
X$40929 \$15003 \$15866 NWELL PWELL BULK INV_X1
X$40940 \$15332 \$15011 NWELL PWELL BULK INV_X1
X$40950 \$I174345 \$15878 \$16234 \$15021 NWELL PWELL BULK DFF_X1
X$40953 \$I175657 \$16237 \$16236 \$15021 NWELL PWELL BULK DFF_X1
X$40956 \$I174246 \$17598 \$17530 \$15021 NWELL PWELL BULK DFF_X1
X$40958 \$I177161 \$15209 \$15749 \$15021 NWELL PWELL BULK DFF_X1
X$40960 \$I177156 \$17603 \$17602 \$15021 NWELL PWELL BULK DFF_X1
X$40962 \$I177033 \$19481 \$19731 \$15021 NWELL PWELL BULK DFF_X1
X$40964 \$I176934 \$19623 \$19626 \$15021 NWELL PWELL BULK DFF_X1
X$40966 \$I175569 \$19940 \$19478 \$15021 NWELL PWELL BULK DFF_X1
X$40968 \$I175621 \$18393 \$18392 \$15021 NWELL PWELL BULK DFF_X1
X$40971 \$I176922 \$19730 \$19944 \$15021 NWELL PWELL BULK DFF_X1
X$40974 \$19728 \$20579 \$20576 \$15021 NWELL PWELL BULK DFF_X1
X$40976 \$19725 \$19632 \$19630 \$15021 NWELL PWELL BULK DFF_X1
X$40978 \$20106 \$20105 \$20569 \$15021 NWELL PWELL BULK DFF_X1
X$40980 \$I178307 \$17975 \$19015 \$15021 NWELL PWELL BULK DFF_X1
X$40982 \$I176107 \$17965 \$17963 \$15021 NWELL PWELL BULK DFF_X1
X$40984 \$I177440 \$17969 \$17967 \$15021 NWELL PWELL BULK DFF_X1
X$40986 \$I177159 \$17533 \$17968 \$15021 NWELL PWELL BULK DFF_X1
X$40989 \$17801 \$15021 NWELL PWELL BULK BUF_X4
X$40991 \$19634 \$19404 \$19402 \$15021 NWELL PWELL BULK DFF_X1
X$40993 \$I177153 \$18677 \$18235 \$15021 NWELL PWELL BULK DFF_X1
X$40996 \$I176873 \$17972 \$18384 \$15021 NWELL PWELL BULK DFF_X1
X$40998 \$I176539 \$18783 \$18782 \$15021 NWELL PWELL BULK DFF_X1
X$41001 \$I176872 \$18226 \$18388 \$15021 NWELL PWELL BULK DFF_X1
X$41003 \$I176896 \$16677 \$16675 \$15021 NWELL PWELL BULK DFF_X1
X$41006 \$I176616 \$17224 \$17518 \$15021 NWELL PWELL BULK DFF_X1
X$41008 \$I176663 \$16248 \$16572 \$15021 NWELL PWELL BULK DFF_X1
X$41010 \$I178298 \$17121 \$17112 \$15021 NWELL PWELL BULK DFF_X1
X$41013 \$I177015 \$15882 \$17105 \$15021 NWELL PWELL BULK DFF_X1
X$41016 \$20110 \$20814 \$21234 \$15021 NWELL PWELL BULK DFF_X1
X$41018 \$I174973 \$21217 \$20996 \$15021 NWELL PWELL BULK DFF_X1
X$41056 \$I175629 \$15033 \$15354 \$16254 NWELL PWELL BULK DFF_X1
X$41098 \$16279 \$17000 \$15398 \$16280 \$15050 NWELL PWELL BULK AOI22_X4
X$41100 \$16275 \$15917 \$16966 \$15916 \$15050 \$16964 NWELL PWELL BULK
+ OAI221_X1
X$41107 \$15910 \$15050 \$16277 NWELL PWELL BULK NOR2_X1
X$41110 \$16988 \$16716 \$16275 \$15050 NWELL PWELL BULK DFF_X2
X$41114 \$15050 \$15373 NWELL PWELL BULK INV_X1
X$41118 \$15647 \$15050 \$15053 \$15393 NWELL PWELL BULK OAI21_X4
X$41142 \$15394 \$15055 \$15393 \$15398 \$15619 NWELL PWELL BULK AND4_X1
X$41144 \$15398 \$15145 \$15055 \$15916 NWELL PWELL BULK NAND3_X1
X$41146 \$15393 \$15055 \$15398 \$15941 NWELL PWELL BULK NAND3_X4
X$41154 \$15056 \$15393 \$15398 \$15514 NWELL PWELL BULK NOR3_X4
X$41187 \$15971 \$15070 \$15952 \$15472 NWELL PWELL BULK MUX2_X1
X$41189 \$19794 \$15070 \$18042 \$20191 NWELL PWELL BULK MUX2_X1
X$41192 \$18019 \$15070 \$16768 \$18045 NWELL PWELL BULK MUX2_X1
X$41196 \$16749 \$15070 \$16747 \$16325 NWELL PWELL BULK MUX2_X1
X$41198 \$19792 \$15070 \$18046 \$20227 NWELL PWELL BULK MUX2_X1
X$41200 \$15078 \$15070 \$15408 \$15958 NWELL PWELL BULK MUX2_X1
X$41208 \$16319 \$15071 \$15952 \$16349 NWELL PWELL BULK MUX2_X1
X$41210 \$18827 \$15071 \$18046 \$18853 NWELL PWELL BULK MUX2_X1
X$41212 \$17639 \$15071 \$16768 \$18051 NWELL PWELL BULK MUX2_X1
X$41215 \$18021 \$15071 \$16747 \$18458 NWELL PWELL BULK MUX2_X1
X$41217 \$18832 \$15071 \$18042 \$18850 NWELL PWELL BULK MUX2_X1
X$41219 \$15077 \$15071 \$15408 \$15075 NWELL PWELL BULK MUX2_X1
X$41228 \$16749 \$15076 \$17284 \$17642 NWELL PWELL BULK MUX2_X1
X$41230 \$16319 \$15076 \$15954 \$16343 NWELL PWELL BULK MUX2_X1
X$41232 \$18832 \$15076 \$19175 \$18840 NWELL PWELL BULK MUX2_X1
X$41234 \$18021 \$15076 \$17298 \$18023 NWELL PWELL BULK MUX2_X1
X$41237 \$18019 \$15076 \$17279 \$17669 NWELL PWELL BULK MUX2_X1
X$41240 \$15971 \$15076 \$15956 \$16323 NWELL PWELL BULK MUX2_X1
X$41244 \$17639 \$15076 \$16744 \$17302 NWELL PWELL BULK MUX2_X1
X$41246 \$19792 \$15076 \$20175 \$19522 NWELL PWELL BULK MUX2_X1
X$41248 \$18827 \$15076 \$19174 \$19521 NWELL PWELL BULK MUX2_X1
X$41250 \$15077 \$15076 \$15445 \$15429 NWELL PWELL BULK MUX2_X1
X$41254 \$19794 \$15076 \$19796 \$19795 NWELL PWELL BULK MUX2_X1
X$41281 \$I178859 \$15078 \$15958 \$16316 NWELL PWELL BULK DFF_X1
X$41291 \$15085 S1_AXI_AWSIZE[1] NWELL PWELL BULK BUF_X1
X$41297 \$15095 S1_AXI_AWSIZE[2] NWELL PWELL BULK BUF_X1
X$41318 \$15145 \$15398 \$15142 \$15407 NWELL PWELL BULK AND3_X2
X$41394 \$23118 \$23188 \$15253 \$23540 NWELL PWELL BULK MUX2_X2
X$41396 \$21247 \$20679 \$15253 \$20701 NWELL PWELL BULK MUX2_X2
X$41398 \$18776 \$15253 \$18693 \$17870 NWELL PWELL BULK MUX2_X1
X$41400 \$19112 \$19651 \$15253 \$19704 NWELL PWELL BULK MUX2_X2
X$41402 \$24772 \$24463 \$15253 \$24875 NWELL PWELL BULK MUX2_X2
X$41404 \$19707 \$20452 \$15253 \$20451 NWELL PWELL BULK MUX2_X2
X$41410 \$21376 \$21797 \$15253 \$22248 NWELL PWELL BULK MUX2_X2
X$41412 \$20816 \$20813 \$15253 \$23671 NWELL PWELL BULK MUX2_X2
X$41414 \$24781 \$25162 \$15253 \$24986 NWELL PWELL BULK MUX2_X2
X$41416 \$24816 \$23790 \$15253 \$24982 NWELL PWELL BULK MUX2_X2
X$41418 \$19955 \$20559 \$15253 \$20104 NWELL PWELL BULK MUX2_X2
X$41420 \$25397 \$25398 \$15253 \$25409 NWELL PWELL BULK MUX2_X2
X$41422 \$21423 \$22821 \$15253 \$22830 NWELL PWELL BULK MUX2_X2
X$41424 \$21855 \$21856 \$15253 \$22301 NWELL PWELL BULK MUX2_X2
X$41426 \$17053 \$17857 \$15253 \$17217 NWELL PWELL BULK MUX2_X2
X$41428 \$23233 \$22921 \$15253 \$23238 NWELL PWELL BULK MUX2_X2
X$41431 \$25893 \$20927 \$I245662 \$15253 NWELL PWELL BULK DFF_X2
X$41435 \$19707 \$15253 \$19454 NWELL PWELL BULK NOR2_X1
X$41437 \$15253 \$20688 NWELL PWELL BULK INV_X1
X$41440 \$18367 \$15253 \$18267 \$17484 NWELL PWELL BULK MUX2_X1
X$41445 \$17844 \$15253 \$16657 \$15332 NWELL PWELL BULK MUX2_X1
X$41499 \$I178183 \$15272 \$15448 \$15814 NWELL PWELL BULK DFF_X1
X$41526 \$I177979 \$17911 \$18130 \$15283 NWELL PWELL BULK DFF_X1
X$41529 \$I176282 \$17360 \$17915 \$15283 NWELL PWELL BULK DFF_X1
X$41532 \$I177906 \$17356 \$17354 \$15283 NWELL PWELL BULK DFF_X1
X$41534 \$I177820 \$16166 \$16428 \$15283 NWELL PWELL BULK DFF_X1
X$41536 \$I176098 \$16167 \$16850 \$15283 NWELL PWELL BULK DFF_X1
X$41539 \$20834 \$21169 \$21165 \$15283 NWELL PWELL BULK DFF_X1
X$41542 \$I176521 \$20042 \$20811 \$15283 NWELL PWELL BULK DFF_X1
X$41544 \$I176581 \$20650 \$20905 \$15283 NWELL PWELL BULK DFF_X1
X$41547 \$I177665 \$18325 \$17905 \$15283 NWELL PWELL BULK DFF_X1
X$41550 \$I176618 \$18738 \$18115 \$15283 NWELL PWELL BULK DFF_X1
X$41552 \$I176632 \$16836 \$16160 \$15283 NWELL PWELL BULK DFF_X1
X$41555 \$I177666 \$20320 \$20817 \$15283 NWELL PWELL BULK DFF_X1
X$41557 \$I177585 \$19428 \$19427 \$15283 NWELL PWELL BULK DFF_X1
X$41559 \$I177607 \$15517 \$15504 \$15283 NWELL PWELL BULK DFF_X1
X$41561 \$I176682 \$15836 \$16619 \$15283 NWELL PWELL BULK DFF_X1
X$41564 \$I176633 \$15285 \$15829 \$15283 NWELL PWELL BULK DFF_X1
X$41568 \$I176196 \$16163 \$16412 \$15283 NWELL PWELL BULK DFF_X1
X$41571 \$I176298 \$15291 \$16165 \$15283 NWELL PWELL BULK DFF_X1
X$41574 \$I176681 \$15503 \$15286 \$15283 NWELL PWELL BULK DFF_X1
X$41576 \$I177652 \$19091 \$19584 \$15283 NWELL PWELL BULK DFF_X1
X$41578 \$20338 \$20832 \$20655 \$15283 NWELL PWELL BULK DFF_X1
X$41581 \$19591 \$19877 \$19589 \$15283 NWELL PWELL BULK DFF_X1
X$41583 \$I177663 \$21155 \$20326 \$15283 NWELL PWELL BULK DFF_X1
X$41586 \$I176658 \$17909 \$18120 \$15283 NWELL PWELL BULK DFF_X1
X$41588 \$I176294 \$18742 \$19260 \$15283 NWELL PWELL BULK DFF_X1
X$41591 \$I177625 \$19089 \$19087 \$15283 NWELL PWELL BULK DFF_X1
X$41593 \$I177627 \$17557 \$17341 \$15283 NWELL PWELL BULK DFF_X1
X$41596 \$I177817 \$18131 \$18124 \$15283 NWELL PWELL BULK DFF_X1
X$41599 \$I176290 \$18328 \$18536 \$15283 NWELL PWELL BULK DFF_X1
X$41673 \$I174411 \$17585 \$17855 \$15321 NWELL PWELL BULK DFF_X1
X$41675 \$I175626 \$20975 \$21290 \$15321 NWELL PWELL BULK DFF_X1
X$41678 \$I175703 \$20828 \$21283 \$15321 NWELL PWELL BULK DFF_X1
X$41681 \$I179020 \$19465 \$19650 \$15321 NWELL PWELL BULK DFF_X1
X$41683 \$I174404 \$17939 \$18261 \$15321 NWELL PWELL BULK DFF_X1
X$41686 \$I179018 \$20094 \$20509 \$15321 NWELL PWELL BULK DFF_X1
X$41688 \$I174588 \$18771 \$18769 \$15321 NWELL PWELL BULK DFF_X1
X$41691 \$I179023 \$19121 \$19377 \$15321 NWELL PWELL BULK DFF_X1
X$41693 \$I179009 \$18775 \$19068 \$15321 NWELL PWELL BULK DFF_X1
X$41695 \$I179054 \$15860 \$15861 \$15321 NWELL PWELL BULK DFF_X1
X$41697 \$I174586 \$18772 \$18773 \$15321 NWELL PWELL BULK DFF_X1
X$41700 \$I175034 \$15323 \$15646 \$15321 NWELL PWELL BULK DFF_X1
X$41702 \$I177891 \$16194 \$16645 \$15321 NWELL PWELL BULK DFF_X1
X$41704 \$I175304 \$15859 \$16204 \$15321 NWELL PWELL BULK DFF_X1
X$41706 \$I178984 \$18762 \$19014 \$15321 NWELL PWELL BULK DFF_X1
X$41709 \$I174442 \$18615 \$18356 \$15321 NWELL PWELL BULK DFF_X1
X$41712 \$I178922 \$17194 \$18240 \$15321 NWELL PWELL BULK DFF_X1
X$41714 \$I179265 \$17195 \$16647 \$15321 NWELL PWELL BULK DFF_X1
X$41716 \$I175025 \$16195 \$16502 \$15321 NWELL PWELL BULK DFF_X1
X$41718 \$I179300 \$16987 \$16980 \$15321 NWELL PWELL BULK DFF_X1
X$41721 \$I174277 \$17937 \$18247 \$15321 NWELL PWELL BULK DFF_X1
X$41723 \$I178959 \$19341 \$19657 \$15321 NWELL PWELL BULK DFF_X1
X$41725 \$I175169 \$20070 \$19988 \$15321 NWELL PWELL BULK DFF_X1
X$41728 \$I174282 \$20071 \$19997 \$15321 NWELL PWELL BULK DFF_X1
X$41731 \$I178986 \$19706 \$20003 \$15321 NWELL PWELL BULK DFF_X1
X$41734 \$19036 \$15321 NWELL PWELL BULK BUF_X4
X$41736 \$I175130 \$19452 \$19355 \$15321 NWELL PWELL BULK DFF_X1
X$41738 \$I175124 \$17938 \$18636 \$15321 NWELL PWELL BULK DFF_X1
X$41741 \$I174245 \$18768 \$19359 \$15321 NWELL PWELL BULK DFF_X1
X$41743 \$I178952 \$18760 \$19011 \$15321 NWELL PWELL BULK DFF_X1
X$41746 \$I178990 \$18628 \$18360 \$15321 NWELL PWELL BULK DFF_X1
X$41796 \$20079 \$15332 \$17484 \$17870 \$17217 NWELL PWELL BULK OR4_X4
X$41837 \$16250 \$15887 \$15349 \$16566 NWELL PWELL BULK MUX2_X1
X$41866 \$15900 \$16275 \$16711 \$15360 \$17022 NWELL PWELL BULK AND4_X1
X$41874 \$16703 \$16528 \$15362 NWELL PWELL BULK NOR2_X1
X$41893 \$16482 \$15373 \$16031 \$16282 NWELL PWELL BULK AOI21_X1
X$41895 \$15917 \$15373 \$16482 NWELL PWELL BULK NOR2_X1
X$41933 \$21894 \$21893 \$21895 \$15394 NWELL PWELL BULK NAND3_X4
X$41935 \$20742 \$20159 \$15394 \$19836 NWELL PWELL BULK AND3_X1
X$41938 \$20159 \$20742 \$15394 \$18425 NWELL PWELL BULK NAND3_X4
X$41941 \$15394 \$17741 \$17625 NWELL PWELL BULK AND2_X1
X$41944 \$17618 \$17246 \$18141 \$17741 \$15394 \$17997 NWELL PWELL BULK
+ AOI221_X2
X$41951 \$16951 \$15394 \$21462 NWELL PWELL BULK NAND2_X2
X$41990 \$15514 \$15406 \$16298 \$15407 \$16411 NWELL PWELL BULK AOI22_X1
X$41992 \$18006 \$15406 \$18013 \$18010 \$18821 NWELL PWELL BULK AOI22_X2
X$41994 \$15406 \$18012 NWELL PWELL BULK INV_X1
X$42002 \$15514 \$16733 \$17258 \$15407 \$16862 NWELL PWELL BULK AOI22_X1
X$42005 \$15514 \$16739 \$17269 \$15407 \$15943 NWELL PWELL BULK AOI22_X1
X$42022 \$15937 \$15538 \$15408 NWELL PWELL BULK OR2_X1
X$42025 \$15445 \$15463 \$15408 \$15969 NWELL PWELL BULK MUX2_X1
X$42054 \$15433 M0_AXI_BRESP[1] NWELL PWELL BULK BUF_X1
X$42056 \$32460 \$33025 \$15437 \$33194 \$32461 NWELL PWELL BULK AOI22_X4
X$42075 \$I178860 \$15445 \$15969 \$16316 NWELL PWELL BULK DFF_X1
X$42094 \$17298 \$15463 \$16747 \$17281 NWELL PWELL BULK MUX2_X1
X$42098 \$15954 \$15463 \$15952 \$15976 NWELL PWELL BULK MUX2_X1
X$42103 \$16744 \$15463 \$16768 \$16770 NWELL PWELL BULK MUX2_X1
X$42105 \$19174 \$15463 \$18046 \$19173 NWELL PWELL BULK MUX2_X1
X$42107 \$19175 \$15463 \$18042 \$19177 NWELL PWELL BULK MUX2_X1
X$42178 \$32460 \$49842 \$15525 \$49845 \$33856 NWELL PWELL BULK AOI22_X4
X$42208 \$16005 \$16732 \$16737 \$15538 NWELL PWELL BULK OAI21_X1
X$42379 \$32460 \$51454 \$15813 \$51031 \$32461 NWELL PWELL BULK AOI22_X4
X$42397 \$I175772 \$17902 \$17704 \$15814 NWELL PWELL BULK DFF_X1
X$42399 \$I175525 \$17547 \$17544 \$15814 NWELL PWELL BULK DFF_X1
X$42402 \$I175766 \$15818 \$16367 \$15814 NWELL PWELL BULK DFF_X1
X$42404 \$I176007 \$18731 \$19220 \$15814 NWELL PWELL BULK DFF_X1
X$42407 \$I178039 \$19842 \$19420 \$15814 NWELL PWELL BULK DFF_X1
X$42409 \$I178066 \$17162 \$17548 \$15814 NWELL PWELL BULK DFF_X1
X$42411 \$I175995 \$20034 \$19668 \$15814 NWELL PWELL BULK DFF_X1
X$42414 \$I175807 \$16608 \$17159 \$15814 NWELL PWELL BULK DFF_X1
X$42417 \$I178038 \$18311 \$18492 \$15814 NWELL PWELL BULK DFF_X1
X$42419 \$I175526 \$19419 \$19417 \$15814 NWELL PWELL BULK DFF_X1
X$42422 \$I178192 \$18308 \$18068 \$15814 NWELL PWELL BULK DFF_X1
X$42425 \$I175853 \$18728 \$19201 \$15814 NWELL PWELL BULK DFF_X1
X$42428 \$I175834 \$17895 \$17682 \$15814 NWELL PWELL BULK DFF_X1
X$42430 \$I175738 \$16613 \$16810 \$15814 NWELL PWELL BULK DFF_X1
X$42433 \$I178115 \$19233 \$19229 \$15814 NWELL PWELL BULK DFF_X1
X$42436 \$I175967 \$18095 \$18504 \$15814 NWELL PWELL BULK DFF_X1
X$42439 \$I177832 \$19676 \$19424 \$15814 NWELL PWELL BULK DFF_X1
X$42442 \$I178028 \$20292 \$20282 \$15814 NWELL PWELL BULK DFF_X1
X$42445 \$I178112 \$20270 \$20264 \$15814 NWELL PWELL BULK DFF_X1
X$42447 \$I175966 \$19572 \$19082 \$15814 NWELL PWELL BULK DFF_X1
X$42450 \$I178065 \$17555 \$18102 \$15814 NWELL PWELL BULK DFF_X1
X$42454 \$I178098 \$19081 \$19856 \$15814 NWELL PWELL BULK DFF_X1
X$42457 \$I176564 \$20899 \$21122 \$15814 NWELL PWELL BULK DFF_X1
X$42459 \$I177834 \$16159 \$16394 \$15814 NWELL PWELL BULK DFF_X1
X$42461 \$I176562 \$20893 \$20790 \$15814 NWELL PWELL BULK DFF_X1
X$42464 \$I177836 \$16617 \$16826 \$15814 NWELL PWELL BULK DFF_X1
X$42466 \$I176328 \$19085 \$19240 \$15814 NWELL PWELL BULK DFF_X1
X$42469 \$I176293 \$18321 \$18515 \$15814 NWELL PWELL BULK DFF_X1
X$42472 \$I177837 \$17170 \$17725 \$15814 NWELL PWELL BULK DFF_X1
X$42511 \$15832 \$33844 \$33419 \$32461 NWELL PWELL BULK AOI21_X4
X$42548 \$16920 \$15850 \$16633 \$16507 NWELL PWELL BULK MUX2_X2
X$42595 \$16672 \$16670 \$15872 \$17063 NWELL PWELL BULK MUX2_X1
X$42614 \$20132 \$15887 \$19486 \$20566 NWELL PWELL BULK MUX2_X1
X$42617 \$22794 \$15887 \$21872 \$23043 NWELL PWELL BULK MUX2_X1
X$42619 \$22322 \$15887 \$22324 \$23038 NWELL PWELL BULK MUX2_X1
X$42621 \$24223 \$15887 \$23797 \$24750 NWELL PWELL BULK MUX2_X1
X$42625 \$18792 \$15887 \$17231 \$18788 NWELL PWELL BULK MUX2_X1
X$42627 \$19930 \$15887 \$20123 \$20613 NWELL PWELL BULK MUX2_X1
X$42629 \$19734 \$15887 \$19735 \$19482 NWELL PWELL BULK MUX2_X1
X$42631 \$17507 \$15887 \$17808 \$17135 NWELL PWELL BULK MUX2_X1
X$42633 \$17981 \$15887 \$18404 \$18403 NWELL PWELL BULK MUX2_X1
X$42635 \$20591 \$15887 \$20602 \$19741 NWELL PWELL BULK MUX2_X1
X$42639 \$23810 \$15887 \$23586 \$23587 NWELL PWELL BULK MUX2_X1
X$42641 \$23482 \$23276 \$23274 \$15887 NWELL PWELL BULK NOR3_X4
X$42644 \$24533 \$15887 \$23930 \$25134 NWELL PWELL BULK MUX2_X1
X$42690 \$15910 \$15900 \$16710 NWELL PWELL BULK NOR2_X1
X$42702 \$16711 \$16710 \$15908 \$17000 NWELL PWELL BULK OAI21_X2
X$42716 \$15916 \$16275 \$16943 \$16966 NWELL PWELL BULK NAND3_X1
X$42757 S2_AXI_BID[0] \$15927 NWELL PWELL BULK BUF_X1
X$42778 \$18819 \$19517 \$20330 \$15939 NWELL PWELL BULK MUX2_X1
X$42811 \$15948 \$16732 \$16737 \$16315 NWELL PWELL BULK OAI21_X1
X$42814 \$15949 \$16315 \$15952 NWELL PWELL BULK OR2_X1
X$42915 \$16020 S1_AXI_AWADDR[23] NWELL PWELL BULK BUF_X1
X$42932 \$16707 \$16031 \$17439 NWELL PWELL BULK NAND2_X1
X$42968 \$16082 \$17017 NWELL PWELL BULK INV_X1
X$43021 \$16208 \$16138 NWELL PWELL BULK INV_X1
X$43053 \$16157 S1_AXI_AWADDR[16] NWELL PWELL BULK BUF_X1
X$43126 \$26785 \$24191 \$16197 \$25357 \$26398 NWELL PWELL BULK OAI211_X2
X$43128 \$26397 \$16197 \$25357 \$27075 NWELL PWELL BULK OAI21_X2
X$43130 \$21381 \$21382 \$16197 \$20942 \$21687 NWELL PWELL BULK OAI22_X1
X$43132 \$25918 \$16197 \$23579 \$26842 \$27435 NWELL PWELL BULK AOI211_X2
X$43134 \$21317 \$26410 \$16197 \$25764 \$26298 NWELL PWELL BULK OAI22_X1
X$43140 \$20942 \$16197 \$21821 \$21391 \$20944 NWELL PWELL BULK AOI211_X2
X$43142 \$20683 \$16197 \$20942 \$21708 NWELL PWELL BULK OR3_X1
X$43144 \$16197 \$22695 \$22672 \$23207 NWELL PWELL BULK OR3_X1
X$43146 \$22672 \$22695 \$16197 \$22895 NWELL PWELL BULK NOR3_X2
X$43148 \$20942 \$16197 \$20935 NWELL PWELL BULK NOR2_X2
X$43150 \$22695 \$16197 \$22672 \$23104 \$23204 \$23205 \$23766 NWELL PWELL
+ BULK OAI33_X1
X$43153 \$21825 \$17582 \$21738 \$16197 \$22695 \$23090 \$22711 NWELL PWELL
+ BULK OAI33_X1
X$43252 \$17870 \$16222 NWELL PWELL BULK INV_X1
X$43312 \$I176491 \$16691 \$17145 \$16254 NWELL PWELL BULK DFF_X1
X$43315 \$I176718 \$17986 \$17985 \$16254 NWELL PWELL BULK DFF_X1
X$43318 \$I176555 \$18410 \$18588 \$16254 NWELL PWELL BULK DFF_X1
X$43321 \$I175637 \$16694 \$16693 \$16254 NWELL PWELL BULK DFF_X1
X$43324 \$I176400 \$17480 \$17483 \$16254 NWELL PWELL BULK DFF_X1
X$43326 \$I175416 \$18793 \$19366 \$16254 NWELL PWELL BULK DFF_X1
X$43328 \$I175700 \$19921 \$19924 \$16254 NWELL PWELL BULK DFF_X1
X$43330 \$I175646 \$18792 \$18788 \$16254 NWELL PWELL BULK DFF_X1
X$43333 \$I178251 \$20132 \$20566 \$16254 NWELL PWELL BULK DFF_X1
X$43335 \$I175709 \$19489 \$19913 \$16254 NWELL PWELL BULK DFF_X1
X$43338 \$I179156 \$17980 \$18207 \$16254 NWELL PWELL BULK DFF_X1
X$43341 \$I175642 \$17983 \$18599 \$16254 NWELL PWELL BULK DFF_X1
X$43344 \$I179158 \$17140 \$17609 \$16254 NWELL PWELL BULK DFF_X1
X$43347 \$I175338 \$21443 \$21442 \$16254 NWELL PWELL BULK DFF_X1
X$43350 \$I174974 \$20590 \$20725 \$16254 NWELL PWELL BULK DFF_X1
X$43353 \$I179151 \$27134 \$27133 \$16254 NWELL PWELL BULK DFF_X1
X$43355 \$I175347 \$26486 \$26840 \$16254 NWELL PWELL BULK DFF_X1
X$43358 \$I175728 \$22332 \$22670 \$16254 NWELL PWELL BULK DFF_X1
X$43360 \$I174339 \$21996 \$22000 \$16254 NWELL PWELL BULK DFF_X1
X$43362 \$I179132 \$22327 \$23035 \$16254 NWELL PWELL BULK DFF_X1
X$43364 \$I178749 \$22330 \$21879 \$16254 NWELL PWELL BULK DFF_X1
X$43366 \$17801 \$16254 NWELL PWELL BULK BUF_X4
X$43369 \$I175940 \$22328 \$22715 \$16254 NWELL PWELL BULK DFF_X1
X$43372 \$I175973 \$23810 \$23587 \$16254 NWELL PWELL BULK DFF_X1
X$43374 \$I177124 \$22331 \$21881 \$16254 NWELL PWELL BULK DFF_X1
X$43376 \$I178805 \$21009 \$21555 \$16254 NWELL PWELL BULK DFF_X1
X$43379 \$I176158 \$21444 \$22013 \$16254 NWELL PWELL BULK DFF_X1
X$43382 \$I177123 \$23808 \$23958 \$16254 NWELL PWELL BULK DFF_X1
X$43384 \$I179154 \$25143 \$24711 \$16254 NWELL PWELL BULK DFF_X1
X$43386 \$I174475 \$25002 \$25675 \$16254 NWELL PWELL BULK DFF_X1
X$43440 \$16516 \$16520 \$16270 \$16267 \$16266 NWELL PWELL BULK OAI22_X1
X$43448 \$16506 \$16270 \$16707 NWELL PWELL BULK NOR2_X1
X$43453 \$16272 \$16275 \$16271 \$16506 NWELL PWELL BULK AOI21_X1
X$43478 \$17434 \$16716 \$I245539 \$16280 NWELL PWELL BULK DFF_X2
X$43480 \$16280 \$17429 NWELL PWELL BULK INV_X1
X$43486 \$16463 \$16737 \$16313 \$17376 \$16293 NWELL PWELL BULK OAI22_X2
X$43508 \$18820 \$16298 NWELL PWELL BULK INV_X1
X$43511 \$17262 \$16298 \$16860 \$17333 NWELL PWELL BULK AOI21_X1
X$43514 \$17272 \$16307 \$16860 \$17687 NWELL PWELL BULK AOI21_X1
X$43517 \$19518 \$16307 NWELL PWELL BULK INV_X1
X$43543 \$19542 \$19517 \$19816 \$16314 NWELL PWELL BULK MUX2_X1
X$43558 \$17275 \$17311 \$17678 \$16316 NWELL PWELL BULK DFF_X1
X$43560 \$16317 \$16368 \$16370 \$16316 NWELL PWELL BULK DFF_X1
X$43563 \$I178815 \$16744 \$16770 \$16316 NWELL PWELL BULK DFF_X1
X$43565 \$I176476 \$17298 \$17281 \$16316 NWELL PWELL BULK DFF_X1
X$43567 \$I176255 \$16749 \$16325 \$16316 NWELL PWELL BULK DFF_X1
X$43569 \$I174958 \$18827 \$18853 \$16316 NWELL PWELL BULK DFF_X1
X$43571 \$I174998 \$17639 \$18051 \$16316 NWELL PWELL BULK DFF_X1
X$43573 \$I178662 \$19174 \$19173 \$16316 NWELL PWELL BULK DFF_X1
X$43576 \$I178491 \$19792 \$20227 \$16316 NWELL PWELL BULK DFF_X1
X$43580 \$I179195 \$17284 \$18022 \$16316 NWELL PWELL BULK DFF_X1
X$43583 \$20243 \$19815 \$19519 \$16316 NWELL PWELL BULK DFF_X1
X$43586 \$20245 \$21058 \$20174 \$16316 NWELL PWELL BULK DFF_X1
X$43588 \$16355 \$16353 \$16361 \$16316 NWELL PWELL BULK DFF_X1
X$43591 \$I175326 \$18019 \$18045 \$16316 NWELL PWELL BULK DFF_X1
X$43593 \$19212 \$19213 \$18873 \$16316 NWELL PWELL BULK DFF_X1
X$43595 \$20166 \$20323 \$19824 \$16316 NWELL PWELL BULK DFF_X1
X$43597 \$17315 \$18018 \$17679 \$16316 NWELL PWELL BULK DFF_X1
X$43602 \$20310 \$20171 \$20299 \$16316 NWELL PWELL BULK DFF_X1
X$43605 \$20255 \$21065 \$20263 \$16316 NWELL PWELL BULK DFF_X1
X$43607 \$20276 \$20266 \$20278 \$16316 NWELL PWELL BULK DFF_X1
X$43610 \$18859 \$18857 \$18861 \$16316 NWELL PWELL BULK DFF_X1
X$43612 \$I174728 \$18021 \$18458 \$16316 NWELL PWELL BULK DFF_X1
X$43614 \$I179198 \$20175 \$20199 \$16316 NWELL PWELL BULK DFF_X1
X$43617 \$I174715 \$18832 \$18850 \$16316 NWELL PWELL BULK DFF_X1
X$43620 \$I178601 \$19175 \$19177 \$16316 NWELL PWELL BULK DFF_X1
X$43622 \$I178598 \$19796 \$19179 \$16316 NWELL PWELL BULK DFF_X1
X$43624 \$I178602 \$19794 \$20191 \$16316 NWELL PWELL BULK DFF_X1
X$43626 \$19786 \$21075 \$20766 \$16316 NWELL PWELL BULK DFF_X1
X$43665 \$16753 M0_AXI_BRESP[0] NWELL PWELL BULK BUF_X1
X$43694 S2_AXI_BID[2] \$16356 NWELL PWELL BULK BUF_X1
X$43733 \$19172 \$18892 \$16397 \$18877 \$17632 \$18871 NWELL PWELL BULK
+ OAI221_X2
X$43735 \$21947 \$21486 \$19517 \$16397 NWELL PWELL BULK MUX2_X2
X$43787 \$16921 \$16463 NWELL PWELL BULK INV_X2
X$43792 \$16960 \$16463 \$27889 \$27891 NWELL PWELL BULK AOI21_X1
X$43794 \$16463 \$28118 \$18146 \$28091 NWELL PWELL BULK AOI21_X1
X$43839 \$16507 \$17944 NWELL PWELL BULK INV_X1
X$43992 \$22532 \$23062 \$16633 \$22527 NWELL PWELL BULK MUX2_X2
X$43994 \$25194 \$26380 \$16633 \$25940 NWELL PWELL BULK MUX2_X2
X$43996 \$26716 \$25881 \$16633 \$26200 NWELL PWELL BULK MUX2_X2
X$43998 \$23982 \$23987 \$16633 \$24214 NWELL PWELL BULK MUX2_X2
X$44000 \$21231 \$21374 \$16633 \$21418 NWELL PWELL BULK MUX2_X2
X$44002 \$23446 \$23161 \$16633 \$23169 NWELL PWELL BULK MUX2_X2
X$44004 \$26142 \$26668 \$16633 \$25384 NWELL PWELL BULK MUX2_X2
X$44007 \$24432 \$25339 \$16633 \$25415 NWELL PWELL BULK MUX2_X2
X$44010 \$19430 \$20836 \$16633 \$20839 NWELL PWELL BULK MUX2_X2
X$44012 \$22037 \$22504 \$16633 \$22250 NWELL PWELL BULK MUX2_X2
X$44014 \$23955 \$23741 \$16633 \$23969 NWELL PWELL BULK MUX2_X2
X$44016 \$19306 \$19308 \$16633 \$18754 NWELL PWELL BULK MUX2_X2
X$44020 \$19100 \$20386 \$16633 \$20087 NWELL PWELL BULK MUX2_X2
X$44023 \$20369 \$20664 \$16633 \$20829 NWELL PWELL BULK MUX2_X2
X$44025 \$24157 \$23991 \$I245556 \$16633 NWELL PWELL BULK DFF_X2
X$44060 \$16650 \$19115 \$24944 \$25357 NWELL PWELL BULK NAND3_X4
X$44063 \$19457 \$21400 \$16650 \$19115 \$25764 NWELL PWELL BULK NAND4_X1
X$44066 \$19115 \$16650 \$24944 \$25365 NWELL PWELL BULK AND3_X2
X$44068 \$25920 \$21400 \$16650 \$19115 \$25918 NWELL PWELL BULK NAND4_X1
X$44070 \$19115 \$16650 \$21400 \$22274 \$21723 NWELL PWELL BULK AND4_X2
X$44072 \$21276 \$16650 \$19115 \$20942 NWELL PWELL BULK NAND3_X2
X$44074 \$16650 \$19115 \$22695 NWELL PWELL BULK NAND2_X1
X$44076 \$19115 \$16650 \$22167 NWELL PWELL BULK AND2_X2
X$44079 \$19115 \$16650 \$21400 \$23618 \$24356 NWELL PWELL BULK AND4_X1
X$44095 \$17484 \$16663 NWELL PWELL BULK INV_X2
X$44102 \$16666 \$17866 NWELL PWELL BULK INV_X1
X$44127 \$27124 \$16670 \$27230 \$27590 NWELL PWELL BULK MUX2_X1
X$44130 \$20096 \$16670 \$19397 \$20525 NWELL PWELL BULK MUX2_X1
X$44134 \$27456 \$16670 \$26447 \$27457 NWELL PWELL BULK MUX2_X1
X$44137 \$25947 \$16670 \$24976 \$26256 NWELL PWELL BULK MUX2_X1
X$44140 \$25951 \$16670 \$26452 \$26994 NWELL PWELL BULK MUX2_X1
X$44144 \$27860 \$27864 \$28316 \$16670 NWELL PWELL BULK NOR3_X4
X$44166 \$24880 \$23228 \$24201 \$16686 NWELL PWELL BULK AND3_X2
X$44238 \$I179177 \$19775 \$20155 \$16716 NWELL PWELL BULK DFF_X1
X$44240 \$18538 \$16716 \$18429 \$17996 NWELL PWELL BULK DFF_X2
X$44245 \$17613 \$16716 \$I245724 \$17614 NWELL PWELL BULK DFF_X2
X$44248 \$19752 \$16716 \$20730 \$18806 NWELL PWELL BULK DFF_X2
X$44250 \$I175871 \$19599 \$19891 \$16716 NWELL PWELL BULK DFF_X1
X$44252 \$I176914 \$19893 \$19139 \$16716 NWELL PWELL BULK DFF_X1
X$44254 \$I176583 \$19745 \$20553 \$16716 NWELL PWELL BULK DFF_X1
X$44257 \$I177164 \$19138 \$19896 \$16716 NWELL PWELL BULK DFF_X1
X$44260 \$I176944 \$20135 \$20134 \$16716 NWELL PWELL BULK DFF_X1
X$44262 \$I177089 \$18800 \$18966 \$16716 NWELL PWELL BULK DFF_X1
X$44264 \$18169 \$16716 \$17241 \$16921 NWELL PWELL BULK DFF_X2
X$44268 \$I175828 \$24541 \$24673 \$16716 NWELL PWELL BULK DFF_X1
X$44270 \$21537 \$16716 \$21023 \$19758 NWELL PWELL BULK DFF_X2
X$44272 \$I175047 \$21976 \$21977 \$16716 NWELL PWELL BULK DFF_X1
X$44275 \$21889 \$22341 \$22576 \$16716 NWELL PWELL BULK DFF_X1
X$44277 \$I177322 \$25016 \$24544 \$16716 NWELL PWELL BULK DFF_X1
X$44279 \$19161 \$20771 \$20772 \$16716 NWELL PWELL BULK DFF_X1
X$44281 \$23273 \$16716 \$I245632 \$23482 NWELL PWELL BULK DFF_X2
X$44283 \$I177372 \$23900 \$24543 \$16716 NWELL PWELL BULK DFF_X1
X$44285 \$I176850 \$22589 \$22590 \$16716 NWELL PWELL BULK DFF_X1
X$44289 \$19751 \$16716 \$20448 \$18423 NWELL PWELL BULK DFF_X2
X$44292 \$I175804 \$21885 \$21884 \$16716 NWELL PWELL BULK DFF_X1
X$44294 \$I177498 \$21019 \$21016 \$16716 NWELL PWELL BULK DFF_X1
X$44296 \$21883 \$22607 \$22626 \$16716 NWELL PWELL BULK DFF_X1
X$44298 \$I174993 \$21018 \$21452 \$16716 NWELL PWELL BULK DFF_X1
X$44300 \$23467 \$16716 \$I245631 \$23276 NWELL PWELL BULK DFF_X2
X$44302 \$I176827 \$23019 \$23451 \$16716 NWELL PWELL BULK DFF_X1
X$44331 \$16940 \$16719 NWELL PWELL BULK INV_X1
X$44333 \$19162 \$18429 \$16719 \$19160 NWELL PWELL BULK NAND3_X1
X$44336 \$17741 \$16719 \$16945 NWELL PWELL BULK NAND2_X1
X$44338 \$16719 \$17618 \$17243 NWELL PWELL BULK AND2_X1
X$44360 \$18012 \$16732 \$17262 NWELL PWELL BULK NOR2_X1
X$44362 \$17259 \$16732 \$17260 NWELL PWELL BULK NOR2_X1
X$44365 \$17332 \$16732 \$17693 NWELL PWELL BULK NOR2_X1
X$44367 \$16814 \$16732 \$17272 NWELL PWELL BULK NOR2_X1
X$44379 \$18006 \$16733 \$18106 \$18010 \$18818 NWELL PWELL BULK AOI22_X2
X$44384 \$16733 \$17259 NWELL PWELL BULK INV_X1
X$44389 \$18498 \$18892 \$16735 \$18877 \$18818 \$19548 NWELL PWELL BULK
+ OAI221_X2
X$44394 \$21900 \$21960 \$19517 \$16735 NWELL PWELL BULK MUX2_X2
X$44410 \$16739 \$17332 NWELL PWELL BULK INV_X1
X$44414 \$18006 \$16739 \$18088 \$18010 \$17632 NWELL PWELL BULK AOI22_X2
X$44451 \$16759 S1_AXI_AWADDR[2] NWELL PWELL BULK BUF_X1
X$44483 \$16775 S1_AXI_AWADDR[6] NWELL PWELL BULK BUF_X1
X$44502 \$16791 S1_AXI_AWADDR[7] NWELL PWELL BULK BUF_X1
X$44517 \$16796 S1_AXI_AWID[4] NWELL PWELL BULK BUF_X1
X$44568 \$22355 \$22451 \$19517 \$16856 NWELL PWELL BULK MUX2_X2
X$44570 \$18820 \$18892 \$16856 \$18877 \$18821 \$19235 NWELL PWELL BULK
+ OAI221_X2
X$44587 \$17260 \$17258 \$16860 \$17708 NWELL PWELL BULK AOI21_X1
X$44594 \$17693 \$17269 \$16860 \$17680 NWELL PWELL BULK AOI21_X1
X$44655 \$19162 \$16940 \$18812 \$18923 NWELL PWELL BULK NAND3_X1
X$44658 \$17997 \$16940 \$18816 NWELL PWELL BULK NOR2_X1
X$44661 \$17997 \$16940 \$17996 \$18533 NWELL PWELL BULK OAI21_X1
X$44666 \$16940 \$24550 \$25093 NWELL PWELL BULK XNOR2_X1
X$44668 \$24611 \$21461 \$I245678 \$16940 NWELL PWELL BULK DFF_X2
X$44670 \$18499 \$16940 \$24248 NWELL PWELL BULK NOR2_X4
X$44699 \$18430 \$18815 \$16949 NWELL PWELL BULK NAND2_X2
X$44701 \$16949 \$18910 \$18511 NWELL PWELL BULK NOR2_X1
X$44704 \$17618 \$16949 \$18433 NWELL PWELL BULK NOR2_X2
X$44707 \$17624 \$17741 \$16949 \$17618 \$18006 NWELL PWELL BULK NOR4_X4
X$44723 \$37128 \$37127 \$I241120 \$16960 NWELL PWELL BULK HA_X1
X$44725 \$38614 \$16960 \$38323 NWELL PWELL BULK NAND2_X1
X$44728 \$37819 \$16960 \$37504 \$38343 NWELL PWELL BULK NOR3_X1
X$44810 \$18421 \$17050 NWELL PWELL BULK INV_X1
X$44896 \$20538 \$17136 \$19746 \$19803 NWELL PWELL BULK MUX2_X1
X$44907 \$24686 \$25445 \$I245737 \$17136 NWELL PWELL BULK DFF_X2
X$44910 \$23023 \$17136 \$22948 \$23473 NWELL PWELL BULK MUX2_X1
X$44912 \$24237 \$17136 \$25127 \$25066 NWELL PWELL BULK MUX2_X1
X$44914 \$21992 \$17136 \$21454 \$21952 NWELL PWELL BULK MUX2_X1
X$44917 \$24290 \$17136 \$24235 \$24532 NWELL PWELL BULK MUX2_X1
X$44987 \$32460 \$51281 \$17156 \$51285 \$32461 NWELL PWELL BULK AOI22_X4
X$45038 \$20087 \$17201 \$21697 \$21809 \$21380 NWELL PWELL BULK NAND4_X2
X$45041 \$21697 \$17201 \$20087 \$21809 \$21384 NWELL PWELL BULK AND4_X2
X$45044 \$24465 \$17201 \$24940 NWELL PWELL BULK NAND2_X2
X$45047 \$17201 \$24465 \$25363 NWELL PWELL BULK AND2_X1
X$45098 \$17217 \$17949 NWELL PWELL BULK INV_X2
X$45157 \$17741 \$17241 \$17405 NWELL PWELL BULK NOR2_X1
X$45160 \$17241 \$17246 NWELL PWELL BULK INV_X1
X$45166 \$17243 \$17244 \$18146 NWELL PWELL BULK OR2_X4
X$45185 \$18498 \$17258 NWELL PWELL BULK INV_X1
X$45197 \$19172 \$17269 NWELL PWELL BULK INV_X1
X$45205 \$19518 \$18892 \$17271 \$18877 \$18474 \$19787 NWELL PWELL BULK
+ OAI221_X2
X$45207 \$20315 \$20260 \$19517 \$17271 NWELL PWELL BULK MUX2_X2
X$45234 \$17292 S1_AXI_ARADDR[21] NWELL PWELL BULK BUF_X1
X$45296 \$17326 \$34618 \$31910 \$32461 NWELL PWELL BULK AOI21_X4
X$45312 \$17336 \$34638 \$25327 \$32461 NWELL PWELL BULK AOI21_X4
X$45364 \$21893 \$21894 \$21895 \$17376 NWELL PWELL BULK AND3_X2
X$45390 \$17625 \$17618 \$17405 \$17739 NWELL PWELL BULK MUX2_X1
X$45433 \$17614 \$17447 NWELL PWELL BULK INV_X1
X$45549 \$21825 \$17582 \$21827 NWELL PWELL BULK NOR2_X1
X$45552 \$20087 \$17582 \$22186 NWELL PWELL BULK NOR2_X2
X$45555 \$21738 \$17582 \$21742 \$20953 \$20951 \$20956 \$21303 NWELL PWELL
+ BULK OAI33_X1
X$45611 \$17618 \$17621 \$19164 \$18892 NWELL PWELL BULK NAND3_X4
X$45614 \$19583 \$18808 \$20775 \$17618 \$18812 NWELL PWELL BULK OAI22_X4
X$45616 \$18910 \$17741 \$17621 \$17618 \$18010 NWELL PWELL BULK NOR4_X4
X$45634 \$18815 \$18430 \$17621 NWELL PWELL BULK AND2_X2
X$45642 \$17741 \$17624 \$18433 \$18877 NWELL PWELL BULK NAND3_X4
X$45644 \$19773 \$19508 \$18812 \$17624 NWELL PWELL BULK MUX2_X2
X$45668 \$17655 M0_AXI_BID[0] NWELL PWELL BULK BUF_X1
X$45764 \$18926 \$19573 \$19269 \$17741 \$18812 NWELL PWELL BULK OAI22_X4
X$45771 \$17741 \$18910 \$19164 NWELL PWELL BULK NOR2_X2
X$45811 \$32460 \$49846 \$17755 \$49847 \$33856 NWELL PWELL BULK AOI22_X4
X$45836 \$17801 \$25950 NWELL PWELL BULK BUF_X4
X$45838 \$17801 \$21000 NWELL PWELL BULK BUF_X4
X$45841 \$17801 \$28890 NWELL PWELL BULK BUF_X4
X$45844 \$17801 \$39339 NWELL PWELL BULK BUF_X4
X$45848 \$17801 \$21994 NWELL PWELL BULK BUF_X4
X$45851 \$17801 \$21640 NWELL PWELL BULK BUF_X4
X$45872 \$17801 \$20994 NWELL PWELL BULK BUF_X4
X$45878 \$20694 \$20083 \$17808 NWELL PWELL BULK NOR2_X2
X$45956 \$32460 \$51782 \$17896 \$51791 \$32461 NWELL PWELL BULK AOI22_X4
X$45976 \$17898 \$34404 \$23142 \$32461 NWELL PWELL BULK AOI21_X4
X$46151 \$17990 \$18169 NWELL PWELL BULK INV_X1
X$46155 \$18423 \$18425 \$17993 \$18424 NWELL PWELL BULK OAI21_X1
X$46158 \$18809 \$17995 \$18423 \$18810 \$19156 NWELL PWELL BULK OAI22_X1
X$46160 \$19576 \$17995 \$18812 \$18430 NWELL PWELL BULK NAND3_X1
X$46162 \$20430 \$19852 \$17995 \$20152 NWELL PWELL BULK OAI21_X1
X$46165 \$17995 \$18954 \$18801 \$19143 NWELL PWELL BULK NOR3_X2
X$46167 \$17995 \$18954 \$19506 NWELL PWELL BULK NOR2_X1
X$46171 \$18802 \$17995 \$18810 \$19151 NWELL PWELL BULK OAI21_X1
X$46173 \$18954 \$18810 \$17995 \$20511 NWELL PWELL BULK AOI21_X1
X$46181 \$19838 \$17996 \$19508 \$18910 NWELL PWELL BULK OAI21_X2
X$46183 \$17996 \$19775 \$19838 NWELL PWELL BULK NAND2_X1
X$46185 \$18429 \$18816 \$19160 \$19162 \$17996 \$19771 NWELL PWELL BULK
+ OAI221_X1
X$46190 \$17996 \$18812 NWELL PWELL BULK INV_X2
X$46193 \$17996 \$18425 \$18811 \$18926 NWELL PWELL BULK OR3_X1
X$46197 \$17996 \$19763 \$20448 \$19852 NWELL PWELL BULK AOI21_X1
X$46230 \$18010 \$18823 NWELL PWELL BULK INV_X1
X$46283 \$18034 S1_AXI_AWADDR[5] NWELL PWELL BULK BUF_X1
X$46381 \$38313 \$18146 \$38321 \$37512 \$37508 NWELL PWELL BULK AND4_X1
X$46384 \$18146 \$37506 \$38446 NWELL PWELL BULK NAND2_X1
X$46539 \$32460 \$51726 \$18303 \$51743 \$32461 NWELL PWELL BULK AOI22_X4
X$46571 \$32460 \$48934 \$18329 \$48602 \$33856 NWELL PWELL BULK AOI22_X4
X$46593 \$I176372 \$18335 \$19094 \$18338 NWELL PWELL BULK DFF_X1
X$46598 \$I176436 \$18337 \$18556 \$18338 NWELL PWELL BULK DFF_X1
X$46604 \$20914 \$21191 \$21610 \$18338 NWELL PWELL BULK DFF_X1
X$46606 \$I177983 \$18746 \$18936 \$18338 NWELL PWELL BULK DFF_X1
X$46609 \$26143 \$25870 \$26135 \$18338 NWELL PWELL BULK DFF_X1
X$46612 \$I174520 \$25334 \$25624 \$18338 NWELL PWELL BULK DFF_X1
X$46614 \$23737 \$24675 \$24349 \$18338 NWELL PWELL BULK DFF_X1
X$46616 \$19597 \$19884 \$20337 \$18338 NWELL PWELL BULK DFF_X1
X$46618 \$I177996 \$20048 \$20345 \$18338 NWELL PWELL BULK DFF_X1
X$46621 \$I176382 \$20053 \$19686 \$18338 NWELL PWELL BULK DFF_X1
X$46624 \$I176540 \$21603 \$20910 \$18338 NWELL PWELL BULK DFF_X1
X$46627 \$25634 \$25635 \$25337 \$18338 NWELL PWELL BULK DFF_X1
X$46629 \$I174466 \$21777 \$22046 \$18338 NWELL PWELL BULK DFF_X1
X$46631 \$I178881 \$21361 \$21357 \$18338 NWELL PWELL BULK DFF_X1
X$46633 \$22039 \$21173 \$21588 \$18338 NWELL PWELL BULK DFF_X1
X$46636 \$I176510 \$20660 \$21597 \$18338 NWELL PWELL BULK DFF_X1
X$46639 \$23740 \$23432 \$23155 \$18338 NWELL PWELL BULK DFF_X1
X$46641 \$22032 \$22030 \$22026 \$18338 NWELL PWELL BULK DFF_X1
X$46643 \$25168 \$25632 \$24427 \$18338 NWELL PWELL BULK DFF_X1
X$46645 \$23449 \$23050 \$23444 \$18338 NWELL PWELL BULK DFF_X1
X$46647 \$22862 \$22510 \$22509 \$18338 NWELL PWELL BULK DFF_X1
X$46649 \$26367 \$26663 \$26366 \$18338 NWELL PWELL BULK DFF_X1
X$46651 \$23443 \$23438 \$23046 \$18338 NWELL PWELL BULK DFF_X1
X$46654 \$22507 \$21769 \$22041 \$18338 NWELL PWELL BULK DFF_X1
X$46657 \$24430 \$24688 \$24687 \$18338 NWELL PWELL BULK DFF_X1
X$46659 \$23961 \$24678 \$24351 \$18338 NWELL PWELL BULK DFF_X1
X$46661 \$20366 \$21195 \$20662 \$18338 NWELL PWELL BULK DFF_X1
X$46664 \$I176417 \$19688 \$19895 \$18338 NWELL PWELL BULK DFF_X1
X$46667 \$I176410 \$19609 \$19903 \$18338 NWELL PWELL BULK DFF_X1
X$46670 \$23424 \$23949 \$23153 \$18338 NWELL PWELL BULK DFF_X1
X$46704 \$I176838 \$18595 \$18349 \$18753 NWELL PWELL BULK DFF_X1
X$46796 \$19455 \$24129 \$24483 \$18404 NWELL PWELL BULK AOI21_X2
X$46833 \$37347 \$28890 \$I245639 \$18421 NWELL PWELL BULK DFF_X2
X$46836 \$37126 \$27889 \$18421 \$37139 NWELL PWELL BULK MUX2_X1
X$46844 \$18954 \$18810 \$18424 \$18422 NWELL PWELL BULK AOI21_X1
X$46846 \$18801 \$18806 \$18422 \$18808 NWELL PWELL BULK OAI21_X2
X$46849 \$18423 \$18807 \$18425 \$18809 NWELL PWELL BULK AOI21_X1
X$46852 \$19758 \$18806 \$18423 \$19765 NWELL PWELL BULK NOR3_X1
X$46854 \$18423 \$19505 NWELL PWELL BULK INV_X1
X$46856 \$18423 \$19325 \$18425 \$18802 NWELL PWELL BULK AOI21_X1
X$46859 \$20145 \$20142 \$18423 \$19506 \$20445 NWELL PWELL BULK AOI22_X1
X$46861 \$20729 \$18423 \$20145 NWELL PWELL BULK NOR2_X1
X$46865 \$18423 \$19333 \$18425 \$19598 NWELL PWELL BULK AOI21_X1
X$46867 \$19143 \$18423 \$19144 NWELL PWELL BULK NAND2_X1
X$46869 \$21151 \$18954 \$21023 \$18423 \$19758 \$20730 \$20734 NWELL PWELL
+ BULK OAI33_X1
X$46887 \$18429 \$18425 \$19765 \$20430 NWELL PWELL BULK AND3_X1
X$46889 \$20140 \$18804 \$18425 \$19505 \$19763 NWELL PWELL BULK NAND4_X1
X$46895 \$18425 \$19599 \$18800 \$19749 NWELL PWELL BULK NOR3_X1
X$46901 \$18425 \$20735 \$20736 \$20156 \$21024 NWELL PWELL BULK OAI22_X1
X$46903 \$20729 \$18425 \$20732 NWELL PWELL BULK NAND2_X1
X$46925 \$18804 \$18429 \$20148 NWELL PWELL BULK NAND2_X1
X$46942 \$18433 \$19164 \$19162 NWELL PWELL BULK NAND2_X1
X$46945 \$18892 \$18440 NWELL PWELL BULK INV_X1
X$46955 \$18448 M0_AXI_BID[1] NWELL PWELL BULK BUF_X1
X$46968 \$25483 \$21907 \$18459 \$26028 NWELL PWELL BULK MUX2_X1
X$46971 \$26032 \$21904 \$18459 \$26554 NWELL PWELL BULK MUX2_X1
X$46973 \$27911 \$22983 \$18459 \$27947 NWELL PWELL BULK MUX2_X1
X$46975 \$27516 \$23316 \$18459 \$27522 NWELL PWELL BULK MUX2_X1
X$46987 \$24558 \$21907 \$18465 \$24556 NWELL PWELL BULK MUX2_X1
X$46990 \$24562 \$23316 \$18465 \$24571 NWELL PWELL BULK MUX2_X1
X$46992 \$25043 \$21904 \$18465 \$24559 NWELL PWELL BULK MUX2_X1
X$46995 \$24565 \$22983 \$18465 \$25516 NWELL PWELL BULK MUX2_X1
X$47028 \$18494 S1_AXI_AWADDR[20] NWELL PWELL BULK BUF_X1
X$47037 \$44925 \$43962 \$18498 \$45200 NWELL PWELL BULK DFF_X2
X$47077 \$18526 \$34722 \$29885 \$32461 NWELL PWELL BULK AOI21_X4
X$47126 \$I177369 \$18584 \$18585 \$18753 NWELL PWELL BULK DFF_X1
X$47137 \$18587 \$21366 NWELL PWELL BULK INV_X4
X$47140 \$18587 \$21785 \$22083 NWELL PWELL BULK NAND2_X1
X$47142 \$21785 \$23176 \$18587 \$20336 NWELL PWELL BULK NOR3_X4
X$47145 \$18587 \$22876 \$22875 NWELL PWELL BULK NAND2_X1
X$47147 \$18587 \$22235 \$22539 NWELL PWELL BULK NAND2_X1
X$47150 \$18587 \$20919 \$21618 NWELL PWELL BULK NAND2_X1
X$47152 \$18587 \$20917 \$19691 \$I241523 NWELL PWELL BULK HA_X1
X$47155 \$21785 \$23747 \$18587 \$20046 NWELL PWELL BULK NOR3_X4
X$47158 \$18587 \$23747 \$23746 NWELL PWELL BULK NAND2_X1
X$47282 \$32460 \$49848 \$18745 \$49497 \$33856 NWELL PWELL BULK AOI22_X4
X$47312 \$I177239 \$18752 \$18971 \$18753 NWELL PWELL BULK DFF_X1
X$47318 \$20924 \$20390 \$20672 \$18753 NWELL PWELL BULK DFF_X1
X$47320 \$22568 \$21790 \$21791 \$18753 NWELL PWELL BULK DFF_X1
X$47323 \$21221 \$20671 \$20669 \$18753 NWELL PWELL BULK DFF_X1
X$47325 \$22064 \$20919 \$22071 \$18753 NWELL PWELL BULK DFF_X1
X$47327 \$21783 \$18753 \$I245715 \$21785 NWELL PWELL BULK DFF_X2
X$47330 \$I175627 \$20667 \$20372 \$18753 NWELL PWELL BULK DFF_X1
X$47332 \$22566 \$22556 \$21787 \$18753 NWELL PWELL BULK DFF_X1
X$47335 \$19036 \$18753 NWELL PWELL BULK BUF_X4
X$47338 \$I175566 \$22876 \$23179 \$18753 NWELL PWELL BULK DFF_X1
X$47340 \$I174949 \$24451 \$24930 \$18753 NWELL PWELL BULK DFF_X1
X$47342 \$20920 \$21371 \$21629 \$18753 NWELL PWELL BULK DFF_X1
X$47344 \$21633 \$21372 \$21373 \$18753 NWELL PWELL BULK DFF_X1
X$47346 \$I177422 \$24445 \$25688 \$18753 NWELL PWELL BULK DFF_X1
X$47348 \$I174407 \$22235 \$22535 \$18753 NWELL PWELL BULK DFF_X1
X$47351 \$23490 \$18753 \$I245708 \$23747 NWELL PWELL BULK DFF_X2
X$47354 \$24442 \$18753 \$I245710 \$19683 NWELL PWELL BULK DFF_X2
X$47356 \$I175560 \$24443 \$24442 \$18753 NWELL PWELL BULK DFF_X1
X$47359 \$22579 \$22574 \$22242 \$18753 NWELL PWELL BULK DFF_X1
X$47361 \$23509 \$23500 \$23502 \$18753 NWELL PWELL BULK DFF_X1
X$47363 \$I178580 \$20676 \$21241 \$18753 NWELL PWELL BULK DFF_X1
X$47365 \$I178500 \$24161 \$23184 \$18753 NWELL PWELL BULK DFF_X1
X$47368 \$I177395 \$23750 \$24007 \$18753 NWELL PWELL BULK DFF_X1
X$47371 \$24022 \$24162 \$23185 \$18753 NWELL PWELL BULK DFF_X1
X$47376 \$I177378 \$19298 \$19102 \$18753 NWELL PWELL BULK DFF_X1
X$47379 \$I177379 \$20060 \$20385 \$18753 NWELL PWELL BULK DFF_X1
X$47381 \$I178733 \$19104 \$19949 \$18753 NWELL PWELL BULK DFF_X1
X$47384 \$I174785 \$19098 \$19295 \$18753 NWELL PWELL BULK DFF_X1
X$47386 \$I174731 \$19441 \$19934 \$18753 NWELL PWELL BULK DFF_X1
X$47414 \$18754 \$20440 \$21809 NWELL PWELL BULK NOR2_X2
X$47418 \$18754 \$20087 \$24465 NWELL PWELL BULK NAND2_X1
X$47420 \$24448 \$18754 \$25370 NWELL PWELL BULK AND2_X1
X$47425 \$18754 \$21311 NWELL PWELL BULK INV_X1
X$47427 \$20087 \$20440 \$18754 \$21825 NWELL PWELL BULK OR3_X1
X$47530 \$18800 \$19142 NWELL PWELL BULK INV_X1
X$47533 \$18801 \$19141 \$19142 \$19325 NWELL PWELL BULK NAND3_X1
X$47535 \$19767 \$18801 \$20787 NWELL PWELL BULK NAND2_X1
X$47539 \$18801 \$18806 \$18807 NWELL PWELL BULK NAND2_X1
X$47550 \$18810 \$18807 \$18804 \$18805 \$18811 NWELL PWELL BULK AOI22_X1
X$47556 \$18806 \$18805 \$18804 \$19310 NWELL PWELL BULK OAI21_X1
X$47558 \$18806 \$20511 \$18804 \$20517 NWELL PWELL BULK OAI21_X1
X$47569 \$19505 \$19506 \$18805 \$18810 \$18812 \$19583 NWELL PWELL BULK
+ OAI221_X2
X$47578 \$18806 \$19500 NWELL PWELL BULK INV_X1
X$47582 \$19758 \$18806 \$20729 NWELL PWELL BULK NOR2_X1
X$47604 \$19758 \$18810 NWELL PWELL BULK INV_X2
X$47615 \$19872 \$19598 \$18810 \$19145 \$21537 NWELL PWELL BULK OAI22_X1
X$47631 \$18811 \$19836 \$19505 \$19576 NWELL PWELL BULK OAI21_X1
X$47634 \$18812 \$19161 \$18815 NWELL PWELL BULK OR2_X1
X$47662 \$19238 \$18898 \$18900 \$18819 NWELL PWELL BULK MUX2_X1
X$47665 \$40039 \$34366 \$18820 \$40639 NWELL PWELL BULK DFF_X2
X$47694 \$18837 M0_AXI_BID[2] NWELL PWELL BULK BUF_X1
X$47703 \$18838 S1_AXI_ARADDR[17] NWELL PWELL BULK BUF_X1
X$47714 \$32460 \$49584 \$18845 \$48557 \$32461 NWELL PWELL BULK AOI22_X4
X$47748 \$18857 \$19513 \$18860 \$18861 NWELL PWELL BULK MUX2_X1
X$47753 \$19212 \$18898 \$18859 \$19542 NWELL PWELL BULK MUX2_X1
X$47756 S0_AXI_BRESP[0] \$18860 NWELL PWELL BULK BUF_X1
X$47758 \$18860 \$20341 \$19815 \$19519 NWELL PWELL BULK MUX2_X1
X$47760 \$19213 \$19511 \$18860 \$18873 NWELL PWELL BULK MUX2_X1
X$47765 \$18860 \$20167 \$21058 \$20174 NWELL PWELL BULK MUX2_X1
X$47778 \$18863 S1_AXI_AWADDR[9] NWELL PWELL BULK BUF_X1
X$47790 \$23827 \$21907 \$18871 \$23871 NWELL PWELL BULK MUX2_X1
X$47792 \$25041 \$23316 \$18871 \$24255 NWELL PWELL BULK MUX2_X1
X$47795 \$25040 \$22983 \$18871 \$25038 NWELL PWELL BULK MUX2_X1
X$47798 \$22360 \$21904 \$18871 \$22434 NWELL PWELL BULK MUX2_X1
X$47843 \$20243 \$18898 \$20245 \$19816 NWELL PWELL BULK MUX2_X1
X$47846 \$20329 \$18898 \$20166 \$20330 NWELL PWELL BULK MUX2_X1
X$47848 \$21898 \$18898 \$22349 \$21463 NWELL PWELL BULK MUX2_X1
X$47850 \$19781 \$18898 \$19512 \$19779 NWELL PWELL BULK MUX2_X1
X$47853 \$20310 \$18898 \$19786 \$20315 NWELL PWELL BULK MUX2_X1
X$47856 \$20276 \$18898 \$20255 \$20260 NWELL PWELL BULK MUX2_X1
X$47860 \$21029 \$18898 \$20164 \$20162 NWELL PWELL BULK MUX2_X1
X$47862 \$23391 \$18898 \$23294 \$21900 NWELL PWELL BULK MUX2_X1
X$47865 \$23404 \$18898 \$24548 \$21085 NWELL PWELL BULK MUX2_X1
X$47868 \$22463 \$18898 \$21903 \$21947 NWELL PWELL BULK MUX2_X1
X$47871 \$21961 \$18898 \$21957 \$21960 NWELL PWELL BULK MUX2_X1
X$47873 \$21484 \$18898 \$21478 \$21486 NWELL PWELL BULK MUX2_X1
X$47875 \$23373 \$18898 \$23296 \$22355 NWELL PWELL BULK MUX2_X1
X$47877 \$22966 \$18898 \$22967 \$22451 NWELL PWELL BULK MUX2_X1
X$47879 \$23287 \$21461 \$I245732 \$18898 NWELL PWELL BULK DFF_X2
X$47901 \$19243 \$19513 \$19170 \$18899 NWELL PWELL BULK MUX2_X1
X$47940 \$19156 \$18954 \$19508 NWELL PWELL BULK NAND2_X1
X$47942 \$18954 \$19758 \$20142 NWELL PWELL BULK NAND2_X1
X$47951 \$18954 \$21023 \$19758 \$20730 \$20140 NWELL PWELL BULK OAI22_X1
X$48011 \$19036 \$30047 NWELL PWELL BULK BUF_X4
X$48016 \$19036 \$34366 NWELL PWELL BULK BUF_X4
X$48018 \$19036 \$32516 NWELL PWELL BULK BUF_X4
X$48022 \$19036 \$20927 NWELL PWELL BULK BUF_X4
X$48025 \$19036 \$23991 NWELL PWELL BULK BUF_X4
X$48028 \$19036 \$31789 NWELL PWELL BULK BUF_X4
X$48030 \$19036 \$30263 NWELL PWELL BULK BUF_X4
X$48062 \$19036 \$21417 NWELL PWELL BULK BUF_X4
X$48076 \$19076 S1_AXI_AWADDR[30] NWELL PWELL BULK BUF_X1
X$48124 \$19098 \$19929 \$19439 NWELL PWELL BULK XNOR2_X1
X$48178 \$19116 \$20937 \$20938 NWELL PWELL BULK NOR2_X1
X$48180 \$20434 \$19116 \$20677 \$20086 NWELL PWELL BULK MUX2_X2
X$48188 \$19123 \$20097 \$19964 \$19638 NWELL PWELL BULK MUX2_X1
X$48191 \$19123 \$24504 \$19397 \$19967 NWELL PWELL BULK MUX2_X1
X$48215 \$19599 \$19141 NWELL PWELL BULK INV_X1
X$48220 \$19310 \$19141 \$19142 \$19333 NWELL PWELL BULK NAND3_X1
X$48232 \$19143 \$19505 \$19573 NWELL PWELL BULK NOR2_X1
X$48246 \$19500 \$19145 \$19592 \$19752 NWELL PWELL BULK OAI21_X1
X$48280 \$19168 \$19511 \$19170 \$19248 NWELL PWELL BULK MUX2_X1
X$48286 \$19170 \$20167 \$20323 \$19824 NWELL PWELL BULK MUX2_X1
X$48289 \$19170 \$20341 \$20331 \$20335 NWELL PWELL BULK MUX2_X1
X$48291 S0_AXI_BRESP[1] \$19170 NWELL PWELL BULK BUF_X1
X$48297 \$44544 \$43962 \$19172 \$44545 NWELL PWELL BULK DFF_X2
X$48324 \$19528 M0_AXI_BID[3] NWELL PWELL BULK BUF_X1
X$48368 \$23300 \$22983 \$19235 \$23320 NWELL PWELL BULK MUX2_X1
X$48371 \$22390 \$21907 \$19235 \$22363 NWELL PWELL BULK MUX2_X1
X$48374 \$21912 \$21904 \$19235 \$21911 NWELL PWELL BULK MUX2_X1
X$48376 \$23302 \$23316 \$19235 \$23309 NWELL PWELL BULK MUX2_X1
X$48396 \$19245 S1_AXI_AWADDR[28] NWELL PWELL BULK BUF_X1
X$48412 \$19512 \$19513 \$19782 \$19253 NWELL PWELL BULK MUX2_X1
X$48427 \$19269 \$20739 \$21024 \$21461 NWELL PWELL BULK DFF_X1
X$48444 \$19620 \$19691 \$19438 \$19293 NWELL PWELL BULK MUX2_X1
X$48574 \$34718 \$24330 \$32461 \$19425 NWELL PWELL BULK AOI21_X2
X$48596 \$19591 \$19683 \$19597 \$19430 NWELL PWELL BULK MUX2_X1
X$48601 \$32460 \$48599 \$19433 \$48604 \$33856 NWELL PWELL BULK AOI22_X4
X$48618 \$20667 \$20860 \$20057 \$21206 \$19438 NWELL PWELL BULK FA_X1
X$48641 \$19708 \$19454 \$19714 NWELL PWELL BULK OR2_X4
X$48643 \$19704 \$19708 \$19454 \$20075 NWELL PWELL BULK OAI21_X2
X$48646 \$24178 \$23776 \$22895 \$19455 NWELL PWELL BULK OAI21_X4
X$48648 \$24126 \$20947 \$19455 \$25263 NWELL PWELL BULK OR3_X1
X$48657 \$25380 \$19455 \$24448 \$25379 \$25348 NWELL PWELL BULK NAND4_X2
X$48672 \$19457 \$20086 \$24944 NWELL PWELL BULK NAND2_X2
X$48676 \$20938 \$20936 \$21698 \$19457 \$21276 NWELL PWELL BULK NOR4_X2
X$48681 \$19457 \$20970 NWELL PWELL BULK INV_X1
X$48684 \$19457 \$21413 \$22274 NWELL PWELL BULK NOR2_X1
X$48687 \$19457 \$21828 \$23618 NWELL PWELL BULK NOR2_X1
X$48693 \$27338 \$19457 \$25920 NWELL PWELL BULK AND2_X1
X$48792 \$20734 \$19506 \$21133 \$20733 NWELL PWELL BULK AOI21_X1
X$48799 \$19508 \$20399 \$19773 \$20156 \$20155 NWELL PWELL BULK OAI22_X1
X$48806 \$19781 \$19511 \$19782 \$19564 NWELL PWELL BULK MUX2_X1
X$48809 \$23295 \$19511 \$21510 \$23392 NWELL PWELL BULK MUX2_X1
X$48811 \$20171 \$19511 \$20747 \$20299 NWELL PWELL BULK MUX2_X1
X$48813 \$21898 \$19511 \$21966 \$22524 NWELL PWELL BULK MUX2_X1
X$48815 \$21466 \$19511 \$21037 \$21502 NWELL PWELL BULK MUX2_X1
X$48819 \$22965 \$19511 \$22356 \$22993 NWELL PWELL BULK MUX2_X1
X$48822 \$22346 \$22959 \$22961 \$19511 NWELL PWELL BULK NOR3_X4
X$48834 \$22353 \$19513 \$21510 \$22499 NWELL PWELL BULK MUX2_X1
X$48837 \$21497 \$19513 \$21037 \$21500 NWELL PWELL BULK MUX2_X1
X$48841 \$23297 \$19513 \$22356 \$23371 NWELL PWELL BULK MUX2_X1
X$48843 \$21075 \$19513 \$20747 \$20766 NWELL PWELL BULK MUX2_X1
X$48849 \$22346 \$23291 \$22961 \$19513 NWELL PWELL BULK NOR3_X4
X$48851 \$22349 \$19513 \$21966 \$22351 NWELL PWELL BULK MUX2_X1
X$48862 \$21463 \$21085 \$19517 \$20159 NWELL PWELL BULK MUX2_X2
X$48864 \$19779 \$20162 \$19517 \$20742 NWELL PWELL BULK MUX2_X2
X$48874 \$19779 \$19517 \$19778 NWELL PWELL BULK NOR2_X1
X$48876 \$21460 \$21461 \$I245557 \$19517 NWELL PWELL BULK DFF_X2
X$48878 \$21463 \$19517 \$21027 NWELL PWELL BULK NOR2_X1
X$48880 \$19517 \$20743 NWELL PWELL BULK INV_X1
X$48895 \$41523 \$34366 \$19518 \$41811 NWELL PWELL BULK DFF_X2
X$48930 \$25481 \$21904 \$19548 \$26569 NWELL PWELL BULK MUX2_X1
X$48933 \$26026 \$21907 \$19548 \$26024 NWELL PWELL BULK MUX2_X1
X$48937 \$27969 \$22983 \$19548 \$27985 NWELL PWELL BULK MUX2_X1
X$48939 \$27527 \$23316 \$19548 \$27159 NWELL PWELL BULK MUX2_X1
X$48951 \$34098 \$29333 \$32461 \$19563 NWELL PWELL BULK AOI21_X2
X$48987 \$19877 \$20046 \$19682 \$19589 NWELL PWELL BULK MUX2_X1
X$49096 M1_AXI_ARLEN[4] \$19682 NWELL PWELL BULK CLKBUF_X2
X$49102 \$19884 \$20336 \$19682 \$20337 NWELL PWELL BULK MUX2_X1
X$49112 \$22060 \$19683 \$21780 \$22532 NWELL PWELL BULK MUX2_X1
X$49114 \$23168 \$19683 \$23469 \$23062 NWELL PWELL BULK MUX2_X1
X$49117 \$26378 \$19683 \$26379 \$26380 NWELL PWELL BULK MUX2_X1
X$49120 \$27263 \$19683 \$25880 \$25881 NWELL PWELL BULK MUX2_X1
X$49123 \$25209 \$19683 \$25674 \$26716 NWELL PWELL BULK MUX2_X1
X$49126 \$26680 \$19683 \$26370 \$25339 NWELL PWELL BULK MUX2_X1
X$49129 \$25168 \$19683 \$25634 \$26142 NWELL PWELL BULK MUX2_X1
X$49131 \$22032 \$19683 \$22039 \$22504 NWELL PWELL BULK MUX2_X1
X$49134 \$22024 \$19683 \$22494 \$22037 NWELL PWELL BULK MUX2_X1
X$49137 \$19916 \$19683 \$19919 \$20369 NWELL PWELL BULK MUX2_X1
X$49142 \$25189 \$19683 \$24438 \$25194 NWELL PWELL BULK MUX2_X1
X$49144 \$20366 \$19683 \$20914 \$20664 NWELL PWELL BULK MUX2_X1
X$49147 \$20338 \$19683 \$20834 \$20836 NWELL PWELL BULK MUX2_X1
X$49149 \$22862 \$19683 \$23449 \$23161 NWELL PWELL BULK MUX2_X1
X$49151 \$24435 \$19683 \$25179 \$23982 NWELL PWELL BULK MUX2_X1
X$49153 \$23961 \$19683 \$23740 \$23741 NWELL PWELL BULK MUX2_X1
X$49155 \$26143 \$19683 \$26367 \$26668 NWELL PWELL BULK MUX2_X1
X$49157 \$23452 \$19683 \$23985 \$23987 NWELL PWELL BULK MUX2_X1
X$49159 \$22507 \$19683 \$23443 \$23446 NWELL PWELL BULK MUX2_X1
X$49161 \$24430 \$19683 \$24431 \$24432 NWELL PWELL BULK MUX2_X1
X$49163 \$23424 \$19683 \$23737 \$23955 NWELL PWELL BULK MUX2_X1
X$49194 \$21203 \$20860 \$19690 NWELL PWELL BULK XOR2_X1
X$49196 \$19690 \$19691 \$19929 NWELL PWELL BULK NOR2_X1
X$49200 \$19691 \$20057 \$20375 NWELL PWELL BULK NOR2_X1
X$49203 \$20375 \$20667 \$19691 \$20373 NWELL PWELL BULK AOI21_X1
X$49221 \$19704 \$20947 \$20451 \$20964 NWELL PWELL BULK OR3_X2
X$49223 \$19704 \$20947 \$23209 NWELL PWELL BULK OR2_X2
X$49225 \$19704 \$19717 NWELL PWELL BULK INV_X1
X$49227 \$20451 \$19704 \$23194 NWELL PWELL BULK NAND2_X1
X$49233 \$22902 \$23195 \$19704 \$21806 NWELL PWELL BULK NAND3_X2
X$49262 \$20452 \$20688 \$19708 NWELL PWELL BULK NOR2_X1
X$49267 \$24375 \$24181 \$19709 \$24182 NWELL PWELL BULK MUX2_X2
X$49269 \$19709 \$24476 \$24194 \$24483 NWELL PWELL BULK OAI21_X2
X$49273 \$19709 \$21282 \$20686 \$20944 NWELL PWELL BULK AOI21_X4
X$49289 \$23209 \$19714 \$27089 NWELL PWELL BULK NOR2_X1
X$49401 \$20436 \$19765 \$19767 \$20735 NWELL PWELL BULK AOI21_X1
X$49407 \$19767 \$20399 NWELL PWELL BULK INV_X1
X$49415 \$19775 \$19773 NWELL PWELL BULK INV_X1
X$49443 S0_AXI_BID[4] \$19782 NWELL PWELL BULK BUF_X1
X$49448 \$19782 \$20167 \$20164 \$21031 NWELL PWELL BULK MUX2_X1
X$49451 \$19782 \$20341 \$21029 \$21094 NWELL PWELL BULK MUX2_X1
X$49462 \$22970 \$22983 \$19787 \$23335 NWELL PWELL BULK MUX2_X1
X$49464 \$23854 \$23316 \$19787 \$23860 NWELL PWELL BULK MUX2_X1
X$49466 \$22397 \$21904 \$19787 \$21919 NWELL PWELL BULK MUX2_X1
X$49468 \$21909 \$21907 \$19787 \$21927 NWELL PWELL BULK MUX2_X1
X$49502 \$19803 S1_AXI_ARADDR[13] NWELL PWELL BULK BUF_X1
X$49704 \$32460 \$34025 \$20027 \$33028 \$32461 NWELL PWELL BULK AOI22_X4
X$49738 \$20045 S1_AXI_AWADDR[27] NWELL PWELL BULK BUF_X1
X$49744 \$21364 \$20046 \$21365 \$22054 NWELL PWELL BULK MUX2_X1
X$49746 \$21769 \$20046 \$21771 \$22041 NWELL PWELL BULK MUX2_X1
X$49749 \$24688 \$20046 \$24429 \$24687 NWELL PWELL BULK MUX2_X1
X$49751 \$23949 \$20046 \$24153 \$23153 NWELL PWELL BULK MUX2_X1
X$49756 \$24707 \$20046 \$24441 \$24706 NWELL PWELL BULK MUX2_X1
X$49758 \$25632 \$20046 \$25336 \$24427 NWELL PWELL BULK MUX2_X1
X$49760 \$24436 \$20046 \$25877 \$24918 NWELL PWELL BULK MUX2_X1
X$49762 \$24365 \$20046 \$23744 \$24156 NWELL PWELL BULK MUX2_X1
X$49764 \$22481 \$20046 \$22226 \$22018 NWELL PWELL BULK MUX2_X1
X$49825 \$20075 \$20849 \$20947 \$21382 NWELL PWELL BULK NOR3_X1
X$49844 \$21708 \$21303 \$20943 \$20083 \$21389 NWELL PWELL BULK OAI22_X4
X$49846 \$20083 \$24191 \$24190 NWELL PWELL BULK NAND2_X1
X$49860 \$22711 \$22717 \$20084 \$22719 \$23086 NWELL PWELL BULK AOI22_X4
X$49863 \$20084 \$24964 \$27090 \$39850 \$27337 NWELL PWELL BULK AOI22_X2
X$49866 \$24493 \$20084 \$24198 NWELL PWELL BULK NOR2_X1
X$49871 \$26894 \$23228 \$23783 \$20084 \$26911 NWELL PWELL BULK NAND4_X1
X$49873 \$24487 \$20084 \$24865 \$25818 NWELL PWELL BULK MUX2_X1
X$49876 \$22755 \$20084 \$24201 NWELL PWELL BULK NAND2_X1
X$49896 \$20086 \$21698 \$21400 NWELL PWELL BULK NOR2_X4
X$49919 \$20087 \$23104 NWELL PWELL BULK INV_X2
X$49925 \$21809 \$20087 \$21394 \$21742 NWELL PWELL BULK NAND3_X1
X$49954 \$20096 \$20097 \$20706 \$20098 NWELL PWELL BULK MUX2_X1
X$49959 \$27853 \$20097 \$28412 \$27251 NWELL PWELL BULK MUX2_X1
X$49961 \$27473 \$20097 \$26925 \$27217 NWELL PWELL BULK MUX2_X1
X$49964 \$26171 \$20097 \$24995 \$25717 NWELL PWELL BULK MUX2_X1
X$49966 \$21428 \$20097 \$21429 \$21860 NWELL PWELL BULK MUX2_X1
X$49969 \$21867 \$20097 \$21438 \$21869 NWELL PWELL BULK MUX2_X1
X$49973 \$25197 \$20097 \$24506 \$24977 NWELL PWELL BULK MUX2_X1
X$49975 \$24227 \$20097 \$24529 \$24228 NWELL PWELL BULK MUX2_X1
X$49979 \$27456 \$20097 \$27849 \$27613 NWELL PWELL BULK MUX2_X1
X$49981 \$25947 \$20097 \$26976 \$25395 NWELL PWELL BULK MUX2_X1
X$49984 \$27115 \$20097 \$28400 \$26973 NWELL PWELL BULK MUX2_X1
X$49987 \$25434 \$20097 \$25982 \$25692 NWELL PWELL BULK MUX2_X1
X$49990 \$27481 \$20994 \$I245707 \$20097 NWELL PWELL BULK DFF_X2
X$49993 \$22310 \$20097 \$22313 \$21868 NWELL PWELL BULK MUX2_X1
X$49995 \$26860 \$20097 \$26854 \$25981 NWELL PWELL BULK MUX2_X1
X$49997 \$25951 \$20097 \$26456 \$26458 NWELL PWELL BULK MUX2_X1
X$50000 \$25431 \$20097 \$25426 \$25980 NWELL PWELL BULK MUX2_X1
X$50002 \$23248 \$20097 \$23055 \$21862 NWELL PWELL BULK MUX2_X1
X$50004 \$24992 \$20097 \$25420 \$25711 NWELL PWELL BULK MUX2_X1
X$50006 \$20993 \$20097 \$21435 \$21232 NWELL PWELL BULK MUX2_X1
X$50008 \$27124 \$20097 \$27126 \$27218 NWELL PWELL BULK MUX2_X1
X$50041 \$20104 \$25797 NWELL PWELL BULK INV_X1
X$50109 \$20148 \$20445 \$20738 \$20436 NWELL PWELL BULK NOR3_X1
X$50112 \$20152 \$20738 \$21116 \$20156 \$20772 NWELL PWELL BULK OAI22_X1
X$50118 \$20787 \$20733 \$20775 \$20156 \$21977 NWELL PWELL BULK OAI22_X1
X$50135 \$20162 \$20743 \$20160 NWELL PWELL BULK NOR2_X1
X$50150 \$I178190 \$20164 \$21031 \$21032 NWELL PWELL BULK DFF_X1
X$50156 \$22356 \$20167 \$23346 \$23350 NWELL PWELL BULK MUX2_X1
X$50158 \$21037 \$20167 \$21479 \$21469 NWELL PWELL BULK MUX2_X1
X$50160 \$22959 \$22346 \$22958 \$20167 NWELL PWELL BULK NAND3_X4
X$50167 \$21966 \$20167 \$24548 \$24612 NWELL PWELL BULK MUX2_X1
X$50169 \$21510 \$20167 \$22475 \$21956 NWELL PWELL BULK MUX2_X1
X$50171 \$20747 \$20167 \$21065 \$20263 NWELL PWELL BULK MUX2_X1
X$50204 \$20193 S1_AXI_AWADDR[3] NWELL PWELL BULK BUF_X1
X$50229 \$32460 \$45644 \$20229 \$46211 \$32461 NWELL PWELL BULK AOI22_X4
X$50245 \$20231 S1_AXI_AWADDR[1] NWELL PWELL BULK BUF_X1
X$50266 \$32460 \$51297 \$20254 \$51813 \$32461 NWELL PWELL BULK AOI22_X4
X$50296 \$20747 \$20341 \$20266 \$20278 NWELL PWELL BULK MUX2_X1
X$50333 \$34925 \$34614 \$32461 \$20283 NWELL PWELL BULK AOI21_X2
X$50359 \$I179035 \$20309 \$21557 \$21355 NWELL PWELL BULK DFF_X1
X$50406 \$25643 \$20336 \$24429 \$24690 NWELL PWELL BULK MUX2_X1
X$50409 \$25635 \$20336 \$25336 \$25337 NWELL PWELL BULK MUX2_X1
X$50411 \$26176 \$20336 \$25877 \$25344 NWELL PWELL BULK MUX2_X1
X$50415 \$24675 \$20336 \$24153 \$24349 NWELL PWELL BULK MUX2_X1
X$50421 \$24710 \$20336 \$24441 \$24920 NWELL PWELL BULK MUX2_X1
X$50423 \$22514 \$20336 \$21365 \$22518 NWELL PWELL BULK MUX2_X1
X$50425 \$24434 \$20336 \$23744 \$25176 NWELL PWELL BULK MUX2_X1
X$50427 \$22228 \$20336 \$22226 \$22490 NWELL PWELL BULK MUX2_X1
X$50429 \$23438 \$20336 \$21771 \$23046 NWELL PWELL BULK MUX2_X1
X$50456 \$23291 \$22346 \$22958 \$20341 NWELL PWELL BULK NAND3_X4
X$50458 \$21037 \$20341 \$21487 \$21489 NWELL PWELL BULK MUX2_X1
X$50460 \$21510 \$20341 \$21509 \$21508 NWELL PWELL BULK MUX2_X1
X$50463 \$21966 \$20341 \$23404 \$23825 NWELL PWELL BULK MUX2_X1
X$50466 \$22356 \$20341 \$22988 \$22990 NWELL PWELL BULK MUX2_X1
X$50549 \$20434 \$20677 \$20936 NWELL PWELL BULK NOR2_X1
X$50558 \$29538 \$25724 \$25899 \$26785 \$27798 \$20440 \$28743 NWELL PWELL
+ BULK OAI33_X1
X$50562 \$26262 \$20440 \$21697 \$25363 NWELL PWELL BULK AOI21_X4
X$50564 \$24178 \$20440 \$23775 NWELL PWELL BULK NOR2_X1
X$50567 \$20440 \$25906 \$21697 \$25363 \$27423 NWELL PWELL BULK AOI211_X2
X$50569 \$20440 \$28507 \$28763 \$29628 \$29970 \$29627 \$28764 NWELL PWELL
+ BULK OAI33_X1
X$50571 \$24160 \$24389 \$24730 \$20440 NWELL PWELL BULK AND3_X4
X$50574 \$20440 \$23783 \$24487 \$20978 \$20947 \$24961 NWELL PWELL BULK
+ OAI221_X1
X$50611 \$20732 \$20448 \$21133 NWELL PWELL BULK NAND2_X1
X$50613 \$20448 \$21151 NWELL PWELL BULK INV_X1
X$50621 \$23209 \$20451 \$23210 NWELL PWELL BULK NOR2_X1
X$50626 \$20451 \$23209 \$23612 \$23216 NWELL PWELL BULK OR3_X1
X$50629 \$20451 \$20947 \$23195 NWELL PWELL BULK NOR2_X1
X$50760 \$I178720 \$20631 \$21529 \$20888 NWELL PWELL BULK DFF_X1
X$50772 \$20641 S1_AXI_AWADDR[18] NWELL PWELL BULK BUF_X1
X$50816 \$32917 \$32915 \$20677 \$24969 NWELL PWELL BULK MUX2_X2
X$50818 \$29699 \$29958 \$20677 \$25390 NWELL PWELL BULK MUX2_X2
X$50821 \$32414 \$32152 \$20677 \$25403 NWELL PWELL BULK MUX2_X2
X$50823 \$29507 \$29509 \$20677 \$25957 NWELL PWELL BULK MUX2_X2
X$50826 \$32032 \$33005 \$20677 \$26467 NWELL PWELL BULK MUX2_X2
X$50828 \$29660 \$28973 \$20677 \$25417 NWELL PWELL BULK MUX2_X2
X$50830 \$22573 \$22244 \$20677 \$21666 NWELL PWELL BULK MUX2_X2
X$50833 \$31512 \$32065 \$20677 \$24212 NWELL PWELL BULK MUX2_X2
X$50835 \$33747 \$33474 \$20677 \$20987 NWELL PWELL BULK MUX2_X2
X$50837 \$32537 \$32538 \$20677 \$26281 NWELL PWELL BULK MUX2_X2
X$50839 \$34304 \$33902 \$20677 \$25972 NWELL PWELL BULK MUX2_X2
X$50841 \$33726 \$33107 \$20677 \$26469 NWELL PWELL BULK MUX2_X2
X$50843 \$29701 \$30047 \$I245669 \$20677 NWELL PWELL BULK DFF_X2
X$50846 \$20677 \$20937 NWELL PWELL BULK INV_X1
X$50874 \$20683 \$24174 \$24194 NWELL PWELL BULK AND2_X2
X$50876 \$24053 \$20683 \$22192 \$23766 \$24476 NWELL PWELL BULK AOI211_X2
X$50879 \$23759 \$20683 \$24178 NWELL PWELL BULK NAND2_X2
X$50881 \$23193 \$20683 \$22650 NWELL PWELL BULK NAND2_X1
X$50884 \$23191 \$20683 \$24045 NWELL PWELL BULK NAND2_X1
X$50886 \$26815 \$25377 \$20683 \$26810 NWELL PWELL BULK OAI21_X1
X$50889 \$24945 \$21417 \$25364 \$20683 NWELL PWELL BULK DFF_X2
X$50891 \$20683 \$20943 NWELL PWELL BULK INV_X1
X$50896 \$20683 \$21296 \$20687 \$20686 NWELL PWELL BULK AOI21_X2
X$50916 \$25370 \$20685 \$26831 NWELL PWELL BULK NAND2_X1
X$50931 \$20687 \$23579 NWELL PWELL BULK BUF_X4
X$50940 \$21394 \$20932 \$20689 NWELL PWELL BULK NOR2_X1
X$50948 \$21409 \$21836 \$22157 \$20696 NWELL PWELL BULK OAI21_X1
X$50953 \$20701 \$27306 NWELL PWELL BULK INV_X1
X$50970 \$I178361 \$20706 \$21271 \$21640 NWELL PWELL BULK DFF_X1
X$51026 \$20739 \$20736 NWELL PWELL BULK INV_X1
X$51050 \$21085 \$20743 \$21101 NWELL PWELL BULK NOR2_X1
X$51054 S0_AXI_BID[3] \$20747 NWELL PWELL BULK BUF_X1
X$51081 \$20771 \$21116 NWELL PWELL BULK INV_X1
X$51090 \$21976 \$20775 NWELL PWELL BULK INV_X1
X$51131 \$32460 \$49707 \$20820 \$49839 \$33856 NWELL PWELL BULK AOI22_X4
X$51161 \$20829 \$26938 NWELL PWELL BULK INV_X1
X$51184 \$20839 \$27308 NWELL PWELL BULK INV_X1
X$51201 \$20849 \$20964 \$20973 NWELL PWELL BULK NOR2_X1
X$51247 \$I178574 \$20884 \$21327 \$21324 NWELL PWELL BULK DFF_X1
X$51250 \$32460 \$49823 \$20886 \$49945 \$32461 NWELL PWELL BULK AOI22_X4
X$51265 \$I178496 \$20887 \$21069 \$21324 NWELL PWELL BULK DFF_X1
X$51269 \$I174681 \$21754 \$21953 \$20888 NWELL PWELL BULK DFF_X1
X$51272 \$I178605 \$20889 \$21335 \$20888 NWELL PWELL BULK DFF_X1
X$51274 \$23347 \$22994 \$22839 \$20888 NWELL PWELL BULK DFF_X1
X$51276 \$22208 \$22209 \$22410 \$20888 NWELL PWELL BULK DFF_X1
X$51279 \$I178497 \$21750 \$21748 \$20888 NWELL PWELL BULK DFF_X1
X$51282 \$23344 \$23338 \$23343 \$20888 NWELL PWELL BULK DFF_X1
X$51284 \$22413 \$22399 \$22407 \$20888 NWELL PWELL BULK DFF_X1
X$51286 \$24420 \$25096 \$24605 \$20888 NWELL PWELL BULK DFF_X1
X$51288 \$24614 \$23882 \$24606 \$20888 NWELL PWELL BULK DFF_X1
X$51290 \$I174524 \$23400 \$23394 \$20888 NWELL PWELL BULK DFF_X1
X$51292 \$I175197 \$22437 \$21345 \$20888 NWELL PWELL BULK DFF_X1
X$51295 \$I179165 \$20896 \$20894 \$20888 NWELL PWELL BULK DFF_X1
X$51297 \$I174842 \$21761 \$21343 \$20888 NWELL PWELL BULK DFF_X1
X$51300 \$I178507 \$22452 \$22442 \$20888 NWELL PWELL BULK DFF_X1
X$51302 \$I175239 \$21760 \$21542 \$20888 NWELL PWELL BULK DFF_X1
X$51305 \$I174811 \$23728 \$23389 \$20888 NWELL PWELL BULK DFF_X1
X$51307 \$I175221 \$22215 \$22446 \$20888 NWELL PWELL BULK DFF_X1
X$51310 \$I174843 \$22851 \$23014 \$20888 NWELL PWELL BULK DFF_X1
X$51313 \$I175240 \$22211 \$23005 \$20888 NWELL PWELL BULK DFF_X1
X$51316 \$I174813 \$23139 \$23359 \$20888 NWELL PWELL BULK DFF_X1
X$51318 \$I175209 \$21974 \$21756 \$20888 NWELL PWELL BULK DFF_X1
X$51321 \$26079 \$25557 \$26073 \$20888 NWELL PWELL BULK DFF_X1
X$51324 \$I179196 \$23140 \$23890 \$20888 NWELL PWELL BULK DFF_X1
X$51326 \$25321 \$25558 \$24902 \$20888 NWELL PWELL BULK DFF_X1
X$51329 \$25852 \$26584 \$26579 \$20888 NWELL PWELL BULK DFF_X1
X$51331 \$25851 \$26075 \$26575 \$20888 NWELL PWELL BULK DFF_X1
X$51334 \$I179211 \$22846 \$23008 \$20888 NWELL PWELL BULK DFF_X1
X$51336 \$I179197 \$24906 \$24905 \$20888 NWELL PWELL BULK DFF_X1
X$51341 \$I175242 \$25119 \$24621 \$20888 NWELL PWELL BULK DFF_X1
X$51414 \$23750 \$20917 \$24445 \$24005 NWELL PWELL BULK MUX2_X1
X$51417 \$25348 \$25887 \$20917 NWELL PWELL BULK NAND2_X2
X$51420 \$25347 \$20917 \$26199 \$25883 NWELL PWELL BULK MUX2_X1
X$51422 \$20917 \$21208 NWELL PWELL BULK INV_X1
X$51425 \$24719 \$20917 \$25347 \$25214 NWELL PWELL BULK MUX2_X1
X$51428 \$24443 \$20917 \$24927 \$24928 NWELL PWELL BULK MUX2_X1
X$51431 \$24927 \$20917 \$26722 \$26718 NWELL PWELL BULK MUX2_X1
X$51442 \$20919 \$22235 \$23474 \$22869 NWELL PWELL BULK HA_X1
X$51444 \$21366 \$20919 \$21369 NWELL PWELL BULK NAND2_X1
X$51457 \$I176272 \$27064 \$27717 \$20927 NWELL PWELL BULK DFF_X1
X$51459 \$I177231 \$30259 \$30054 \$20927 NWELL PWELL BULK DFF_X1
X$51461 \$29070 \$20927 \$28728 \$27406 NWELL PWELL BULK DFF_X2
X$51464 \$29704 \$20927 \$I245626 \$29173 NWELL PWELL BULK DFF_X2
X$51466 \$I175166 \$27397 \$27785 \$20927 NWELL PWELL BULK DFF_X1
X$51469 \$27061 \$27060 \$27393 \$20927 NWELL PWELL BULK DFF_X1
X$51471 \$29073 \$20927 \$27794 \$25900 NWELL PWELL BULK DFF_X2
X$51473 \$I176271 \$27062 \$27290 \$20927 NWELL PWELL BULK DFF_X1
X$51475 \$I177359 \$30257 \$29704 \$20927 NWELL PWELL BULK DFF_X1
X$51478 \$I177360 \$28156 \$28674 \$20927 NWELL PWELL BULK DFF_X1
X$51480 \$29519 \$29139 \$29515 \$20927 NWELL PWELL BULK DFF_X1
X$51482 \$I175549 \$31017 \$30770 \$20927 NWELL PWELL BULK DFF_X1
X$51485 \$24170 \$24766 \$24760 \$20927 NWELL PWELL BULK DFF_X1
X$51490 \$25250 \$20927 \$I245722 \$24167 NWELL PWELL BULK DFF_X2
X$51492 \$I174972 \$25890 \$25888 \$20927 NWELL PWELL BULK DFF_X1
X$51495 \$25700 \$20927 \$I245549 \$24168 NWELL PWELL BULK DFF_X2
X$51497 \$I174925 \$25892 \$25350 \$20927 NWELL PWELL BULK DFF_X1
X$51500 \$25350 \$20927 \$I245720 \$23187 NWELL PWELL BULK DFF_X2
X$51502 \$I175578 \$26393 \$26241 \$20927 NWELL PWELL BULK DFF_X1
X$51504 \$I174862 \$25708 \$25893 \$20927 NWELL PWELL BULK DFF_X1
X$51507 \$24460 \$25712 \$25715 \$20927 NWELL PWELL BULK DFF_X1
X$51510 \$21648 \$21375 \$22106 \$20927 NWELL PWELL BULK DFF_X1
X$51512 \$21644 \$22582 \$22107 \$20927 NWELL PWELL BULK DFF_X1
X$51514 \$23186 \$23520 \$23518 \$20927 NWELL PWELL BULK DFF_X1
X$51516 \$22611 \$22591 \$22600 \$20927 NWELL PWELL BULK DFF_X1
X$51518 \$23532 \$22884 \$23114 \$20927 NWELL PWELL BULK DFF_X1
X$51520 \$22594 \$22246 \$22879 \$20927 NWELL PWELL BULK DFF_X1
X$51522 \$21662 \$21378 \$21659 \$20927 NWELL PWELL BULK DFF_X1
X$51524 \$21796 \$20928 \$21656 \$20927 NWELL PWELL BULK DFF_X1
X$51557 \$20932 \$22891 NWELL PWELL BULK INV_X1
X$51559 \$21676 \$21380 \$20932 \$21382 \$21262 NWELL PWELL BULK AOI22_X1
X$51562 \$20932 \$20935 \$22886 \$23549 NWELL PWELL BULK OAI21_X1
X$51564 \$23539 \$21417 \$23190 \$20932 NWELL PWELL BULK DFF_X2
X$51567 \$20932 \$21384 \$21806 \$22150 NWELL PWELL BULK OAI21_X1
X$51569 \$20932 \$21380 \$20935 \$20933 NWELL PWELL BULK OAI21_X1
X$51571 \$21267 \$20932 \$22192 NWELL PWELL BULK NAND2_X2
X$51585 \$21267 \$21384 \$20933 \$21383 NWELL PWELL BULK OAI21_X1
X$51587 \$21381 \$21379 \$20935 \$22623 NWELL PWELL BULK OAI21_X1
X$51590 \$23551 \$23123 \$21806 \$20935 \$23193 NWELL PWELL BULK NAND4_X1
X$51592 \$21382 \$20935 \$21802 NWELL PWELL BULK NOR2_X1
X$51597 \$20935 \$21801 \$22150 \$22638 NWELL PWELL BULK AOI21_X1
X$51624 \$20943 \$21389 \$21282 NWELL PWELL BULK NOR2_X1
X$51627 \$20943 \$22260 \$23112 NWELL PWELL BULK AND2_X1
X$51632 \$27319 \$28198 \$20947 \$23579 \$27427 \$27078 NWELL PWELL BULK
+ AOI221_X2
X$51635 \$27797 \$20947 \$23579 \$27427 \$29538 NWELL PWELL BULK AOI211_X2
X$51638 \$20947 \$25906 \$23579 \$27427 \$27803 NWELL PWELL BULK AOI211_X2
X$51641 \$20947 \$23579 \$27427 \$28484 NWELL PWELL BULK AOI21_X2
X$51644 \$25705 \$25895 \$25894 \$20947 NWELL PWELL BULK AND3_X4
X$51646 \$27438 \$28624 \$28758 \$20947 \$27665 \$29002 NWELL PWELL BULK
+ OAI221_X1
X$51663 \$20947 \$26426 \$26894 NWELL PWELL BULK NOR2_X1
X$51665 \$26385 \$20947 \$26868 \$27337 NWELL PWELL BULK AOI21_X4
X$51707 \$22911 \$20969 \$23224 NWELL PWELL BULK NAND2_X1
X$51709 \$22911 \$20969 \$23783 \$23226 \$21828 NWELL PWELL BULK AOI22_X4
X$51714 \$21413 \$20971 NWELL PWELL BULK INV_X1
X$51717 \$21828 \$21404 \$20971 \$22717 NWELL PWELL BULK AOI21_X2
X$51719 \$20971 \$21404 \$21307 NWELL PWELL BULK NAND2_X1
X$51721 \$21295 \$20971 \$21683 NWELL PWELL BULK NAND2_X1
X$51724 \$20971 \$21410 \$21832 \$22288 NWELL PWELL BULK OAI21_X1
X$51731 \$20972 \$21417 \$21703 \$21404 NWELL PWELL BULK DFF_X2
X$51735 \$21690 \$21409 \$21404 \$20973 \$21291 NWELL PWELL BULK AOI22_X1
X$51738 \$20973 \$21703 \$21404 \$21295 NWELL PWELL BULK OAI21_X1
X$51741 \$21413 \$21832 \$20973 \$21848 NWELL PWELL BULK OAI21_X1
X$51743 \$20973 \$21413 \$21404 \$21841 NWELL PWELL BULK OAI21_X1
X$51751 \$20975 \$21679 NWELL PWELL BULK INV_X1
X$51753 \$21832 \$21411 \$20975 \$21843 NWELL PWELL BULK NOR3_X1
X$51755 \$20975 \$21411 \$21839 \$22125 NWELL PWELL BULK OR3_X1
X$51761 \$20976 \$20978 \$21279 NWELL PWELL BULK NAND2_X1
X$51766 \$26445 \$20978 \$26263 NWELL PWELL BULK NAND2_X1
X$51769 \$25953 \$20978 \$27015 NWELL PWELL BULK NAND2_X1
X$51771 \$20978 \$23228 \$22291 NWELL PWELL BULK XNOR2_X1
X$51774 \$22172 \$22165 \$21729 \$20978 \$21831 NWELL PWELL BULK OAI22_X4
X$51779 \$27022 \$20978 \$25410 NWELL PWELL BULK NAND2_X1
X$51782 \$26984 \$20978 \$27237 NWELL PWELL BULK NAND2_X1
X$51784 \$27021 \$20978 \$26232 NWELL PWELL BULK NAND2_X1
X$51787 \$23795 \$20978 \$23796 NWELL PWELL BULK NAND2_X1
X$51789 \$26966 \$20978 \$26941 NWELL PWELL BULK NAND2_X1
X$51791 \$23228 \$20978 \$24448 \$25933 NWELL PWELL BULK NAND3_X1
X$51793 \$25747 \$20978 \$26470 NWELL PWELL BULK NAND2_X1
X$51796 \$26276 \$20978 \$26441 NWELL PWELL BULK NAND2_X1
X$51799 \$26279 \$20978 \$25939 NWELL PWELL BULK NAND2_X1
X$51801 \$23783 \$20978 \$24880 NWELL PWELL BULK NAND2_X1
X$51804 \$21624 \$20978 \$21617 NWELL PWELL BULK NAND2_X1
X$51827 \$27835 \$20987 \$28607 \$27839 \$32553 NWELL PWELL BULK OAI22_X2
X$51871 \$I176244 \$20993 \$21430 \$21640 NWELL PWELL BULK DFF_X1
X$51874 \$31529 \$30805 \$31528 \$20994 NWELL PWELL BULK DFF_X1
X$51879 \$I176710 \$29743 \$29206 \$20994 NWELL PWELL BULK DFF_X1
X$51881 \$I175229 \$27478 \$27130 \$20994 NWELL PWELL BULK DFF_X1
X$51883 \$29468 \$28530 \$29476 \$20994 NWELL PWELL BULK DFF_X1
X$51887 \$I175889 \$27869 \$27481 \$20994 NWELL PWELL BULK DFF_X1
X$51889 \$I178714 \$29208 \$30138 \$20994 NWELL PWELL BULK DFF_X1
X$51892 \$I175430 \$31320 \$30806 \$20994 NWELL PWELL BULK DFF_X1
X$51895 \$I177937 \$25420 \$25419 \$20994 NWELL PWELL BULK DFF_X1
X$51898 \$24519 \$24761 \$24518 \$20994 NWELL PWELL BULK DFF_X1
X$51901 \$I176666 \$27473 \$27471 \$20994 NWELL PWELL BULK DFF_X1
X$51903 \$I176151 \$26171 \$26174 \$20994 NWELL PWELL BULK DFF_X1
X$51906 \$I178978 \$27124 \$27590 \$20994 NWELL PWELL BULK DFF_X1
X$51908 \$28385 \$20994 \$I245584 \$27860 NWELL PWELL BULK DFF_X2
X$51911 \$I177637 \$23657 \$24019 \$20994 NWELL PWELL BULK DFF_X1
X$51914 \$I178708 \$26925 \$27567 \$20994 NWELL PWELL BULK DFF_X1
X$51916 \$I177879 \$28525 \$29196 \$20994 NWELL PWELL BULK DFF_X1
X$51919 \$I176892 \$24995 \$25159 \$20994 NWELL PWELL BULK DFF_X1
X$51922 \$I177628 \$23800 \$24003 \$20994 NWELL PWELL BULK DFF_X1
X$51925 \$I174417 \$30088 \$29739 \$20994 NWELL PWELL BULK DFF_X1
X$51927 \$I177946 \$24992 \$24521 \$20994 NWELL PWELL BULK DFF_X1
X$51930 \$I174550 \$27126 \$28426 \$20994 NWELL PWELL BULK DFF_X1
X$51933 \$I179052 \$29201 \$29891 \$20994 NWELL PWELL BULK DFF_X1
X$51936 \$29532 \$20994 \$I245582 \$27864 NWELL PWELL BULK DFF_X2
X$51939 \$I179298 \$21224 \$21227 \$20994 NWELL PWELL BULK DFF_X1
X$51941 \$I178958 \$21435 \$22827 \$20994 NWELL PWELL BULK DFF_X1
X$51943 \$I175071 \$22929 \$23051 \$20994 NWELL PWELL BULK DFF_X1
X$51946 \$28523 \$28784 \$28782 \$20994 NWELL PWELL BULK DFF_X1
X$51948 \$I175045 \$22310 \$22819 \$20994 NWELL PWELL BULK DFF_X1
X$51951 \$I176733 \$23256 \$24006 \$20994 NWELL PWELL BULK DFF_X1
X$51978 \$I177472 \$21438 \$20997 \$21000 NWELL PWELL BULK DFF_X1
X$51980 \$I175208 \$21873 \$21439 \$21000 NWELL PWELL BULK DFF_X1
X$51983 \$I174490 \$21871 \$22028 \$21000 NWELL PWELL BULK DFF_X1
X$51986 \$I175519 \$21867 \$22050 \$21000 NWELL PWELL BULK DFF_X1
X$51989 \$I176894 \$22313 \$22933 \$21000 NWELL PWELL BULK DFF_X1
X$51991 \$I177457 \$22794 \$23043 \$21000 NWELL PWELL BULK DFF_X1
X$51994 \$I176566 \$21440 \$22015 \$21000 NWELL PWELL BULK DFF_X1
X$51996 \$I175246 \$22756 \$22777 \$21000 NWELL PWELL BULK DFF_X1
X$51998 \$I174847 \$23258 \$23971 \$21000 NWELL PWELL BULK DFF_X1
X$52000 \$I176915 \$22325 \$22936 \$21000 NWELL PWELL BULK DFF_X1
X$52003 \$I176948 \$22322 \$23038 \$21000 NWELL PWELL BULK DFF_X1
X$52006 \$I177215 \$21001 \$21201 \$21000 NWELL PWELL BULK DFF_X1
X$52008 \$I179293 \$25434 \$26484 \$21000 NWELL PWELL BULK DFF_X1
X$52013 \$I174814 \$24529 \$24723 \$21000 NWELL PWELL BULK DFF_X1
X$52015 \$I175291 \$27485 \$27483 \$21000 NWELL PWELL BULK DFF_X1
X$52018 \$I174816 \$24713 \$25147 \$21000 NWELL PWELL BULK DFF_X1
X$52021 \$I176816 \$25982 \$26144 \$21000 NWELL PWELL BULK DFF_X1
X$52023 \$I175290 \$27874 \$27560 \$21000 NWELL PWELL BULK DFF_X1
X$52026 \$I175964 \$24223 \$24750 \$21000 NWELL PWELL BULK DFF_X1
X$52029 \$I177520 \$25426 \$26170 \$21000 NWELL PWELL BULK DFF_X1
X$52031 \$I176809 \$24227 \$24724 \$21000 NWELL PWELL BULK DFF_X1
X$52034 \$I175249 \$23805 \$24734 \$21000 NWELL PWELL BULK DFF_X1
X$52036 \$I174788 \$23804 \$23803 \$21000 NWELL PWELL BULK DFF_X1
X$52039 \$I177266 \$23802 \$24524 \$21000 NWELL PWELL BULK DFF_X1
X$52042 \$I175082 \$25431 \$25428 \$21000 NWELL PWELL BULK DFF_X1
X$52045 \$I179148 \$23965 \$23966 \$21000 NWELL PWELL BULK DFF_X1
X$52047 \$I179297 \$26854 \$26482 \$21000 NWELL PWELL BULK DFF_X1
X$52050 \$I179149 \$26860 \$26479 \$21000 NWELL PWELL BULK DFF_X1
X$52053 \$I175635 \$28790 \$28791 \$21000 NWELL PWELL BULK DFF_X1
X$52092 \$I175330 \$21011 \$21449 \$21994 NWELL PWELL BULK DFF_X1
X$52098 \$I177514 \$21013 \$21012 \$21994 NWELL PWELL BULK DFF_X1
X$52129 \$I176864 \$21029 \$21094 \$21461 NWELL PWELL BULK DFF_X1
X$52134 \$23391 \$23295 \$23392 \$21032 NWELL PWELL BULK DFF_X1
X$52136 \$I175046 \$21912 \$21911 \$21032 NWELL PWELL BULK DFF_X1
X$52139 \$23294 \$22353 \$22499 \$21032 NWELL PWELL BULK DFF_X1
X$52142 \$I178944 \$26017 \$25470 \$21032 NWELL PWELL BULK DFF_X1
X$52144 \$I175156 \$26507 \$25467 \$21032 NWELL PWELL BULK DFF_X1
X$52147 \$24249 \$25029 \$24602 \$21032 NWELL PWELL BULK DFF_X1
X$52149 \$I176268 \$24252 \$25031 \$21032 NWELL PWELL BULK DFF_X1
X$52151 \$21903 \$21497 \$21500 \$21032 NWELL PWELL BULK DFF_X1
X$52154 \$24595 \$21032 \$I245691 \$24254 NWELL PWELL BULK DFF_X2
X$52157 \$21957 \$22475 \$21956 \$21032 NWELL PWELL BULK DFF_X1
X$52159 \$I176792 \$25040 \$25038 \$21032 NWELL PWELL BULK DFF_X1
X$52162 \$I177377 \$22970 \$23335 \$21032 NWELL PWELL BULK DFF_X1
X$52164 \$I175924 \$25041 \$24255 \$21032 NWELL PWELL BULK DFF_X1
X$52166 \$22463 \$21466 \$21502 \$21032 NWELL PWELL BULK DFF_X1
X$52170 \$I178422 \$22349 \$22351 \$21032 NWELL PWELL BULK DFF_X1
X$52173 \$21961 \$21509 \$21508 \$21032 NWELL PWELL BULK DFF_X1
X$52175 \$I176355 \$22397 \$21919 \$21032 NWELL PWELL BULK DFF_X1
X$52178 \$I176313 \$23300 \$23320 \$21032 NWELL PWELL BULK DFF_X1
X$52181 \$I175057 \$22390 \$22363 \$21032 NWELL PWELL BULK DFF_X1
X$52183 \$23373 \$22965 \$22993 \$21032 NWELL PWELL BULK DFF_X1
X$52185 \$I177518 \$23302 \$23309 \$21032 NWELL PWELL BULK DFF_X1
X$52188 \$I176345 \$23827 \$23871 \$21032 NWELL PWELL BULK DFF_X1
X$52191 \$I174727 \$22360 \$22434 \$21032 NWELL PWELL BULK DFF_X1
X$52193 \$I175310 \$21909 \$21927 \$21032 NWELL PWELL BULK DFF_X1
X$52196 \$21484 \$21487 \$21489 \$21032 NWELL PWELL BULK DFF_X1
X$52199 \$23296 \$23297 \$23371 \$21032 NWELL PWELL BULK DFF_X1
X$52202 \$21478 \$21479 \$21469 \$21032 NWELL PWELL BULK DFF_X1
X$52205 \$22967 \$23346 \$23350 \$21032 NWELL PWELL BULK DFF_X1
X$52207 \$22966 \$22988 \$22990 \$21032 NWELL PWELL BULK DFF_X1
X$52237 S0_AXI_BID[2] \$21037 NWELL PWELL BULK BUF_X1
X$52278 \$21091 S1_AXI_AWADDR[10] NWELL PWELL BULK BUF_X1
X$52307 \$21138 S1_AXI_AWADDR[25] NWELL PWELL BULK BUF_X1
X$52316 \$I179075 \$21143 \$21566 \$21355 NWELL PWELL BULK DFF_X1
X$52357 \$21366 \$21208 \$I241111 \$21203 NWELL PWELL BULK HA_X1
X$52361 \$21203 \$21206 NWELL PWELL BULK INV_X1
X$52421 \$I178216 \$21381 \$21259 \$21417 NWELL PWELL BULK DFF_X1
X$52430 \$22095 \$21266 \$21265 \$21640 NWELL PWELL BULK DFF_X1
X$52435 \$21394 \$21267 NWELL PWELL BULK INV_X1
X$52440 \$21276 \$21267 \$22672 NWELL PWELL BULK NAND2_X1
X$52443 \$21267 \$21806 \$21687 \$21676 NWELL PWELL BULK OAI21_X1
X$52496 \$21307 \$22707 \$22165 NWELL PWELL BULK NAND2_X1
X$52499 \$21839 \$22149 \$21307 \$22746 NWELL PWELL BULK AOI21_X1
X$52507 \$21821 \$21820 \$21317 \$23776 \$22190 NWELL PWELL BULK OAI211_X4
X$52512 \$25243 \$27421 \$21317 \$26812 \$27685 NWELL PWELL BULK OAI211_X2
X$52518 \$21317 \$26812 \$27080 \$27082 \$25243 \$26400 NWELL PWELL BULK
+ OAI221_X2
X$52533 \$29276 \$28573 \$28842 \$21324 NWELL PWELL BULK DFF_X1
X$52535 \$28684 \$29262 \$29254 \$21324 NWELL PWELL BULK DFF_X1
X$52538 \$28837 \$28834 \$28687 \$21324 NWELL PWELL BULK DFF_X1
X$52541 \$27171 \$27036 \$27166 \$21324 NWELL PWELL BULK DFF_X1
X$52543 \$29301 \$28858 \$28850 \$21324 NWELL PWELL BULK DFF_X1
X$52546 \$29306 \$29808 \$29674 \$21324 NWELL PWELL BULK DFF_X1
X$52548 \$27033 \$27353 \$27032 \$21324 NWELL PWELL BULK DFF_X1
X$52550 \$27940 \$27355 \$27926 \$21324 NWELL PWELL BULK DFF_X1
X$52553 \$23127 \$23129 \$23319 \$21324 NWELL PWELL BULK DFF_X1
X$52555 \$23135 \$22986 \$22837 \$21324 NWELL PWELL BULK DFF_X1
X$52557 \$23133 \$23849 \$23322 \$21324 NWELL PWELL BULK DFF_X1
X$52560 \$23128 \$23841 \$23838 \$21324 NWELL PWELL BULK DFF_X1
X$52563 \$I174742 \$21325 \$21920 \$21324 NWELL PWELL BULK DFF_X1
X$52567 \$24893 \$25061 \$24570 \$21324 NWELL PWELL BULK DFF_X1
X$52570 \$25503 \$25500 \$24402 \$21324 NWELL PWELL BULK DFF_X1
X$52572 \$24585 \$24412 \$24144 \$21324 NWELL PWELL BULK DFF_X1
X$52574 \$24408 \$25069 \$24405 \$21324 NWELL PWELL BULK DFF_X1
X$52579 \$26340 \$26336 \$26337 \$21324 NWELL PWELL BULK DFF_X1
X$52581 \$26338 \$26062 \$25848 \$21324 NWELL PWELL BULK DFF_X1
X$52584 \$27974 \$27953 \$27361 \$21324 NWELL PWELL BULK DFF_X1
X$52587 \$27737 \$27968 \$27966 \$21324 NWELL PWELL BULK DFF_X1
X$52590 \$I176577 \$27368 \$27190 \$21324 NWELL PWELL BULK DFF_X1
X$52592 \$I176594 \$27739 \$27978 \$21324 NWELL PWELL BULK DFF_X1
X$52595 \$25314 \$21324 NWELL PWELL BULK BUF_X4
X$52597 \$27037 \$25845 \$26551 \$21324 NWELL PWELL BULK DFF_X1
X$52600 \$26541 \$26522 \$26330 \$21324 NWELL PWELL BULK DFF_X1
X$52603 \$25842 \$25312 \$26038 \$21324 NWELL PWELL BULK DFF_X1
X$52605 \$24414 \$24899 \$25090 \$21324 NWELL PWELL BULK DFF_X1
X$52607 \$24603 \$24589 \$24146 \$21324 NWELL PWELL BULK DFF_X1
X$52648 \$21761 \$21757 \$22435 \$21343 NWELL PWELL BULK MUX2_X1
X$52651 \$22435 \$22207 \$22437 \$21345 NWELL PWELL BULK MUX2_X1
X$52654 \$I174290 \$26360 \$27374 \$21355 NWELL PWELL BULK DFF_X1
X$52656 \$I178946 \$28621 \$28930 \$21355 NWELL PWELL BULK DFF_X1
X$52658 \$I175112 \$28703 \$28943 \$21355 NWELL PWELL BULK DFF_X1
X$52661 \$I174521 \$25869 \$25866 \$21355 NWELL PWELL BULK DFF_X1
X$52665 \$I174530 \$24912 \$25612 \$21355 NWELL PWELL BULK DFF_X1
X$52668 \$I174540 \$24425 \$24151 \$21355 NWELL PWELL BULK DFF_X1
X$52670 \$I179295 \$26365 \$26363 \$21355 NWELL PWELL BULK DFF_X1
X$52672 \$I179296 \$27047 \$27046 \$21355 NWELL PWELL BULK DFF_X1
X$52674 \$I174573 \$28469 \$28958 \$21355 NWELL PWELL BULK DFF_X1
X$52677 \$I179087 \$29119 \$29390 \$21355 NWELL PWELL BULK DFF_X1
X$52679 \$I174578 \$28470 \$28053 \$21355 NWELL PWELL BULK DFF_X1
X$52681 \$I175121 \$28467 \$27757 \$21355 NWELL PWELL BULK DFF_X1
X$52683 \$I178924 \$27236 \$27381 \$21355 NWELL PWELL BULK DFF_X1
X$52685 \$I174672 \$22220 \$22462 \$21355 NWELL PWELL BULK DFF_X1
X$52688 \$I174536 \$23935 \$23731 \$21355 NWELL PWELL BULK DFF_X1
X$52691 \$I174533 \$22222 \$22467 \$21355 NWELL PWELL BULK DFF_X1
X$52698 \$I179074 \$21766 \$22466 \$21355 NWELL PWELL BULK DFF_X1
X$52700 \$I179036 \$22219 \$22455 \$21355 NWELL PWELL BULK DFF_X1
X$52702 \$I179294 \$26357 \$27214 \$21355 NWELL PWELL BULK DFF_X1
X$52704 \$I174532 \$26362 \$26359 \$21355 NWELL PWELL BULK DFF_X1
X$52707 \$I179105 \$25596 \$25328 \$21355 NWELL PWELL BULK DFF_X1
X$52710 \$I179104 \$25329 \$25330 \$21355 NWELL PWELL BULK DFF_X1
X$52712 \$I179068 \$24654 \$24652 \$21355 NWELL PWELL BULK DFF_X1
X$52714 \$I174639 \$24641 \$24646 \$21355 NWELL PWELL BULK DFF_X1
X$52716 \$I179016 \$22469 \$22476 \$21355 NWELL PWELL BULK DFF_X1
X$52719 \$22494 \$22228 \$22490 \$21355 NWELL PWELL BULK DFF_X1
X$52722 \$22024 \$22481 \$22018 \$21355 NWELL PWELL BULK DFF_X1
X$52724 \$I174522 \$22858 \$23413 \$21355 NWELL PWELL BULK DFF_X1
X$52752 \$32460 \$49855 \$21359 \$49857 \$33856 NWELL PWELL BULK AOI22_X4
X$52777 \$22060 \$21364 \$22054 \$21778 NWELL PWELL BULK DFF_X1
X$52784 M1_AXI_ARLEN[1] \$21365 NWELL PWELL BULK CLKBUF_X2
X$52795 \$21366 \$22869 \$23476 NWELL PWELL BULK NAND2_X1
X$52802 \$21366 \$22064 \$21367 NWELL PWELL BULK NAND2_X1
X$52805 \$21366 \$23171 \$23178 NWELL PWELL BULK NAND2_X1
X$52807 \$21366 \$23474 \$23068 NWELL PWELL BULK NAND2_X1
X$52809 \$21366 \$22235 \$23172 NWELL PWELL BULK NAND2_X1
X$52843 \$21381 \$21379 \$21384 \$21801 NWELL PWELL BULK OAI21_X1
X$52846 \$I176926 \$21379 \$21798 \$21417 NWELL PWELL BULK DFF_X1
X$52848 \$21802 \$21380 \$21379 \$22126 NWELL PWELL BULK NAND3_X1
X$52875 \$21383 \$21806 \$22145 NWELL PWELL BULK NAND2_X1
X$52878 \$22638 \$21394 \$21384 \$22633 NWELL PWELL BULK AOI21_X1
X$52884 \$23549 \$23551 \$21384 \$23191 NWELL PWELL BULK NAND3_X1
X$52886 \$22886 \$21384 \$21394 \$23190 \$23123 NWELL PWELL BULK OAI22_X1
X$52899 \$21389 \$22262 \$22894 \$21417 NWELL PWELL BULK DFF_X1
X$52907 \$22620 \$21417 \$22886 \$21394 NWELL PWELL BULK DFF_X2
X$52910 \$21394 \$22891 \$22643 NWELL PWELL BULK NOR2_X1
X$52931 \$22274 \$21400 \$23090 NWELL PWELL BULK NAND2_X1
X$52943 \$21404 \$21409 \$21839 \$22124 NWELL PWELL BULK OAI21_X1
X$52946 \$21832 \$21409 \$21839 \$21404 \$22157 NWELL PWELL BULK NAND4_X1
X$52949 \$21404 \$21413 \$23629 \$23612 NWELL PWELL BULK OAI21_X1
X$52966 \$21809 \$21697 \$22186 \$21409 NWELL PWELL BULK NAND3_X4
X$52971 \$21413 \$21832 \$21409 \$22149 NWELL PWELL BULK OAI21_X1
X$52974 \$21409 \$22761 \$22759 \$22294 NWELL PWELL BULK AOI21_X1
X$52976 \$21409 \$21839 \$21410 NWELL PWELL BULK NAND2_X1
X$52990 \$22761 \$21410 \$21683 \$22292 NWELL PWELL BULK OAI21_X1
X$52996 \$I174926 \$21411 \$21850 \$21417 NWELL PWELL BULK DFF_X1
X$52999 \$21832 \$21411 \$21416 NWELL PWELL BULK NAND2_X1
X$53006 \$21413 \$22125 \$21832 \$21836 NWELL PWELL BULK AOI21_X1
X$53012 \$22913 \$21417 \$22761 \$21413 NWELL PWELL BULK DFF_X2
X$53017 \$23629 \$23104 \$21413 \$24104 NWELL PWELL BULK NAND3_X1
X$53033 \$21832 \$21414 NWELL PWELL BULK INV_X1
X$53036 \$22292 \$22765 \$21414 \$22293 NWELL PWELL BULK NAND3_X1
X$53038 \$21679 \$21414 \$21848 \$21690 NWELL PWELL BULK OAI21_X1
X$53044 \$I177295 \$31510 \$31509 \$21417 NWELL PWELL BULK DFF_X1
X$53046 \$29987 \$30173 \$30055 \$21417 NWELL PWELL BULK DFF_X1
X$53049 \$31021 \$31367 \$31369 \$21417 NWELL PWELL BULK DFF_X1
X$53052 \$30934 \$31355 \$31348 \$21417 NWELL PWELL BULK DFF_X1
X$53055 \$29150 \$29548 \$29996 \$21417 NWELL PWELL BULK DFF_X1
X$53057 \$27798 \$29089 \$29144 \$21417 NWELL PWELL BULK DFF_X1
X$53059 \$29663 \$29647 \$29657 \$21417 NWELL PWELL BULK DFF_X1
X$53062 \$29728 \$30148 \$29950 \$21417 NWELL PWELL BULK DFF_X1
X$53064 \$28977 \$29643 \$28770 \$21417 NWELL PWELL BULK DFF_X1
X$53067 \$28771 \$28976 \$28978 \$21417 NWELL PWELL BULK DFF_X1
X$53069 \$I175676 \$24174 \$24784 \$21417 NWELL PWELL BULK DFF_X1
X$53077 \$I175437 \$23759 \$24172 \$21417 NWELL PWELL BULK DFF_X1
X$53080 \$24392 \$24034 \$24036 \$21417 NWELL PWELL BULK DFF_X1
X$53082 \$24462 \$24775 \$24774 \$21417 NWELL PWELL BULK DFF_X1
X$53088 \$I175088 \$30076 \$30289 \$21417 NWELL PWELL BULK DFF_X1
X$53091 \$I175038 \$30074 \$30075 \$21417 NWELL PWELL BULK DFF_X1
X$53097 \$I174691 \$22295 \$22296 \$21417 NWELL PWELL BULK DFF_X1
X$53099 \$23679 \$21417 \$I245574 \$23226 NWELL PWELL BULK DFF_X2
X$53101 \$23685 \$23686 \$24091 \$21417 NWELL PWELL BULK DFF_X1
X$53104 \$24966 \$21417 \$24499 \$21828 NWELL PWELL BULK DFF_X2
X$53109 \$24095 \$24877 \$24343 \$21417 NWELL PWELL BULK DFF_X1
X$53145 \$21418 \$21851 NWELL PWELL BULK INV_X1
X$53160 \$21638 \$21420 \$21626 \$21640 NWELL PWELL BULK DFF_X1
X$53166 \$I174341 \$21428 \$22070 \$21640 NWELL PWELL BULK DFF_X1
X$53174 \$I179066 \$21429 \$21609 \$21640 NWELL PWELL BULK DFF_X1
X$53235 \$22338 \$21883 \$21455 NWELL PWELL BULK NAND2_X1
X$53237 \$22607 \$21885 \$22617 \$21457 NWELL PWELL BULK HA_X1
X$53239 \$22338 \$21457 \$21458 NWELL PWELL BULK NAND2_X1
X$53241 \$22589 \$21458 \$21538 NWELL PWELL BULK XOR2_X1
X$53247 \$I176537 \$21892 \$21460 \$21461 NWELL PWELL BULK DFF_X1
X$53251 \$26502 \$26008 \$26679 \$21461 NWELL PWELL BULK DFF_X1
X$53254 \$26078 \$25465 \$26080 \$21461 NWELL PWELL BULK DFF_X1
X$53257 \$I176167 \$24548 \$24612 \$21461 NWELL PWELL BULK DFF_X1
X$53259 \$25097 \$21461 \$I245648 \$22346 NWELL PWELL BULK DFF_X2
X$53261 \$I179272 \$23404 \$23825 \$21461 NWELL PWELL BULK DFF_X1
X$53264 \$I178279 \$26012 \$26637 \$21461 NWELL PWELL BULK DFF_X1
X$53266 \$I175029 \$26063 \$26015 \$21461 NWELL PWELL BULK DFF_X1
X$53269 \$I176805 \$21898 \$22524 \$21461 NWELL PWELL BULK DFF_X1
X$53271 \$I177447 \$29237 \$29305 \$21461 NWELL PWELL BULK DFF_X1
X$53273 \$I174819 \$29762 \$29240 \$21461 NWELL PWELL BULK DFF_X1
X$53275 \$I177535 \$28067 \$27501 \$21461 NWELL PWELL BULK DFF_X1
X$53279 \$I179183 \$24628 \$24637 \$21461 NWELL PWELL BULK DFF_X1
X$53282 \$I174732 \$25458 \$26699 \$21461 NWELL PWELL BULK DFF_X1
X$53284 \$I178660 \$22954 \$23898 \$21461 NWELL PWELL BULK DFF_X1
X$53286 \$I178531 \$24243 \$25112 \$21461 NWELL PWELL BULK DFF_X1
X$53289 \$24546 \$21461 \$I245602 \$22959 NWELL PWELL BULK DFF_X2
X$53292 \$I178515 \$25024 \$25020 \$21461 NWELL PWELL BULK DFF_X1
X$53299 \$I174336 \$23420 \$23287 \$21461 NWELL PWELL BULK DFF_X1
X$53302 \$I177347 \$25025 \$26501 \$21461 NWELL PWELL BULK DFF_X1
X$53306 \$28050 \$27143 \$27502 \$21461 NWELL PWELL BULK DFF_X1
X$53309 \$I176852 \$31071 \$30825 \$21461 NWELL PWELL BULK DFF_X1
X$53311 \$32287 \$31545 \$31911 \$21461 NWELL PWELL BULK DFF_X1
X$53313 \$I178559 \$27898 \$27144 \$21461 NWELL PWELL BULK DFF_X1
X$53316 \$32189 \$31914 \$31917 \$21461 NWELL PWELL BULK DFF_X1
X$53344 \$22958 \$21462 \$I240996 \$25592 NWELL PWELL BULK HA_X1
X$53347 \$21462 \$24628 \$24634 NWELL PWELL BULK NAND2_X1
X$53349 \$21462 \$23420 \$23823 NWELL PWELL BULK NAND2_X1
X$53351 \$21462 \$22954 \$23437 NWELL PWELL BULK NAND2_X1
X$53353 \$21462 \$22341 \$22560 NWELL PWELL BULK NAND2_X1
X$53356 \$21462 \$21892 \$21891 NWELL PWELL BULK NAND2_X1
X$53359 \$21462 \$21890 NWELL PWELL BULK INV_X2
X$53423 S0_AXI_BID[0] \$21510 NWELL PWELL BULK BUF_X1
X$53474 \$21570 S1_AXI_AWID[0] NWELL PWELL BULK BUF_X1
X$53533 \$22784 \$22788 \$22783 \$21640 NWELL PWELL BULK DFF_X1
X$53536 \$22920 \$23695 \$23683 \$21640 NWELL PWELL BULK DFF_X1
X$53538 \$22925 \$22304 \$22078 \$21640 NWELL PWELL BULK DFF_X1
X$53541 \$22810 \$22809 \$22299 \$21640 NWELL PWELL BULK DFF_X1
X$53543 \$23707 \$23709 \$23241 \$21640 NWELL PWELL BULK DFF_X1
X$53546 \$24820 \$24210 \$24331 \$21640 NWELL PWELL BULK DFF_X1
X$53548 \$I178711 \$26976 \$26971 \$21640 NWELL PWELL BULK DFF_X1
X$53551 \$23789 \$24049 \$24054 \$21640 NWELL PWELL BULK DFF_X1
X$53553 \$26982 \$25800 \$25804 \$21640 NWELL PWELL BULK DFF_X1
X$53555 \$I175628 \$25197 \$25824 \$21640 NWELL PWELL BULK DFF_X1
X$53558 \$22806 \$22799 \$22798 \$21640 NWELL PWELL BULK DFF_X1
X$53561 \$24980 \$25180 \$25798 \$21640 NWELL PWELL BULK DFF_X1
X$53563 \$I175992 \$25947 \$26256 \$21640 NWELL PWELL BULK DFF_X1
X$53565 \$24061 \$24063 \$24066 \$21640 NWELL PWELL BULK DFF_X1
X$53568 \$24979 \$24207 \$24837 \$21640 NWELL PWELL BULK DFF_X1
X$53571 \$24057 \$23234 \$24073 \$21640 NWELL PWELL BULK DFF_X1
X$53574 \$I175730 \$24506 \$24851 \$21640 NWELL PWELL BULK DFF_X1
X$53576 \$24083 \$24334 \$24336 \$21640 NWELL PWELL BULK DFF_X1
X$53579 \$I179079 \$23055 \$22926 \$21640 NWELL PWELL BULK DFF_X1
X$53582 \$I178852 \$23248 \$23687 \$21640 NWELL PWELL BULK DFF_X1
X$53585 \$24516 \$24311 \$24312 \$21640 NWELL PWELL BULK DFF_X1
X$53587 \$23798 \$23053 \$22927 \$21640 NWELL PWELL BULK DFF_X1
X$53594 \$24782 \$24219 \$25165 \$21640 NWELL PWELL BULK DFF_X1
X$53598 \$22816 \$21858 \$22089 \$21640 NWELL PWELL BULK DFF_X1
X$53643 \$27835 \$21666 \$27642 \$27837 \$27426 NWELL PWELL BULK OAI22_X4
X$53690 \$25370 \$22186 \$21697 \$26294 NWELL PWELL BULK NAND3_X2
X$53694 \$21697 \$22186 \$25370 \$25917 NWELL PWELL BULK AND3_X1
X$53697 \$22707 \$21697 \$21827 \$22911 NWELL PWELL BULK AND3_X1
X$53714 \$30261 \$30262 \$30260 \$21698 NWELL PWELL BULK AND3_X4
X$53719 \$27074 \$21698 \$26397 NWELL PWELL BULK NOR2_X1
X$53726 \$27422 \$21698 \$28299 \$28755 NWELL PWELL BULK NOR3_X1
X$53745 \$21698 \$23624 \$24488 \$24487 NWELL PWELL BULK OR3_X1
X$53766 \$25901 \$25900 \$24940 \$21738 \$24448 \$26780 NWELL PWELL BULK
+ OAI221_X2
X$53768 \$26785 \$24448 \$21738 \$24940 \$25724 NWELL PWELL BULK OAI211_X2
X$53816 \$22211 \$21757 \$22844 \$23005 NWELL PWELL BULK MUX2_X1
X$53818 \$30223 \$21757 \$30224 \$31200 NWELL PWELL BULK MUX2_X1
X$53822 \$22209 \$21757 \$22206 \$22410 NWELL PWELL BULK MUX2_X1
X$53825 \$26362 \$21757 \$27222 \$26359 NWELL PWELL BULK MUX2_X1
X$53827 \$22219 \$21757 \$22217 \$22455 NWELL PWELL BULK MUX2_X1
X$53830 \$33880 \$33452 \$32526 \$21757 NWELL PWELL BULK NOR3_X4
X$53833 \$35151 \$21757 NWELL PWELL BULK BUF_X8
X$53835 \$28703 \$21757 \$28464 \$28943 NWELL PWELL BULK MUX2_X1
X$53837 \$26365 \$21757 \$25333 \$26363 NWELL PWELL BULK MUX2_X1
X$53839 \$21766 \$21757 \$21764 \$22466 NWELL PWELL BULK MUX2_X1
X$53841 \$24271 \$21757 NWELL PWELL BULK BUF_X8
X$53843 \$24912 \$21757 \$23936 \$25612 NWELL PWELL BULK MUX2_X1
X$53846 \$25596 \$21757 \$25324 \$25328 NWELL PWELL BULK MUX2_X1
X$53848 \$22215 \$21757 \$22445 \$22446 NWELL PWELL BULK MUX2_X1
X$53880 \$21761 \$22450 \$22437 \$22853 NWELL PWELL BULK MUX2_X1
X$53885 M1_AXI_AWADDR[26] \$21764 NWELL PWELL BULK BUF_X1
X$53887 \$21764 \$22207 \$22469 \$22476 NWELL PWELL BULK MUX2_X1
X$53890 \$22222 \$22838 \$21764 \$22467 NWELL PWELL BULK MUX2_X1
X$53892 \$21764 \$23136 \$22858 \$23413 NWELL PWELL BULK MUX2_X1
X$53903 \$21766 \$22450 \$22469 \$23944 NWELL PWELL BULK MUX2_X1
X$53912 M1_AXI_ARLEN[0] \$21771 NWELL PWELL BULK BUF_X1
X$53931 \$I175589 \$27390 \$28108 \$21778 NWELL PWELL BULK DFF_X1
X$53933 \$21780 \$22514 \$22518 \$21778 NWELL PWELL BULK DFF_X1
X$53936 \$23168 \$22528 \$22863 \$21778 NWELL PWELL BULK DFF_X1
X$53938 \$26379 \$26711 \$26702 \$21778 NWELL PWELL BULK DFF_X1
X$53941 \$26378 \$26694 \$26700 \$21778 NWELL PWELL BULK DFF_X1
X$53943 \$25314 \$21778 NWELL PWELL BULK BUF_X4
X$53945 \$28075 \$27053 \$27248 \$21778 NWELL PWELL BULK DFF_X1
X$53947 \$27387 \$27767 \$28088 \$21778 NWELL PWELL BULK DFF_X1
X$53950 \$25189 \$24436 \$24918 \$21778 NWELL PWELL BULK DFF_X1
X$53953 \$23985 \$23980 \$23978 \$21778 NWELL PWELL BULK DFF_X1
X$53955 \$26680 \$26676 \$26368 \$21778 NWELL PWELL BULK DFF_X1
X$53958 \$26370 \$26159 \$26155 \$21778 NWELL PWELL BULK DFF_X1
X$53960 \$25876 \$26686 \$26374 \$21778 NWELL PWELL BULK DFF_X1
X$53962 \$24438 \$26176 \$25344 \$21778 NWELL PWELL BULK DFF_X1
X$53964 \$25179 \$24434 \$25176 \$21778 NWELL PWELL BULK DFF_X1
X$53967 \$24435 \$24365 \$24156 \$21778 NWELL PWELL BULK DFF_X1
X$53970 \$25875 \$26688 \$25341 \$21778 NWELL PWELL BULK DFF_X1
X$53972 \$23452 \$23457 \$23164 \$21778 NWELL PWELL BULK DFF_X1
X$53975 \$24431 \$25643 \$24690 \$21778 NWELL PWELL BULK DFF_X1
X$53977 \$30510 \$21778 \$I245578 \$30042 NWELL PWELL BULK DFF_X2
X$53979 \$29437 \$28999 \$29428 \$21778 NWELL PWELL BULK DFF_X1
X$53981 \$29127 \$21778 \$I245622 \$26692 NWELL PWELL BULK DFF_X2
X$53983 \$27764 \$27384 \$27655 \$21778 NWELL PWELL BULK DFF_X1
X$53986 \$29124 \$21778 \$I245728 \$29126 NWELL PWELL BULK DFF_X2
X$53989 \$I176878 \$29128 \$29127 \$21778 NWELL PWELL BULK DFF_X1
X$53991 \$I178973 \$27389 \$27769 \$21778 NWELL PWELL BULK DFF_X1
X$53994 \$29438 \$29922 \$29919 \$21778 NWELL PWELL BULK DFF_X1
X$53997 \$30044 \$21778 \$I245612 \$31268 NWELL PWELL BULK DFF_X2
X$53999 \$I176879 \$30244 \$30044 \$21778 NWELL PWELL BULK DFF_X1
X$54001 \$28083 \$28082 \$28071 \$21778 NWELL PWELL BULK DFF_X1
X$54036 \$21785 \$24719 \$24730 NWELL PWELL BULK XNOR2_X2
X$54106 \$21828 \$23782 \$23629 NWELL PWELL BULK NAND2_X1
X$54110 \$22295 \$21828 \$23086 NWELL PWELL BULK NAND2_X1
X$54112 \$21828 \$22295 \$21831 NWELL PWELL BULK AND2_X1
X$54114 \$21828 \$22707 NWELL PWELL BULK INV_X1
X$54118 \$25809 \$21828 \$24498 NWELL PWELL BULK NAND2_X1
X$54123 \$21828 \$24198 \$23783 \$24203 NWELL PWELL BULK AOI21_X1
X$54126 \$21828 \$24874 \$24499 \$24885 NWELL PWELL BULK OAI21_X1
X$54151 \$21841 \$21832 \$22759 NWELL PWELL BULK NAND2_X1
X$54160 \$22902 \$23210 \$21839 NWELL PWELL BULK NAND2_X1
X$54178 \$21843 \$22124 \$22289 NWELL PWELL BULK NAND2_X1
X$54189 \$26438 \$21851 \$25797 \$25937 \$28607 NWELL PWELL BULK AOI22_X2
X$54248 \$23274 \$21885 \$22615 NWELL PWELL BULK NAND2_X1
X$54250 \$22338 \$21885 \$22950 NWELL PWELL BULK NAND2_X1
X$54256 \$21890 \$21889 \$22342 NWELL PWELL BULK NAND2_X1
X$54260 \$22961 \$21890 \$26010 \$I241506 NWELL PWELL BULK HA_X1
X$54262 \$21890 \$23282 \$23283 NWELL PWELL BULK NAND2_X1
X$54267 \$21890 \$23888 \$24273 NWELL PWELL BULK NAND2_X1
X$54269 \$21890 \$24243 \$24245 NWELL PWELL BULK NAND2_X1
X$54271 \$21890 \$22954 \$23428 NWELL PWELL BULK NAND2_X1
X$54273 \$21890 \$22341 \$22548 NWELL PWELL BULK NAND2_X1
X$54284 \$22346 \$21892 \$21893 NWELL PWELL BULK XNOR2_X2
X$54291 \$25024 \$24628 \$21894 NWELL PWELL BULK XNOR2_X2
X$54295 \$22959 \$23420 \$21895 NWELL PWELL BULK XNOR2_X2
X$54308 \$26021 \$24254 \$24248 \$21904 NWELL PWELL BULK AND3_X2
X$54328 \$26020 \$24254 \$24552 \$21907 NWELL PWELL BULK NOR3_X4
X$54342 \$21909 \$22366 \$22397 \$23327 NWELL PWELL BULK MUX2_X1
X$54352 \$22390 \$22366 \$21912 \$22973 NWELL PWELL BULK MUX2_X1
X$54397 \$21952 S1_AXI_ARLEN[2] NWELL PWELL BULK BUF_X1
X$54422 S0_AXI_BID[5] \$21966 NWELL PWELL BULK BUF_X1
X$54452 \$21982 S1_AXI_AWADDR[4] NWELL PWELL BULK BUF_X1
X$54461 \$I178830 \$29392 \$29220 \$21994 NWELL PWELL BULK DFF_X1
X$54464 \$I178487 \$27882 \$28210 \$21994 NWELL PWELL BULK DFF_X1
X$54467 \$I179133 \$28797 \$28884 \$21994 NWELL PWELL BULK DFF_X1
X$54469 \$I175230 \$29216 \$29858 \$21994 NWELL PWELL BULK DFF_X1
X$54471 \$I178492 \$27881 \$28888 \$21994 NWELL PWELL BULK DFF_X1
X$54474 \$I178824 \$27886 \$27490 \$21994 NWELL PWELL BULK DFF_X1
X$54477 \$I178827 \$29219 \$29402 \$21994 NWELL PWELL BULK DFF_X1
X$54480 \$I175200 \$27884 \$27883 \$21994 NWELL PWELL BULK DFF_X1
X$54483 \$I178823 \$27885 \$28175 \$21994 NWELL PWELL BULK DFF_X1
X$54486 \$I175327 \$23529 \$22335 \$21994 NWELL PWELL BULK DFF_X1
X$54489 \$I178562 \$23572 \$23265 \$21994 NWELL PWELL BULK DFF_X1
X$54491 \$I178523 \$22945 \$23558 \$21994 NWELL PWELL BULK DFF_X1
X$54493 \$I175723 \$23501 \$23506 \$21994 NWELL PWELL BULK DFF_X1
X$54495 \$I174963 \$22947 \$23269 \$21994 NWELL PWELL BULK DFF_X1
X$54499 \$26493 \$21994 \$I245672 \$24126 NWELL PWELL BULK DFF_X2
X$54501 \$I177519 \$25005 \$25130 \$21994 NWELL PWELL BULK DFF_X1
X$54504 \$I176077 \$23921 \$24238 \$21994 NWELL PWELL BULK DFF_X1
X$54507 \$I175752 \$26119 \$26122 \$21994 NWELL PWELL BULK DFF_X1
X$54510 \$I176461 \$23947 \$24231 \$21994 NWELL PWELL BULK DFF_X1
X$54512 \$I174938 \$23933 \$24695 \$21994 NWELL PWELL BULK DFF_X1
X$54514 \$I179152 \$26489 \$26795 \$21994 NWELL PWELL BULK DFF_X1
X$54516 \$I179203 \$30812 \$30810 \$21994 NWELL PWELL BULK DFF_X1
X$54518 \$I175795 \$26492 \$26774 \$21994 NWELL PWELL BULK DFF_X1
X$54521 \$I177102 \$25992 \$26112 \$21994 NWELL PWELL BULK DFF_X1
X$54524 \$I176780 \$25665 \$25141 \$21994 NWELL PWELL BULK DFF_X1
X$54526 \$I175351 \$25004 \$25986 \$21994 NWELL PWELL BULK DFF_X1
X$54529 \$I176270 \$25985 \$25984 \$21994 NWELL PWELL BULK DFF_X1
X$54532 \$I177098 \$24533 \$25134 \$21994 NWELL PWELL BULK DFF_X1
X$54724 \$24053 \$22192 \$23766 \$23765 NWELL PWELL BULK AOI21_X1
X$54737 M1_AXI_AWADDR[0] \$22206 NWELL PWELL BULK BUF_X1
X$54740 \$22206 \$23136 \$23338 \$23343 NWELL PWELL BULK MUX2_X1
X$54742 \$22994 \$22838 \$22206 \$22839 NWELL PWELL BULK MUX2_X1
X$54744 \$22206 \$22207 \$22399 \$22407 NWELL PWELL BULK MUX2_X1
X$54750 \$33452 \$33083 \$32528 \$22207 NWELL PWELL BULK NAND3_X4
X$54755 \$28446 \$22207 \$28573 \$28842 NWELL PWELL BULK MUX2_X1
X$54757 \$22844 \$22207 \$22846 \$23008 NWELL PWELL BULK MUX2_X1
X$54760 \$49819 \$22207 \$49937 \$49933 NWELL PWELL BULK MUX2_X1
X$54762 \$51270 \$22207 \$52620 \$52065 NWELL PWELL BULK MUX2_X1
X$54765 \$52849 \$22207 \$54173 \$53983 NWELL PWELL BULK MUX2_X1
X$54768 \$28464 \$22207 \$28467 \$27757 NWELL PWELL BULK MUX2_X1
X$54771 \$24904 \$22207 \$26347 \$26345 NWELL PWELL BULK MUX2_X1
X$54773 \$45365 \$22207 \$47850 \$47851 NWELL PWELL BULK MUX2_X1
X$54776 \$52071 \$22207 \$53867 \$53157 NWELL PWELL BULK MUX2_X1
X$54780 \$50552 \$22207 \$52090 \$52318 NWELL PWELL BULK MUX2_X1
X$54782 \$27964 \$22207 \$27968 \$27966 NWELL PWELL BULK MUX2_X1
X$54784 \$53166 \$22207 \$54327 \$54317 NWELL PWELL BULK MUX2_X1
X$54786 \$50755 \$22207 \$52365 \$51591 NWELL PWELL BULK MUX2_X1
X$54791 \$25324 \$22207 \$25329 \$25330 NWELL PWELL BULK MUX2_X1
X$54794 \$25311 \$22207 \$24412 \$24144 NWELL PWELL BULK MUX2_X1
X$54797 \$22985 \$22207 \$22986 \$22837 NWELL PWELL BULK MUX2_X1
X$54800 \$45262 \$22207 \$47067 \$46062 NWELL PWELL BULK MUX2_X1
X$54803 \$35194 \$22207 \$35836 \$35665 NWELL PWELL BULK MUX2_X1
X$54806 \$33814 \$22207 \$34577 \$34885 NWELL PWELL BULK MUX2_X1
X$54809 \$52862 \$22207 \$54345 \$54342 NWELL PWELL BULK MUX2_X1
X$54812 \$50163 \$22207 \$51527 \$51309 NWELL PWELL BULK MUX2_X1
X$54814 \$51308 \$22207 \$53083 \$52871 NWELL PWELL BULK MUX2_X1
X$54816 \$48219 \$22207 \$49424 \$49154 NWELL PWELL BULK MUX2_X1
X$54819 \$49569 \$22207 \$50490 \$50488 NWELL PWELL BULK MUX2_X1
X$54821 \$51336 \$22207 \$52469 \$52466 NWELL PWELL BULK MUX2_X1
X$54823 \$44162 \$22207 \$45553 \$45537 NWELL PWELL BULK MUX2_X1
X$54825 \$27752 \$22207 \$27211 \$26352 NWELL PWELL BULK MUX2_X1
X$54828 \$27749 \$22207 \$28014 \$28015 NWELL PWELL BULK MUX2_X1
X$54830 \$30971 \$22207 \$30744 \$30743 NWELL PWELL BULK MUX2_X1
X$54833 \$25318 \$22207 \$26584 \$26579 NWELL PWELL BULK MUX2_X1
X$54835 \$24418 \$22207 \$23882 \$24606 NWELL PWELL BULK MUX2_X1
X$54837 \$36494 \$22207 \$36496 \$36493 NWELL PWELL BULK MUX2_X1
X$54840 \$34692 \$22207 \$34865 \$34863 NWELL PWELL BULK MUX2_X1
X$54842 \$27741 \$22207 \$27369 \$28002 NWELL PWELL BULK MUX2_X1
X$54844 \$29677 \$22207 \$29321 \$29310 NWELL PWELL BULK MUX2_X1
X$54846 \$29329 \$22207 \$30430 \$30428 NWELL PWELL BULK MUX2_X1
X$54849 \$27222 \$22207 \$27047 \$27046 NWELL PWELL BULK MUX2_X1
X$54851 \$23936 \$22207 \$24425 \$24151 NWELL PWELL BULK MUX2_X1
X$54854 \$25333 \$22207 \$27236 \$27381 NWELL PWELL BULK MUX2_X1
X$54856 \$39388 \$22207 \$42418 \$42414 NWELL PWELL BULK MUX2_X1
X$54859 \$30224 \$22207 \$31202 \$31657 NWELL PWELL BULK MUX2_X1
X$54862 \$22217 \$22207 \$22220 \$22462 NWELL PWELL BULK MUX2_X1
X$54867 \$22445 \$22207 \$22452 \$22442 NWELL PWELL BULK MUX2_X1
X$54869 \$25323 \$22207 \$26101 \$25570 NWELL PWELL BULK MUX2_X1
X$54886 \$41129 \$22207 \$46175 \$46016 NWELL PWELL BULK MUX2_X1
X$54947 \$50178 \$22207 \$50470 \$50471 NWELL PWELL BULK MUX2_X1
X$54956 \$22208 \$22841 \$22413 \$23002 NWELL PWELL BULK MUX2_X1
X$54963 \$22211 \$22841 \$22846 \$22847 NWELL PWELL BULK MUX2_X1
X$54970 \$22215 \$22450 \$22452 \$22856 NWELL PWELL BULK MUX2_X1
X$54974 M1_AXI_AWADDR[25] \$22217 NWELL PWELL BULK BUF_X1
X$54977 \$23400 \$22838 \$22217 \$23394 NWELL PWELL BULK MUX2_X1
X$54980 \$22217 \$23136 \$24641 \$24646 NWELL PWELL BULK MUX2_X1
X$54988 \$22219 \$22450 \$22220 \$23149 NWELL PWELL BULK MUX2_X1
X$55000 \$22222 \$22450 \$22858 \$23941 NWELL PWELL BULK MUX2_X1
X$55005 M1_AXI_ARLEN[5] \$22226 NWELL PWELL BULK CLKBUF_X2
X$55030 M0_AXI_ARLEN[4] \$22240 NWELL PWELL BULK BUF_X2
X$55055 \$27429 \$23169 \$22248 \$27430 \$29055 NWELL PWELL BULK OAI22_X1
X$55074 \$22250 \$27103 NWELL PWELL BULK INV_X1
X$55094 \$23191 \$22257 \$23758 NWELL PWELL BULK AND2_X1
X$55096 \$24480 \$25380 \$25379 \$22260 NWELL PWELL BULK AOI21_X2
X$55100 \$22260 \$25364 \$25739 NWELL PWELL BULK NAND2_X1
X$55121 \$22291 \$22755 \$22298 NWELL PWELL BULK NOR2_X2
X$55129 \$22294 \$22765 \$23226 \$23230 \$23074 NWELL PWELL BULK AOI22_X1
X$55133 \$22746 \$22765 \$22295 \$23230 \$22770 NWELL PWELL BULK AOI22_X1
X$55157 \$22301 \$26945 NWELL PWELL BULK INV_X1
X$55244 \$22338 \$22607 \$23021 NWELL PWELL BULK NAND2_X1
X$55246 \$23274 \$22338 NWELL PWELL BULK INV_X4
X$55249 \$22338 \$24240 \$I241005 \$26732 NWELL PWELL BULK HA_X1
X$55253 \$22338 \$22617 \$22621 NWELL PWELL BULK NAND2_X1
X$55256 \$22338 \$22589 \$22951 NWELL PWELL BULK NAND2_X1
X$55269 \$22341 \$22954 \$23282 \$23888 NWELL PWELL BULK HA_X1
X$55285 \$22961 \$22346 \$25099 NWELL PWELL BULK NAND2_X1
X$55307 S0_AXI_BID[1] \$22356 NWELL PWELL BULK BUF_X1
X$55317 \$23827 \$22366 \$22360 \$24256 NWELL PWELL BULK MUX2_X1
X$55325 \$27911 \$22366 \$27516 \$27912 NWELL PWELL BULK MUX2_X1
X$55328 \$26026 \$22366 \$25481 \$26027 NWELL PWELL BULK MUX2_X1
X$55330 \$22970 \$22366 \$23854 \$23328 NWELL PWELL BULK MUX2_X1
X$55333 \$25483 \$22366 \$26032 \$26511 NWELL PWELL BULK MUX2_X1
X$55336 \$24558 \$22366 \$25043 \$25502 NWELL PWELL BULK MUX2_X1
X$55339 \$24565 \$22366 \$24562 \$25047 NWELL PWELL BULK MUX2_X1
X$55341 \$25040 \$22366 \$25041 \$25540 NWELL PWELL BULK MUX2_X1
X$55346 \$23300 \$22366 \$23302 \$23829 NWELL PWELL BULK MUX2_X1
X$55348 \$28011 \$24557 \$I245693 \$22366 NWELL PWELL BULK DFF_X2
X$55351 \$27969 \$22366 \$27527 \$27910 NWELL PWELL BULK MUX2_X1
X$55377 \$27780 \$22379 NWELL PWELL BULK INV_X2
X$55382 \$22379 \$27922 \$24450 NWELL PWELL BULK NAND2_X4
X$55385 \$22379 M2_AXI_ARREADY NWELL PWELL BULK BUF_X1
X$55424 M1_AXI_AWADDR[23] \$22435 NWELL PWELL BULK BUF_X1
X$55430 \$22435 \$23136 \$23382 \$23906 NWELL PWELL BULK MUX2_X1
X$55432 \$22851 \$22838 \$22435 \$23014 NWELL PWELL BULK MUX2_X1
X$55447 M1_AXI_AWADDR[28] \$22445 NWELL PWELL BULK BUF_X1
X$55454 \$23728 \$22838 \$22445 \$23389 NWELL PWELL BULK MUX2_X1
X$55457 \$22445 \$23136 \$23919 \$23727 NWELL PWELL BULK MUX2_X1
X$55467 \$22851 \$22450 \$23382 \$23380 NWELL PWELL BULK MUX2_X1
X$55474 \$30220 \$22450 \$29117 \$29687 NWELL PWELL BULK MUX2_X1
X$55476 \$23728 \$22450 \$23919 \$23920 NWELL PWELL BULK MUX2_X1
X$55479 \$24654 \$22450 \$23935 \$24663 NWELL PWELL BULK MUX2_X1
X$55481 \$23400 \$22450 \$24641 \$23931 NWELL PWELL BULK MUX2_X1
X$55484 \$26365 \$22450 \$27236 \$27049 NWELL PWELL BULK MUX2_X1
X$55487 \$36585 \$30047 \$I245547 \$22450 NWELL PWELL BULK DFF_X2
X$55489 \$22450 \$36976 NWELL PWELL BULK BUF_X16
X$55491 \$22450 \$22841 NWELL PWELL BULK BUF_X16
X$55493 \$26362 \$22450 \$27047 \$27376 NWELL PWELL BULK MUX2_X1
X$55496 \$25334 \$22450 \$25869 \$27238 NWELL PWELL BULK MUX2_X1
X$55498 \$24912 \$22450 \$24425 \$24665 NWELL PWELL BULK MUX2_X1
X$55501 \$28703 \$22450 \$28467 \$28704 NWELL PWELL BULK MUX2_X1
X$55503 \$30223 \$22450 \$31202 \$31204 NWELL PWELL BULK MUX2_X1
X$55505 \$30487 \$22450 \$30990 \$31205 NWELL PWELL BULK MUX2_X1
X$55618 \$27429 \$22527 \$27430 \$24875 \$28262 NWELL PWELL BULK OAI22_X1
X$55699 \$22594 \$23187 \$23186 \$23118 NWELL PWELL BULK MUX2_X1
X$55706 \$23274 \$22607 \$22642 NWELL PWELL BULK NAND2_X1
X$55715 \$23532 \$23187 \$22611 \$23188 NWELL PWELL BULK MUX2_X1
X$55758 \$22648 S2_AXI_ARLEN[2] NWELL PWELL BULK BUF_X1
X$55784 \$24085 \$23205 \$23579 \$22691 \$23774 NWELL PWELL BULK AOI211_X2
X$55806 \$23224 \$22707 \$23643 \$22755 NWELL PWELL BULK OAI21_X4
X$55862 \$24203 \$24205 \$22765 NWELL PWELL BULK AND2_X1
X$55924 \$22830 \$27297 NWELL PWELL BULK INV_X1
X$55937 M1_AXI_AWBURST[0] \$22985 NWELL PWELL BULK BUF_X1
X$55946 \$22836 S1_AXI_AWADDR[8] NWELL PWELL BULK BUF_X1
X$55956 \$30487 \$22838 \$30224 \$30484 NWELL PWELL BULK MUX2_X1
X$55960 \$26357 \$22838 \$27222 \$27214 NWELL PWELL BULK MUX2_X1
X$55962 \$24910 \$22838 \$25324 \$25325 NWELL PWELL BULK MUX2_X1
X$55964 \$25558 \$22838 \$25318 \$24902 NWELL PWELL BULK MUX2_X1
X$55967 \$25119 \$22838 \$24904 \$24621 NWELL PWELL BULK MUX2_X1
X$55971 \$24654 \$22838 \$23936 \$24652 NWELL PWELL BULK MUX2_X1
X$55976 \$23129 \$22838 \$22985 \$23319 NWELL PWELL BULK MUX2_X1
X$55978 \$22838 \$33344 NWELL PWELL BULK BUF_X8
X$55980 \$22838 \$34679 NWELL PWELL BULK BUF_X16
X$55983 \$27745 \$22838 NWELL PWELL BULK BUF_X8
X$55985 \$24589 \$22838 \$24418 \$24146 NWELL PWELL BULK MUX2_X1
X$55987 \$25500 \$22838 \$25311 \$24402 NWELL PWELL BULK MUX2_X1
X$55989 \$25334 \$22838 \$25333 \$25624 NWELL PWELL BULK MUX2_X1
X$55991 \$30220 \$22838 \$28464 \$30190 NWELL PWELL BULK MUX2_X1
X$55995 \$23139 \$22838 \$22844 \$23359 NWELL PWELL BULK MUX2_X1
X$56025 \$28455 \$22841 \$28457 \$28699 NWELL PWELL BULK MUX2_X1
X$56027 \$27743 \$22841 \$27369 \$28892 NWELL PWELL BULK MUX2_X1
X$56030 \$27739 \$22841 \$27368 \$28589 NWELL PWELL BULK MUX2_X1
X$56033 \$27747 \$22841 \$28014 \$28906 NWELL PWELL BULK MUX2_X1
X$56035 \$31467 \$22841 \$31715 \$31894 NWELL PWELL BULK MUX2_X1
X$56037 \$37437 \$22841 \$37438 \$37604 NWELL PWELL BULK MUX2_X1
X$56040 \$25119 \$22841 \$24906 \$26095 NWELL PWELL BULK MUX2_X1
X$56042 \$24603 \$22841 \$24414 \$24415 NWELL PWELL BULK MUX2_X1
X$56044 \$27974 \$22841 \$27737 \$27736 NWELL PWELL BULK MUX2_X1
X$56048 \$26357 \$22841 \$26360 \$26361 NWELL PWELL BULK MUX2_X1
X$56051 \$25596 \$22841 \$25329 \$26114 NWELL PWELL BULK MUX2_X1
X$56054 \$24910 \$22841 \$25138 \$25597 NWELL PWELL BULK MUX2_X1
X$56056 \$37219 \$22841 \$36496 \$36708 NWELL PWELL BULK MUX2_X1
X$56059 \$33389 \$22841 \$34577 \$34900 NWELL PWELL BULK MUX2_X1
X$56061 \$34008 \$22841 \$34696 \$34576 NWELL PWELL BULK MUX2_X1
X$56063 \$28684 \$22841 \$29797 \$29799 NWELL PWELL BULK MUX2_X1
X$56065 \$28837 \$22841 \$29276 \$28691 NWELL PWELL BULK MUX2_X1
X$56067 \$29306 \$22841 \$29301 \$29302 NWELL PWELL BULK MUX2_X1
X$56069 \$27372 \$22841 \$27211 \$28025 NWELL PWELL BULK MUX2_X1
X$56071 \$29343 \$22841 \$28698 \$29350 NWELL PWELL BULK MUX2_X1
X$56074 \$30741 \$22841 \$30205 \$30407 NWELL PWELL BULK MUX2_X1
X$56076 \$30023 \$22841 \$30411 \$30144 NWELL PWELL BULK MUX2_X1
X$56079 \$24408 \$22841 \$24585 \$24409 NWELL PWELL BULK MUX2_X1
X$56081 \$23133 \$22841 \$23135 \$23866 NWELL PWELL BULK MUX2_X1
X$56083 \$23347 \$22841 \$23344 \$23138 NWELL PWELL BULK MUX2_X1
X$56085 \$23127 \$22841 \$23128 \$23861 NWELL PWELL BULK MUX2_X1
X$56087 \$25503 \$22841 \$24893 \$25519 NWELL PWELL BULK MUX2_X1
X$56089 \$24420 \$22841 \$24614 \$24900 NWELL PWELL BULK MUX2_X1
X$56091 \$36230 \$22841 \$36025 \$36490 NWELL PWELL BULK MUX2_X1
X$56093 \$37209 \$22841 \$36489 \$37215 NWELL PWELL BULK MUX2_X1
X$56095 \$35328 \$22841 \$36206 \$35337 NWELL PWELL BULK MUX2_X1
X$56097 \$33983 \$22841 \$34387 \$34388 NWELL PWELL BULK MUX2_X1
X$56100 \$30210 \$22841 \$30430 \$30432 NWELL PWELL BULK MUX2_X1
X$56102 \$28695 \$22841 \$29105 \$29334 NWELL PWELL BULK MUX2_X1
X$56105 \$30972 \$22841 \$30744 \$31604 NWELL PWELL BULK MUX2_X1
X$56109 \$26605 \$22841 \$26347 \$25857 NWELL PWELL BULK MUX2_X1
X$56111 \$24908 \$22841 \$26101 \$25860 NWELL PWELL BULK MUX2_X1
X$56113 \$25859 \$22841 \$26350 \$26621 NWELL PWELL BULK MUX2_X1
X$56115 \$23139 \$22841 \$23140 \$23368 NWELL PWELL BULK MUX2_X1
X$56117 \$25851 \$22841 \$25852 \$26587 NWELL PWELL BULK MUX2_X1
X$56120 \$25321 \$22841 \$26079 \$25853 NWELL PWELL BULK MUX2_X1
X$56173 M1_AXI_AWADDR[20] \$22844 NWELL PWELL BULK BUF_X1
X$56182 \$22844 \$23136 \$23140 \$23890 NWELL PWELL BULK MUX2_X1
X$56194 \$23368 \$22847 \$23141 \$23142 NWELL PWELL BULK MUX2_X2
X$56202 \$23380 \$22853 \$23141 \$23395 NWELL PWELL BULK MUX2_X2
X$56205 \$23920 \$22856 \$23141 \$25327 NWELL PWELL BULK MUX2_X2
X$56224 \$22876 \$23750 \$24389 NWELL PWELL BULK XNOR2_X2
X$56244 \$23561 \$23565 \$23112 \$22894 NWELL PWELL BULK AOI21_X1
X$56246 \$23776 \$22895 \$24180 \$24375 NWELL PWELL BULK OAI21_X1
X$56257 \$27089 \$22902 \$27678 NWELL PWELL BULK NAND2_X2
X$56340 \$22958 \$26502 \$26670 NWELL PWELL BULK NAND2_X1
X$56344 \$22958 \$26008 \$25588 NWELL PWELL BULK NAND2_X1
X$56348 \$22961 \$22958 NWELL PWELL BULK INV_X4
X$56350 \$22958 \$26083 \$26007 NWELL PWELL BULK NAND2_X1
X$56353 \$22958 \$26086 \$26088 NWELL PWELL BULK NAND2_X1
X$56356 \$22958 \$25025 \$25100 NWELL PWELL BULK NAND2_X1
X$56361 \$22958 \$25458 \$25021 NWELL PWELL BULK NAND2_X1
X$56375 \$22959 \$23291 NWELL PWELL BULK INV_X2
X$56380 \$22961 \$22959 \$24625 NWELL PWELL BULK NAND2_X1
X$56385 \$25482 \$26545 \$22961 NWELL PWELL BULK NAND2_X4
X$56397 \$22961 \$26008 \$26673 NWELL PWELL BULK NAND2_X1
X$56400 \$22961 \$25025 \$26087 NWELL PWELL BULK NAND2_X1
X$56403 \$22961 \$25024 \$25023 NWELL PWELL BULK NAND2_X1
X$56427 \$22973 \$23846 \$23829 \$25485 NWELL PWELL BULK MUX2_X1
X$56440 \$26021 \$24254 \$24552 \$22983 NWELL PWELL BULK NOR3_X4
X$56453 \$23849 \$24271 \$22985 \$23322 NWELL PWELL BULK MUX2_X1
X$56456 \$22985 \$23136 \$23841 \$23838 NWELL PWELL BULK MUX2_X1
X$56491 \$23138 \$23002 \$23141 \$23356 NWELL PWELL BULK MUX2_X2
X$56504 \$23274 \$23019 \$23280 NWELL PWELL BULK NAND2_X1
X$56507 \$23019 \$23900 \$23819 NWELL PWELL BULK XNOR2_X1
X$56595 \$23112 \$24466 \$23764 \$24784 NWELL PWELL BULK OAI21_X1
X$56597 \$24046 \$23112 \$23758 \$24172 NWELL PWELL BULK AOI21_X1
X$56608 \$23193 \$23116 \$23565 NWELL PWELL BULK AND2_X1
X$56621 M0_AXI_AWADDR[0] \$23719 NWELL PWELL BULK BUF_X1
X$56639 \$23134 S1_AXI_AWADDR[15] NWELL PWELL BULK BUF_X1
X$56645 \$33452 \$33880 \$32528 \$23136 NWELL PWELL BULK NAND3_X4
X$56647 \$25323 \$23136 \$26350 \$27203 NWELL PWELL BULK MUX2_X1
X$56650 \$27749 \$23136 \$28698 \$28898 NWELL PWELL BULK MUX2_X1
X$56653 \$44162 \$23136 \$44174 \$44166 NWELL PWELL BULK MUX2_X1
X$56656 \$50755 \$23136 \$51094 \$50846 NWELL PWELL BULK MUX2_X1
X$56658 \$51270 \$23136 \$52063 \$52061 NWELL PWELL BULK MUX2_X1
X$56660 \$30224 \$23136 \$30990 \$30931 NWELL PWELL BULK MUX2_X1
X$56662 \$52849 \$23136 \$53817 \$53813 NWELL PWELL BULK MUX2_X1
X$56664 \$49819 \$23136 \$50959 \$50951 NWELL PWELL BULK MUX2_X1
X$56666 \$45365 \$23136 \$48727 \$48168 NWELL PWELL BULK MUX2_X1
X$56668 \$27222 \$23136 \$26360 \$27374 NWELL PWELL BULK MUX2_X1
X$56670 \$28464 \$23136 \$29117 \$29115 NWELL PWELL BULK MUX2_X1
X$56675 \$24904 \$23136 \$24906 \$24905 NWELL PWELL BULK MUX2_X1
X$56677 \$50552 \$23136 \$50842 \$50730 NWELL PWELL BULK MUX2_X1
X$56679 \$50163 \$23136 \$50168 \$50169 NWELL PWELL BULK MUX2_X1
X$56682 \$25318 \$23136 \$25557 \$26073 NWELL PWELL BULK MUX2_X1
X$56684 \$24418 \$23136 \$24899 \$25090 NWELL PWELL BULK MUX2_X1
X$56686 \$50178 \$23136 \$50794 \$50790 NWELL PWELL BULK MUX2_X1
X$56689 \$27741 \$23136 \$27368 \$27190 NWELL PWELL BULK MUX2_X1
X$56691 \$23936 \$23136 \$23935 \$23731 NWELL PWELL BULK MUX2_X1
X$56693 \$51308 \$23136 \$51901 \$51598 NWELL PWELL BULK MUX2_X1
X$56695 \$28446 \$23136 \$29779 \$29780 NWELL PWELL BULK MUX2_X1
X$56697 \$53166 \$23136 \$54307 \$54309 NWELL PWELL BULK MUX2_X1
X$56699 \$25333 \$23136 \$25869 \$25866 NWELL PWELL BULK MUX2_X1
X$56703 \$49569 \$23136 \$50883 \$51181 NWELL PWELL BULK MUX2_X1
X$56706 \$33814 \$23136 \$34696 \$34694 NWELL PWELL BULK MUX2_X1
X$56709 \$34692 \$23136 \$36020 \$36202 NWELL PWELL BULK MUX2_X1
X$56712 \$51336 \$23136 \$51489 \$52008 NWELL PWELL BULK MUX2_X1
X$56714 \$52862 \$23136 \$54333 \$54335 NWELL PWELL BULK MUX2_X1
X$56718 \$41129 \$23136 \$44877 \$45037 NWELL PWELL BULK MUX2_X1
X$56720 \$52071 \$23136 \$53390 \$53161 NWELL PWELL BULK MUX2_X1
X$56722 \$48219 \$23136 \$48971 \$48539 NWELL PWELL BULK MUX2_X1
X$56724 \$45262 \$23136 \$45264 \$45575 NWELL PWELL BULK MUX2_X1
X$56726 \$27964 \$23136 \$28858 \$28850 NWELL PWELL BULK MUX2_X1
X$56728 \$29677 \$23136 \$30400 \$30139 NWELL PWELL BULK MUX2_X1
X$56731 \$30971 \$23136 \$31715 \$32084 NWELL PWELL BULK MUX2_X1
X$56734 \$27752 \$23136 \$28457 \$29351 NWELL PWELL BULK MUX2_X1
X$56737 \$25311 \$23136 \$25061 \$24570 NWELL PWELL BULK MUX2_X1
X$56739 \$35194 \$23136 \$36488 \$36678 NWELL PWELL BULK MUX2_X1
X$56742 \$29329 \$23136 \$29105 \$29104 NWELL PWELL BULK MUX2_X1
X$56744 \$36494 \$23136 \$37438 \$37223 NWELL PWELL BULK MUX2_X1
X$56746 \$39388 \$23136 \$41739 \$42082 NWELL PWELL BULK MUX2_X1
X$56754 \$25324 \$23136 \$25138 \$24643 NWELL PWELL BULK MUX2_X1
X$56861 \$29350 \$28906 \$23141 \$28915 NWELL PWELL BULK MUX2_X2
X$56864 \$28589 \$28892 \$23141 \$29333 NWELL PWELL BULK MUX2_X2
X$56866 \$29334 \$30432 \$23141 \$30890 NWELL PWELL BULK MUX2_X2
X$56868 \$31894 \$31604 \$23141 \$31910 NWELL PWELL BULK MUX2_X2
X$56871 \$29799 \$28691 \$23141 \$29806 NWELL PWELL BULK MUX2_X2
X$56874 \$30407 \$30144 \$23141 \$30970 NWELL PWELL BULK MUX2_X2
X$56876 \$37604 \$36708 \$23141 \$36275 NWELL PWELL BULK MUX2_X2
X$56880 \$31205 \$31204 \$23141 \$33419 NWELL PWELL BULK MUX2_X2
X$56884 \$26095 \$25857 \$23141 \$26098 NWELL PWELL BULK MUX2_X2
X$56886 \$28699 \$28025 \$23141 \$29365 NWELL PWELL BULK MUX2_X2
X$56889 \$26621 \$25860 \$23141 \$26622 NWELL PWELL BULK MUX2_X2
X$56891 \$26361 \$27376 \$23141 \$28042 NWELL PWELL BULK MUX2_X2
X$56894 \$25853 \$26587 \$23141 \$26594 NWELL PWELL BULK MUX2_X2
X$56896 \$24415 \$24900 \$23141 \$25556 NWELL PWELL BULK MUX2_X2
X$56898 \$25519 \$24409 \$23141 \$25517 NWELL PWELL BULK MUX2_X2
X$56902 \$23861 \$23866 \$23141 \$24147 NWELL PWELL BULK MUX2_X2
X$56904 \$23931 \$23149 \$23141 \$24330 NWELL PWELL BULK MUX2_X2
X$56907 \$29302 \$27736 \$23141 \$29309 NWELL PWELL BULK MUX2_X2
X$56909 \$27238 \$27049 \$23141 \$27239 NWELL PWELL BULK MUX2_X2
X$56913 \$29687 \$28704 \$23141 \$29885 NWELL PWELL BULK MUX2_X2
X$56915 \$25597 \$26114 \$23141 \$24911 NWELL PWELL BULK MUX2_X2
X$56917 \$24663 \$24665 \$23141 \$24913 NWELL PWELL BULK MUX2_X2
X$56920 \$23941 \$23944 \$23141 \$24152 NWELL PWELL BULK MUX2_X2
X$56922 \$35337 \$23141 \$34388 \$35350 NWELL PWELL BULK MUX2_X1
X$56925 \$37215 \$36490 \$23141 \$36694 NWELL PWELL BULK MUX2_X2
X$56927 \$34576 \$34900 \$23141 \$34614 NWELL PWELL BULK MUX2_X2
X$56929 \$23141 \$36433 NWELL PWELL BULK BUF_X32
X$56931 \$35264 \$23141 NWELL PWELL BULK BUF_X16
X$56972 \$31910 \$23142 \$26622 \$34614 \$36392 NWELL PWELL BULK NOR4_X4
X$56974 \$23142 \$37064 NWELL PWELL BULK INV_X1
X$56978 \$34706 \$36524 \$37072 \$23142 \$38582 NWELL PWELL BULK AOI22_X2
X$57023 \$23171 \$23476 \$23472 NWELL PWELL BULK XOR2_X1
X$57026 \$I178696 \$23171 \$23995 \$23991 NWELL PWELL BULK DFF_X1
X$57032 \$23747 \$23176 NWELL PWELL BULK INV_X1
X$57043 \$24450 \$24161 \$23183 NWELL PWELL BULK NAND2_X1
X$57051 \$24392 \$23187 \$24462 \$24463 NWELL PWELL BULK MUX2_X1
X$57053 \$24170 \$23187 \$24460 \$24772 NWELL PWELL BULK MUX2_X1
X$57105 \$23775 \$23207 \$23774 \$24181 NWELL PWELL BULK AOI21_X1
X$57135 \$23226 \$23643 NWELL PWELL BULK INV_X1
X$57143 \$24488 \$23624 \$23228 NWELL PWELL BULK OR2_X4
X$57157 \$24890 \$24205 \$24203 \$23230 NWELL PWELL BULK OAI21_X1
X$57162 \$23230 \$24877 \$23784 NWELL PWELL BULK NAND2_X1
X$57171 \$23238 \$27271 NWELL PWELL BULK INV_X1
X$57229 \$23274 \$23482 \$23272 NWELL PWELL BULK NAND2_X1
X$57234 \$25927 \$25380 \$26888 \$23274 NWELL PWELL BULK NAND3_X4
X$57238 \$23274 \$25010 \$25996 \$I241509 NWELL PWELL BULK HA_X1
X$57248 \$23274 \$23276 \$23278 NWELL PWELL BULK NAND2_X1
X$57266 \$23276 \$24541 \$24669 NWELL PWELL BULK XNOR2_X1
X$57331 \$26020 \$24254 \$24248 \$23316 NWELL PWELL BULK AND3_X2
X$57351 \$23327 \$23846 \$23328 \$23828 NWELL PWELL BULK MUX2_X1
X$57385 \$23356 \$38363 \$37685 \$38741 NWELL PWELL BULK NOR3_X1
X$57387 \$23356 \$33395 NWELL PWELL BULK INV_X1
X$57390 \$37065 \$23356 \$38743 \$41843 NWELL PWELL BULK OAI21_X1
X$57420 \$I179200 \$23382 \$23906 \$24422 NWELL PWELL BULK DFF_X1
X$57441 \$23395 \$34944 NWELL PWELL BULK INV_X1
X$57445 \$26098 \$23395 \$25327 \$29365 \$34426 NWELL PWELL BULK OR4_X2
X$57448 \$26098 \$23395 \$25327 \$29365 \$34428 NWELL PWELL BULK NOR4_X4
X$57450 \$35682 \$36524 \$37072 \$23395 \$38380 NWELL PWELL BULK AOI22_X2
X$57529 \$23469 \$23462 \$23464 \$23991 NWELL PWELL BULK DFF_X1
X$57546 \$23473 S1_AXI_ARLEN[3] NWELL PWELL BULK BUF_X1
X$57557 \$23482 \$24538 \$24281 NWELL PWELL BULK XNOR2_X1
X$57565 \$23482 \$23911 NWELL PWELL BULK INV_X1
X$57619 \$23540 \$25938 NWELL PWELL BULK INV_X1
X$57660 \$25364 \$23575 NWELL PWELL BULK INV_X1
X$57664 \$24470 \$23575 \$26815 NWELL PWELL BULK NAND2_X1
X$57675 \$29715 \$27432 \$23579 \$29162 NWELL PWELL BULK AOI21_X1
X$57682 \$25911 \$25753 \$28264 \$27432 \$23579 NWELL PWELL BULK AOI22_X4
X$57735 \$24488 \$23624 \$24493 NWELL PWELL BULK NOR2_X2
X$57737 \$24488 \$23624 \$25243 \$24865 NWELL PWELL BULK OAI21_X1
X$57771 \$23671 \$27250 NWELL PWELL BULK INV_X1
X$57823 \$26062 \$26372 \$23719 \$25848 NWELL PWELL BULK MUX2_X1
X$57825 \$25845 \$26524 \$23719 \$26551 NWELL PWELL BULK MUX2_X1
X$57828 \$27036 \$26327 \$23719 \$27166 NWELL PWELL BULK MUX2_X1
X$57830 \$23719 \$26335 \$26336 \$26337 NWELL PWELL BULK MUX2_X1
X$57841 \$I174834 \$23919 \$23727 \$24422 NWELL PWELL BULK DFF_X1
X$57856 M1_AXI_ARLEN[6] \$23744 NWELL PWELL BULK CLKBUF_X2
X$57877 \$23747 \$24443 \$24160 NWELL PWELL BULK XNOR2_X2
X$57891 \$24028 \$24744 \$23751 NWELL PWELL BULK NAND2_X1
X$57894 \$24450 \$24162 \$23752 NWELL PWELL BULK NAND2_X1
X$57929 \$24095 \$23782 NWELL PWELL BULK INV_X1
X$57936 \$25933 \$23783 \$25818 \$25935 NWELL PWELL BULK MUX2_X1
X$57939 \$24964 \$23783 \$24198 \$24874 NWELL PWELL BULK AOI21_X1
X$57942 \$23783 \$26426 \$26425 NWELL PWELL BULK NOR2_X1
X$57947 \$26426 \$23783 \$25932 NWELL PWELL BULK OR2_X1
X$58020 \$24713 \$24504 \$23806 \$25147 NWELL PWELL BULK MUX2_X1
X$58040 \$24669 \$23819 \$24281 \$24649 NWELL PWELL BULK NAND3_X2
X$58052 \$23828 M2_AXI_BID[3] NWELL PWELL BULK BUF_X1
X$58068 \$24256 \$23846 \$25540 \$25479 NWELL PWELL BULK MUX2_X1
X$58073 \$25502 \$23846 \$25047 \$25486 NWELL PWELL BULK MUX2_X1
X$58075 \$27906 \$24557 \$I245532 \$23846 NWELL PWELL BULK DFF_X2
X$58078 \$26027 \$23846 \$27910 \$29260 NWELL PWELL BULK MUX2_X1
X$58080 \$26511 \$23846 \$27912 \$27913 NWELL PWELL BULK MUX2_X1
X$58099 \$I177999 \$23854 \$23860 \$24557 NWELL PWELL BULK DFF_X1
X$58134 \$24240 \$23900 \$24650 NWELL PWELL BULK NAND2_X1
X$58197 M1_AXI_AWADDR[13] \$23936 NWELL PWELL BULK BUF_X1
X$58246 \$23969 \$28381 NWELL PWELL BULK INV_X1
X$58290 \$I174374 \$32130 \$32442 \$23991 NWELL PWELL BULK DFF_X1
X$58293 \$I174338 \$31002 \$31005 \$23991 NWELL PWELL BULK DFF_X1
X$58296 \$I174654 \$32127 \$31756 \$23991 NWELL PWELL BULK DFF_X1
X$58299 \$31008 \$32048 \$31674 \$23991 NWELL PWELL BULK DFF_X1
X$58302 \$31006 \$30248 \$30947 \$23991 NWELL PWELL BULK DFF_X1
X$58304 \$32888 \$32129 \$32885 \$23991 NWELL PWELL BULK DFF_X1
X$58306 \$I174642 \$30536 \$30182 \$23991 NWELL PWELL BULK DFF_X1
X$58308 \$I178740 \$28717 \$29129 \$23991 NWELL PWELL BULK DFF_X1
X$58310 \$I178738 \$28720 \$28476 \$23991 NWELL PWELL BULK DFF_X1
X$58313 \$I175604 \$32125 \$32420 \$23991 NWELL PWELL BULK DFF_X1
X$58315 \$31286 \$30525 \$31279 \$23991 NWELL PWELL BULK DFF_X1
X$58317 \$29506 \$29053 \$29058 \$23991 NWELL PWELL BULK DFF_X1
X$58319 \$29954 \$30547 \$30046 \$23991 NWELL PWELL BULK DFF_X1
X$58322 \$29054 \$29049 \$29045 \$23991 NWELL PWELL BULK DFF_X1
X$58325 \$I177437 \$24927 \$26381 \$23991 NWELL PWELL BULK DFF_X1
X$58328 \$I177465 \$26382 \$26725 \$23991 NWELL PWELL BULK DFF_X1
X$58331 \$29056 \$29134 \$29492 \$23991 NWELL PWELL BULK DFF_X1
X$58333 \$29484 \$29030 \$29480 \$23991 NWELL PWELL BULK DFF_X1
X$58336 \$I175873 \$27778 \$27776 \$23991 NWELL PWELL BULK DFF_X1
X$58338 \$27263 \$27260 \$27259 \$23991 NWELL PWELL BULK DFF_X1
X$58342 \$27783 \$27784 \$28679 \$23991 NWELL PWELL BULK DFF_X1
X$58344 \$I175955 \$27780 \$28128 \$23991 NWELL PWELL BULK DFF_X1
X$58350 \$25209 \$24707 \$24706 \$23991 NWELL PWELL BULK DFF_X1
X$58353 \$25674 \$24710 \$24920 \$23991 NWELL PWELL BULK DFF_X1
X$58356 \$26199 \$25347 \$26190 \$23991 NWELL PWELL BULK DFF_X1
X$58359 \$25880 \$26189 \$25671 \$23991 NWELL PWELL BULK DFF_X1
X$58361 \$I178700 \$24719 \$24157 \$23991 NWELL PWELL BULK DFF_X1
X$58410 \$24028 \$24022 \$24023 NWELL PWELL BULK NAND2_X1
X$58416 \$24028 \$24162 \$24165 NWELL PWELL BULK NAND2_X1
X$58420 \$24028 \$26731 \$I241117 \$27056 NWELL PWELL BULK HA_X1
X$58423 \$24028 \$24451 \$25349 NWELL PWELL BULK NAND2_X1
X$58428 \$24028 \$24161 \$24455 NWELL PWELL BULK NAND2_X1
X$58430 \$24450 \$24028 NWELL PWELL BULK INV_X4
X$58434 \$24028 \$24745 \$25232 NWELL PWELL BULK NAND2_X1
X$58507 \$24126 \$24194 \$24476 \$24957 NWELL PWELL BULK OR3_X1
X$58510 \$24126 \$26423 NWELL PWELL BULK INV_X1
X$58516 \$24126 \$26745 \$25993 NWELL PWELL BULK XNOR2_X1
X$58529 M0_AXI_AWLEN[1] \$24406 NWELL PWELL BULK CLKBUF_X2
X$58544 \$24147 \$38363 \$37685 \$41616 NWELL PWELL BULK NOR3_X1
X$58553 \$24147 \$33028 NWELL PWELL BULK INV_X1
X$58560 \$37065 \$24147 \$41280 \$42295 NWELL PWELL BULK OAI21_X1
X$58566 \$24911 \$33419 \$29885 \$24152 \$34429 NWELL PWELL BULK NOR4_X4
X$58570 \$24911 \$33419 \$29885 \$24152 \$34425 NWELL PWELL BULK OR4_X2
X$58572 \$24152 \$39804 NWELL PWELL BULK INV_X1
X$58575 \$35943 \$36524 \$37072 \$24152 \$40047 NWELL PWELL BULK AOI22_X2
X$58582 M1_AXI_ARID[2] \$24153 NWELL PWELL BULK CLKBUF_X2
X$58601 \$24389 \$24730 \$24160 \$24448 NWELL PWELL BULK NAND3_X4
X$58608 \$24162 \$24161 \$24744 \$24745 NWELL PWELL BULK HA_X1
X$58627 \$24450 \$24167 \$24166 NWELL PWELL BULK NAND2_X1
X$58639 \$24167 \$24933 NWELL PWELL BULK INV_X2
X$58642 \$24167 \$25708 \$25894 NWELL PWELL BULK XNOR2_X2
X$58652 \$24168 \$25892 \$25705 NWELL PWELL BULK XNOR2_X2
X$58655 \$24450 \$24168 \$25236 NWELL PWELL BULK NAND2_X1
X$58674 \$24191 \$24178 \$24180 NWELL PWELL BULK AND2_X1
X$58683 \$24190 \$24954 \$24181 \$24470 NWELL PWELL BULK NAND3_X1
X$58692 \$25263 \$24483 \$24957 \$26879 \$24182 NWELL PWELL BULK OAI22_X4
X$58699 \$28758 \$28997 \$24190 \$25377 \$29639 \$29140 NWELL PWELL BULK
+ OAI221_X2
X$58710 \$30262 \$30260 \$30261 \$24191 NWELL PWELL BULK NAND3_X4
X$58717 \$24191 \$27426 \$28743 \$27090 \$25243 \$30064 NWELL PWELL BULK
+ AOI221_X1
X$58719 \$27426 \$24191 \$29157 NWELL PWELL BULK NAND2_X1
X$58721 \$28278 \$27435 \$28264 \$28499 \$24191 \$28758 NWELL PWELL BULK
+ OAI221_X2
X$58725 \$24493 \$24191 \$27098 \$25931 NWELL PWELL BULK NAND3_X1
X$58745 \$25243 \$24476 \$24194 \$24954 NWELL PWELL BULK OAI21_X2
X$58767 \$27097 \$27098 \$24205 NWELL PWELL BULK NAND2_X1
X$58782 \$27835 \$24212 \$27626 \$31781 \$27839 NWELL PWELL BULK OAI22_X4
X$58804 \$24214 \$26444 NWELL PWELL BULK INV_X1
X$58831 \$24227 \$24504 \$24528 \$24724 NWELL PWELL BULK MUX2_X1
X$58847 \$24240 \$25999 \$26001 NWELL PWELL BULK NAND2_X1
X$58849 \$24240 \$25010 NWELL PWELL BULK INV_X2
X$58852 \$24240 \$24538 \$25008 NWELL PWELL BULK NAND2_X1
X$58855 \$24240 \$25448 \$25011 NWELL PWELL BULK NAND2_X1
X$58858 \$24649 \$27507 \$24240 NWELL PWELL BULK NAND2_X2
X$58863 \$24240 \$24541 \$24539 NWELL PWELL BULK NAND2_X1
X$58875 \$24243 \$24273 \$24639 NWELL PWELL BULK XNOR2_X1
X$58883 \$24248 \$26504 \$I241133 \$26634 NWELL PWELL BULK HA_X1
X$58885 \$24248 \$25029 \$25083 NWELL PWELL BULK NAND2_X1
X$58888 \$24248 \$25033 \$25567 NWELL PWELL BULK NAND2_X1
X$58891 \$24248 \$25035 \$25472 NWELL PWELL BULK NAND2_X1
X$58893 \$24248 \$26507 \$26505 NWELL PWELL BULK NAND2_X1
X$58895 \$24248 \$24249 \$24250 NWELL PWELL BULK NAND2_X1
X$58898 \$24248 \$24252 \$24253 NWELL PWELL BULK NAND2_X1
X$58903 \$24248 \$24552 NWELL PWELL BULK INV_X4
X$58921 \$25029 \$24252 \$25033 \$25035 NWELL PWELL BULK HA_X1
X$58926 \$24552 \$24252 \$25028 NWELL PWELL BULK NAND2_X1
X$58934 \$24552 \$24254 \$24590 NWELL PWELL BULK NAND2_X1
X$58940 \$24254 \$27531 \$26509 NWELL PWELL BULK XNOR2_X1
X$58961 \$27747 \$24271 \$27749 \$27744 NWELL PWELL BULK MUX2_X1
X$58963 \$28834 \$24271 \$28446 \$28687 NWELL PWELL BULK MUX2_X1
X$58966 \$49571 \$24271 \$49819 \$49458 NWELL PWELL BULK MUX2_X1
X$58968 \$51714 \$24271 \$51270 \$51702 NWELL PWELL BULK MUX2_X1
X$58970 \$24908 \$24271 \$25323 \$25122 NWELL PWELL BULK MUX2_X1
X$58972 \$48747 \$24271 \$45365 \$49098 NWELL PWELL BULK MUX2_X1
X$58975 \$25096 \$24271 \$24418 \$24605 NWELL PWELL BULK MUX2_X1
X$58978 \$27953 \$24271 \$27964 \$27361 NWELL PWELL BULK MUX2_X1
X$58981 \$29681 \$24271 \$29677 \$29823 NWELL PWELL BULK MUX2_X1
X$58983 \$35825 \$24271 \$35194 \$35829 NWELL PWELL BULK MUX2_X1
X$58985 \$37219 \$24271 \$36494 \$37434 NWELL PWELL BULK MUX2_X1
X$58987 \$34548 \$24271 \$34692 \$33973 NWELL PWELL BULK MUX2_X1
X$58989 \$33389 \$24271 \$33814 \$34028 NWELL PWELL BULK MUX2_X1
X$58992 \$45391 \$24271 \$41129 \$45219 NWELL PWELL BULK MUX2_X1
X$58994 \$53694 \$24271 \$52849 \$53818 NWELL PWELL BULK MUX2_X1
X$58996 \$27372 \$24271 \$27752 \$27608 NWELL PWELL BULK MUX2_X1
X$58998 \$30972 \$24271 \$30971 \$31138 NWELL PWELL BULK MUX2_X1
X$59003 \$26075 \$24271 \$25318 \$26575 NWELL PWELL BULK MUX2_X1
X$59005 \$25069 \$24271 \$25311 \$24405 NWELL PWELL BULK MUX2_X1
X$59007 \$27743 \$24271 \$27741 \$27742 NWELL PWELL BULK MUX2_X1
X$59009 \$30210 \$24271 \$29329 \$30025 NWELL PWELL BULK MUX2_X1
X$59013 \$26605 \$24271 \$24904 \$26085 NWELL PWELL BULK MUX2_X1
X$59078 \$24330 \$35698 NWELL PWELL BULK INV_X1
X$59083 \$30218 \$36524 \$37072 \$24330 \$37669 NWELL PWELL BULK AOI22_X2
X$59087 \$38109 \$28042 \$24330 \$27239 \$37089 NWELL PWELL BULK NOR4_X1
X$59090 \$28042 \$24330 \$36540 NWELL PWELL BULK NOR2_X2
X$59160 \$26688 \$26372 \$24406 \$25341 NWELL PWELL BULK MUX2_X1
X$59162 \$24406 \$26335 \$26686 \$26374 NWELL PWELL BULK MUX2_X1
X$59165 \$28082 \$27759 \$24406 \$28071 NWELL PWELL BULK MUX2_X1
X$59168 \$27053 \$27383 \$24406 \$27248 NWELL PWELL BULK MUX2_X1
X$59195 \$24417 S1_AXI_AWBURST[0] NWELL PWELL BULK BUF_X1
X$59199 M1_AXI_AWADDR[11] \$24418 NWELL PWELL BULK BUF_X1
X$59213 \$I176684 \$27747 \$27744 \$24422 NWELL PWELL BULK DFF_X1
X$59215 \$I178811 \$28014 \$28015 \$24422 NWELL PWELL BULK DFF_X1
X$59218 \$I178826 \$29848 \$29352 \$24422 NWELL PWELL BULK DFF_X1
X$59220 \$I174776 \$28457 \$29351 \$24422 NWELL PWELL BULK DFF_X1
X$59223 \$I178886 \$27369 \$28002 \$24422 NWELL PWELL BULK DFF_X1
X$59226 \$I176708 \$28698 \$28898 \$24422 NWELL PWELL BULK DFF_X1
X$59228 \$I176717 \$29343 \$29839 \$24422 NWELL PWELL BULK DFF_X1
X$59230 \$I178808 \$28455 \$27753 \$24422 NWELL PWELL BULK DFF_X1
X$59233 \$I174560 \$31476 \$31174 \$24422 NWELL PWELL BULK DFF_X1
X$59236 \$I178704 \$29683 \$30216 \$24422 NWELL PWELL BULK DFF_X1
X$59238 \$25314 \$24422 NWELL PWELL BULK BUF_X4
X$59241 \$I174835 \$27372 \$27608 \$24422 NWELL PWELL BULK DFF_X1
X$59243 \$I174288 \$28940 \$29371 \$24422 NWELL PWELL BULK DFF_X1
X$59246 \$I175120 \$29117 \$29115 \$24422 NWELL PWELL BULK DFF_X1
X$59248 \$I178477 \$29864 \$29359 \$24422 NWELL PWELL BULK DFF_X1
X$59250 \$I178804 \$32294 \$32298 \$24422 NWELL PWELL BULK DFF_X1
X$59252 \$I178802 \$30986 \$31629 \$24422 NWELL PWELL BULK DFF_X1
X$59254 \$I178914 \$30220 \$30190 \$24422 NWELL PWELL BULK DFF_X1
X$59257 \$I178948 \$30031 \$30461 \$24422 NWELL PWELL BULK DFF_X1
X$59260 \$I174335 \$31193 \$31650 \$24422 NWELL PWELL BULK DFF_X1
X$59262 \$I178831 \$24910 \$25325 \$24422 NWELL PWELL BULK DFF_X1
X$59265 \$I179096 \$25138 \$24643 \$24422 NWELL PWELL BULK DFF_X1
X$59267 \$I179190 \$24908 \$25122 \$24422 NWELL PWELL BULK DFF_X1
X$59272 \$I174764 \$25859 \$26348 \$24422 NWELL PWELL BULK DFF_X1
X$59275 \$I178723 \$26350 \$27203 \$24422 NWELL PWELL BULK DFF_X1
X$59277 \$I179215 \$26605 \$26085 \$24422 NWELL PWELL BULK DFF_X1
X$59279 \$I178724 \$26347 \$26345 \$24422 NWELL PWELL BULK DFF_X1
X$59281 \$I178522 \$27211 \$26352 \$24422 NWELL PWELL BULK DFF_X1
X$59283 \$I174836 \$26101 \$25570 \$24422 NWELL PWELL BULK DFF_X1
X$59315 M1_AXI_ARLEN[7] \$24429 NWELL PWELL BULK CLKBUF_X2
X$59344 M1_AXI_ARID[3] \$24441 NWELL PWELL BULK BUF_X2
X$59371 \$24445 \$24447 \$25225 NWELL PWELL BULK XNOR2_X1
X$59378 \$26217 \$25348 \$25887 \$24447 NWELL PWELL BULK AOI21_X1
X$59382 \$26419 \$28305 \$25887 \$27829 \$24448 NWELL PWELL BULK AOI22_X4
X$59384 \$27091 \$24448 \$27438 NWELL PWELL BULK NAND2_X1
X$59411 \$24450 \$26385 \$27057 \$I241518 NWELL PWELL BULK HA_X1
X$59418 \$24450 \$25890 \$25696 NWELL PWELL BULK NAND2_X1
X$59439 \$24451 \$25232 \$25230 NWELL PWELL BULK XOR2_X1
X$59512 \$24499 \$24890 NWELL PWELL BULK INV_X1
X$59522 \$27115 \$24504 \$26447 \$27264 NWELL PWELL BULK MUX2_X1
X$59526 \$26486 \$24504 \$26485 \$26840 NWELL PWELL BULK MUX2_X1
X$59531 \$27853 \$24504 \$26452 \$27851 NWELL PWELL BULK MUX2_X1
X$59533 \$27475 \$27864 \$28316 \$24504 NWELL PWELL BULK NOR3_X4
X$59535 \$25197 \$24504 \$24976 \$25824 NWELL PWELL BULK MUX2_X1
X$59537 \$26860 \$24504 \$25975 \$26479 NWELL PWELL BULK MUX2_X1
X$59541 \$27473 \$24504 \$27230 \$27471 NWELL PWELL BULK MUX2_X1
X$59609 \$24532 S1_AXI_ARID[1] NWELL PWELL BULK BUF_X1
X$59621 \$I175757 \$24538 \$24686 \$25445 NWELL PWELL BULK DFF_X1
X$59627 \$25010 \$25999 \$24540 NWELL PWELL BULK NAND2_X1
X$59645 \$28054 \$27504 \$24550 NWELL PWELL BULK NOR2_X1
X$59648 \$24552 \$26017 \$26629 NWELL PWELL BULK NAND2_X1
X$59651 \$24552 \$25029 \$25088 NWELL PWELL BULK NAND2_X1
X$59654 \$24552 \$26020 \$26614 NWELL PWELL BULK NAND2_X1
X$59663 \$24552 \$27900 \$27504 \$I241543 NWELL PWELL BULK HA_X1
X$59672 \$I177815 \$24558 \$24556 \$24557 NWELL PWELL BULK DFF_X1
X$59674 \$I176062 \$24562 \$24571 \$24557 NWELL PWELL BULK DFF_X1
X$59676 \$26018 \$24557 \$I245537 \$26020 NWELL PWELL BULK DFF_X2
X$59681 \$I176063 \$26026 \$26024 \$24557 NWELL PWELL BULK DFF_X1
X$59684 \$I176344 \$25481 \$26569 \$24557 NWELL PWELL BULK DFF_X1
X$59687 \$I178260 \$26032 \$26554 \$24557 NWELL PWELL BULK DFF_X1
X$59689 \$I174468 \$24565 \$25516 \$24557 NWELL PWELL BULK DFF_X1
X$59691 \$I174456 \$25483 \$26028 \$24557 NWELL PWELL BULK DFF_X1
X$59693 \$I178459 \$25043 \$24559 \$24557 NWELL PWELL BULK DFF_X1
X$59696 \$I178093 \$27969 \$27985 \$24557 NWELL PWELL BULK DFF_X1
X$59699 \$28810 \$28825 \$29268 \$24557 NWELL PWELL BULK DFF_X1
X$59701 \$I177194 \$27513 \$27906 \$24557 NWELL PWELL BULK DFF_X1
X$59703 \$29749 \$24557 NWELL PWELL BULK BUF_X4
X$59705 \$I175377 \$27531 \$28011 \$24557 NWELL PWELL BULK DFF_X1
X$59709 \$I175982 \$27516 \$27522 \$24557 NWELL PWELL BULK DFF_X1
X$59712 \$I175439 \$27527 \$27159 \$24557 NWELL PWELL BULK DFF_X1
X$59715 \$I176889 \$27911 \$27947 \$24557 NWELL PWELL BULK DFF_X1
X$59717 \$I175907 \$30831 \$30386 \$24557 NWELL PWELL BULK DFF_X1
X$59719 \$I175908 \$32608 \$32255 \$24557 NWELL PWELL BULK DFF_X1
X$59721 \$I178206 \$31085 \$31848 \$24557 NWELL PWELL BULK DFF_X1
X$59723 \$I175936 \$31555 \$31553 \$24557 NWELL PWELL BULK DFF_X1
X$59725 \$31832 \$32199 \$32260 \$24557 NWELL PWELL BULK DFF_X1
X$59727 \$31126 \$30829 \$31122 \$24557 NWELL PWELL BULK DFF_X1
X$59729 \$31084 \$31083 \$31130 \$24557 NWELL PWELL BULK DFF_X1
X$59732 \$31120 \$31552 \$31579 \$24557 NWELL PWELL BULK DFF_X1
X$59735 \$I178022 \$31086 \$30351 \$24557 NWELL PWELL BULK DFF_X1
X$59738 \$32597 \$32265 \$32196 \$24557 NWELL PWELL BULK DFF_X1
X$59740 \$31131 \$31548 \$31583 \$24557 NWELL PWELL BULK DFF_X1
X$59878 \$24649 S1_AXI_ARVALID NWELL PWELL BULK BUF_X1
X$59946 \$24703 \$47368 NWELL PWELL BULK BUF_X4
X$59954 \$24703 \$59890 NWELL PWELL BULK BUF_X4
X$60110 \$24880 \$25931 \$25933 \$25932 \$26911 \$25925 NWELL PWELL BULK
+ OAI221_X2
X$60133 M1_AXI_AWADDR[21] \$24904 NWELL PWELL BULK BUF_X1
X$60164 \$31949 \$36524 \$37072 \$24911 \$39056 NWELL PWELL BULK AOI22_X2
X$60170 \$24911 \$37079 NWELL PWELL BULK INV_X1
X$60183 \$24913 \$35068 NWELL PWELL BULK INV_X2
X$60186 \$34428 \$34429 \$24913 \$32322 NWELL PWELL BULK NAND3_X1
X$60188 \$24913 \$32095 \$34999 NWELL PWELL BULK NAND2_X1
X$60191 \$24913 \$34425 \$34426 \$37465 NWELL PWELL BULK NOR3_X4
X$60194 \$30033 \$36524 \$37072 \$24913 \$37701 NWELL PWELL BULK AOI22_X2
X$60212 \$25347 \$24927 \$26722 \$26207 NWELL PWELL BULK HA_X1
X$60247 \$24961 \$24964 \$25809 NWELL PWELL BULK NAND2_X1
X$60249 \$27834 \$26420 \$26418 \$24964 NWELL PWELL BULK NOR3_X2
X$60268 \$27835 \$24969 \$28644 \$33106 NWELL PWELL BULK OAI21_X1
X$60298 \$24982 \$27846 NWELL PWELL BULK INV_X1
X$60310 \$24986 \$26960 NWELL PWELL BULK INV_X1
X$60356 \$25010 \$26100 \$26002 NWELL PWELL BULK NAND2_X1
X$60359 \$25010 \$26004 \$25456 NWELL PWELL BULK NAND2_X1
X$60362 \$25010 \$25016 \$25017 NWELL PWELL BULK NAND2_X1
X$60367 \$25010 \$25448 \$25641 NWELL PWELL BULK NAND2_X1
X$60370 \$25010 \$25997 \$25449 NWELL PWELL BULK NAND2_X1
X$60380 \$25016 \$25456 \$25623 NWELL PWELL BULK XNOR2_X1
X$60400 \$26008 \$25025 \$26086 \$26083 NWELL PWELL BULK HA_X1
X$60442 \$25066 S1_AXI_ARID[3] NWELL PWELL BULK BUF_X1
X$60612 \$25895 \$25894 \$25705 \$25243 NWELL PWELL BULK NAND3_X4
X$60614 \$29029 \$25243 \$29601 NWELL PWELL BULK NAND2_X1
X$60624 \$27428 \$25243 \$29574 NWELL PWELL BULK NAND2_X1
X$60663 M1_AXI_AWADDR[6] \$25311 NWELL PWELL BULK BUF_X1
X$60678 \$25312 \$26327 \$26329 \$26038 NWELL PWELL BULK MUX2_X1
X$60682 \$25314 \$29099 NWELL PWELL BULK BUF_X4
X$60686 \$25314 \$35664 NWELL PWELL BULK BUF_X4
X$60692 \$25314 \$40671 NWELL PWELL BULK BUF_X4
X$60695 \$25314 \$31723 NWELL PWELL BULK BUF_X4
X$60700 \$25314 \$33414 NWELL PWELL BULK BUF_X4
X$60705 \$25314 \$33435 NWELL PWELL BULK BUF_X4
X$60709 \$25314 \$27758 NWELL PWELL BULK BUF_X4
X$60733 M1_AXI_AWADDR[10] \$25318 NWELL PWELL BULK BUF_X1
X$60749 M1_AXI_AWADDR[19] \$25323 NWELL PWELL BULK BUF_X1
X$60754 \$25859 \$27745 \$25323 \$26348 NWELL PWELL BULK MUX2_X1
X$60763 M1_AXI_AWADDR[12] \$25324 NWELL PWELL BULK BUF_X1
X$60784 \$35465 \$36524 \$37072 \$25327 \$38626 NWELL PWELL BULK AOI22_X2
X$60789 \$25327 \$39054 NWELL PWELL BULK INV_X1
X$60808 M1_AXI_AWADDR[14] \$25333 NWELL PWELL BULK BUF_X1
X$60829 M1_AXI_ARID[0] \$25336 NWELL PWELL BULK CLKBUF_X2
X$60871 \$26742 \$26385 \$26387 \$25350 NWELL PWELL BULK MUX2_X1
X$60912 \$25379 \$25380 \$25377 NWELL PWELL BULK NAND2_X1
X$60932 \$26418 \$26420 \$27093 \$25380 NWELL PWELL BULK NOR3_X4
X$60944 \$25384 \$26933 NWELL PWELL BULK INV_X1
X$60962 \$27835 \$25390 \$28497 NWELL PWELL BULK NOR2_X1
X$60983 \$27835 \$25403 \$27840 \$27839 \$32025 NWELL PWELL BULK OAI22_X2
X$60999 \$25409 \$28397 NWELL PWELL BULK INV_X1
X$61018 \$25415 \$27293 NWELL PWELL BULK INV_X1
X$61038 \$27839 \$28965 \$25417 \$28612 \$27835 NWELL PWELL BULK OAI22_X4
X$61093 \$I175087 \$28866 \$28802 \$25445 NWELL PWELL BULK DFF_X1
X$61095 \$30477 \$30332 \$30331 \$25445 NWELL PWELL BULK DFF_X1
X$61098 \$27496 \$26497 \$27193 \$25445 NWELL PWELL BULK DFF_X1
X$61100 \$I177481 \$29223 \$29222 \$25445 NWELL PWELL BULK DFF_X1
X$61102 \$I177150 \$27139 \$27494 \$25445 NWELL PWELL BULK DFF_X1
X$61105 \$I177479 \$27196 \$28140 \$25445 NWELL PWELL BULK DFF_X1
X$61108 \$32172 \$32175 \$32310 \$25445 NWELL PWELL BULK DFF_X1
X$61111 \$30329 \$30330 \$30131 \$25445 NWELL PWELL BULK DFF_X1
X$61114 \$31266 \$25445 \$I245620 \$31258 NWELL PWELL BULK DFF_X2
X$61117 \$I177358 \$25999 \$26500 \$25445 NWELL PWELL BULK DFF_X1
X$61120 \$25997 \$25448 \$25452 \$25445 NWELL PWELL BULK DFF_X1
X$61122 \$I177349 \$26499 \$27142 \$25445 NWELL PWELL BULK DFF_X1
X$61126 \$28539 \$28540 \$28853 \$25445 NWELL PWELL BULK DFF_X1
X$61129 \$I176412 \$29752 \$29831 \$25445 NWELL PWELL BULK DFF_X1
X$61132 \$I177297 \$30346 \$30406 \$25445 NWELL PWELL BULK DFF_X1
X$61135 \$29345 \$28846 \$29326 \$25445 NWELL PWELL BULK DFF_X1
X$61137 \$I175279 \$30344 \$30447 \$25445 NWELL PWELL BULK DFF_X1
X$61139 \$30340 \$25445 \$I245674 \$31063 NWELL PWELL BULK DFF_X2
X$61141 \$I177373 \$29754 \$29755 \$25445 NWELL PWELL BULK DFF_X1
X$61144 \$31057 \$30335 \$30863 \$25445 NWELL PWELL BULK DFF_X1
X$61146 \$I177034 \$30817 \$31221 \$25445 NWELL PWELL BULK DFF_X1
X$61148 \$30105 \$25445 \$I245659 \$30334 NWELL PWELL BULK DFF_X2
X$61150 \$32170 \$31537 \$32313 \$25445 NWELL PWELL BULK DFF_X1
X$61152 \$32798 \$31806 \$32301 \$25445 NWELL PWELL BULK DFF_X1
X$61154 \$31601 \$25445 \$I245636 \$31061 NWELL PWELL BULK DFF_X2
X$61156 \$31947 \$32177 \$32306 \$25445 NWELL PWELL BULK DFF_X1
X$61159 \$29749 \$25445 NWELL PWELL BULK BUF_X4
X$61163 \$31532 \$25445 \$I245664 \$31533 NWELL PWELL BULK DFF_X2
X$61188 \$25448 \$25999 \$26100 \$26004 NWELL PWELL BULK HA_X1
X$61204 \$25458 \$26007 \$26093 NWELL PWELL BULK XOR2_X1
X$61208 \$26078 \$26010 \$25465 \$26647 NWELL PWELL BULK MUX2_X1
X$61212 \$26012 \$25584 \$26014 \$25582 \$25465 NWELL PWELL BULK FA_X1
X$61218 \$26507 \$25472 \$25468 NWELL PWELL BULK XOR2_X1
X$61228 \$25479 M2_AXI_BID[2] NWELL PWELL BULK BUF_X1
X$61238 \$26063 \$25482 NWELL PWELL BULK INV_X1
X$61241 \$25482 S0_AXI_BREADY NWELL PWELL BULK BUF_X1
X$61254 \$25485 M2_AXI_BID[1] NWELL PWELL BULK BUF_X1
X$61257 \$25486 M2_AXI_BRESP[0] NWELL PWELL BULK BUF_X1
X$61259 \$25501 S2_AXI_ARLEN[3] NWELL PWELL BULK BUF_X1
X$61287 \$25517 \$33194 NWELL PWELL BULK INV_X1
X$61289 \$37065 \$25517 \$40301 \$40661 NWELL PWELL BULK OAI21_X1
X$61292 \$25517 \$38363 \$37685 \$40276 NWELL PWELL BULK NOR3_X1
X$61307 \$37065 \$25556 \$50545 \$50698 NWELL PWELL BULK OAI21_X1
X$61310 \$25556 \$51021 NWELL PWELL BULK INV_X1
X$61313 \$25556 \$38363 \$38978 \$50825 NWELL PWELL BULK NOR3_X1
X$61334 \$26067 \$26010 \$25576 NWELL PWELL BULK NOR2_X1
X$61337 \$26063 \$25576 \$26016 NWELL PWELL BULK XNOR2_X1
X$61340 \$25592 \$25582 NWELL PWELL BULK INV_X1
X$61345 \$25592 \$25584 \$26067 NWELL PWELL BULK XOR2_X1
X$61434 \$25708 \$26385 \$27060 \$26748 NWELL PWELL BULK MUX2_X1
X$61459 \$25724 \$27419 \$27417 \$27421 \$28484 \$28492 NWELL PWELL BULK
+ AOI221_X2
X$61479 \$25753 \$25911 \$27338 \$27434 NWELL PWELL BULK NAND3_X1
X$61526 \$25842 \$26331 \$26541 \$26332 NWELL PWELL BULK MUX2_X1
X$61560 \$25875 \$26692 \$25876 \$26375 NWELL PWELL BULK MUX2_X1
X$61565 M1_AXI_ARID[1] \$25877 NWELL PWELL BULK BUF_X2
X$61580 \$34465 \$25879 NWELL PWELL BULK BUF_X2
X$61583 \$25879 \$33879 \$34311 \$36404 NWELL PWELL BULK OR3_X1
X$61615 \$25890 \$27062 \$25895 NWELL PWELL BULK XNOR2_X2
X$61649 \$25900 \$27070 NWELL PWELL BULK INV_X1
X$61651 \$25900 \$25901 \$28185 NWELL PWELL BULK NOR2_X1
X$61655 \$27077 \$25900 \$27319 NWELL PWELL BULK NAND2_X1
X$61658 \$28484 \$28728 \$25900 \$28729 NWELL PWELL BULK NOR3_X1
X$61671 \$27406 \$25901 NWELL PWELL BULK INV_X1
X$61673 \$27070 \$25901 \$27074 NWELL PWELL BULK NAND2_X1
X$61676 \$27079 \$25901 \$27082 NWELL PWELL BULK NOR2_X1
X$61686 \$28734 \$25906 \$30592 \$30588 NWELL PWELL BULK AOI21_X1
X$61688 \$25906 \$29151 \$29145 NWELL PWELL BULK OR2_X2
X$61690 \$25906 \$26785 NWELL PWELL BULK INV_X2
X$61694 \$30168 \$30263 \$30063 \$25906 NWELL PWELL BULK DFF_X2
X$61713 \$30606 \$27822 \$26405 \$25917 \$30924 NWELL PWELL BULK AOI22_X1
X$61716 \$27820 \$25917 \$26405 \$30273 \$30631 NWELL PWELL BULK OAI22_X1
X$61719 \$30778 \$25917 \$30264 NWELL PWELL BULK NOR2_X1
X$61722 \$28752 \$25917 \$27678 \$31652 NWELL PWELL BULK OAI21_X1
X$61744 \$26869 \$25925 \$26416 NWELL PWELL BULK NAND2_X1
X$61761 \$25931 \$28513 \$28768 NWELL PWELL BULK NOR2_X1
X$61769 \$26418 \$26420 \$27834 \$25935 \$28518 NWELL PWELL BULK NOR4_X4
X$61774 \$25937 \$28492 \$27805 \$28658 NWELL PWELL BULK AOI21_X4
X$61776 \$26438 \$27103 \$25937 \$27297 \$27639 NWELL PWELL BULK AOI22_X1
X$61779 \$26438 \$27308 \$27306 \$25937 \$27642 NWELL PWELL BULK AOI22_X2
X$61782 \$26438 \$27293 \$27250 \$25937 \$28965 NWELL PWELL BULK AOI22_X2
X$61785 \$27422 \$26438 \$25937 \$27811 NWELL PWELL BULK OAI21_X2
X$61787 \$26438 \$28381 \$25937 \$28397 \$27847 NWELL PWELL BULK AOI22_X1
X$61789 \$26438 \$26444 \$27271 \$25937 \$27626 NWELL PWELL BULK AOI22_X2
X$61792 \$26438 \$28369 \$25937 \$27846 \$31782 NWELL PWELL BULK AOI22_X1
X$61796 \$26438 \$26933 \$25937 \$25938 \$26435 NWELL PWELL BULK AOI22_X1
X$61798 \$26438 \$26956 \$25937 \$26960 \$26443 NWELL PWELL BULK AOI22_X1
X$61801 \$26438 \$26938 \$26945 \$25937 \$27840 NWELL PWELL BULK AOI22_X2
X$61827 \$25940 \$26956 NWELL PWELL BULK INV_X1
X$61842 \$I176168 \$28400 \$27850 \$25950 NWELL PWELL BULK DFF_X1
X$61845 \$I178235 \$29189 \$29733 \$25950 NWELL PWELL BULK DFF_X1
X$61847 \$I175543 \$27849 \$28396 \$25950 NWELL PWELL BULK DFF_X1
X$61850 \$I178295 \$27456 \$27457 \$25950 NWELL PWELL BULK DFF_X1
X$61852 \$I178277 \$28779 \$29625 \$25950 NWELL PWELL BULK DFF_X1
X$61854 \$29926 \$25950 \$I245592 \$30077 NWELL PWELL BULK DFF_X2
X$61857 \$I176407 \$27115 \$27264 \$25950 NWELL PWELL BULK DFF_X1
X$61859 \$I178233 \$28951 \$28952 \$25950 NWELL PWELL BULK DFF_X1
X$61861 \$I175667 \$27853 \$27851 \$25950 NWELL PWELL BULK DFF_X1
X$61864 \$I176124 \$28412 \$27854 \$25950 NWELL PWELL BULK DFF_X1
X$61866 \$I176295 \$26456 \$26454 \$25950 NWELL PWELL BULK DFF_X1
X$61868 \$I176522 \$30712 \$30295 \$25950 NWELL PWELL BULK DFF_X1
X$61871 \$I175688 \$29180 \$29649 \$25950 NWELL PWELL BULK DFF_X1
X$61873 \$I176186 \$28774 \$29641 \$25950 NWELL PWELL BULK DFF_X1
X$61875 \$I176673 \$29179 \$29178 \$25950 NWELL PWELL BULK DFF_X1
X$61877 \$I176202 \$29187 \$29186 \$25950 NWELL PWELL BULK DFF_X1
X$61879 \$I176671 \$30297 \$30793 \$25950 NWELL PWELL BULK DFF_X1
X$61881 \$I175942 \$25951 \$26994 \$25950 NWELL PWELL BULK DFF_X1
X$61883 \$I176207 \$29590 \$29918 \$25950 NWELL PWELL BULK DFF_X1
X$61886 \$I174330 \$28939 \$28781 \$25950 NWELL PWELL BULK DFF_X1
X$61888 \$I178514 \$30308 \$30311 \$25950 NWELL PWELL BULK DFF_X1
X$61892 \$I178513 \$30800 \$30799 \$25950 NWELL PWELL BULK DFF_X1
X$61894 \$I178052 \$31448 \$31631 \$25950 NWELL PWELL BULK DFF_X1
X$61896 \$30304 \$25950 \$I245637 \$30290 NWELL PWELL BULK DFF_X2
X$61898 \$I176558 \$30792 \$31032 \$25950 NWELL PWELL BULK DFF_X1
X$61900 \$30729 \$30084 \$30725 \$25950 NWELL PWELL BULK DFF_X1
X$61903 \$29912 \$25950 \$I245595 \$26426 NWELL PWELL BULK DFF_X2
X$61905 \$I176187 \$31037 \$31522 \$25950 NWELL PWELL BULK DFF_X1
X$61909 \$I176667 \$31035 \$31621 \$25950 NWELL PWELL BULK DFF_X1
X$61941 \$27835 \$25957 \$27639 \$27426 \$27644 NWELL PWELL BULK OAI22_X2
X$61961 \$27839 \$26443 \$32157 \$25972 \$27835 \$33265 NWELL PWELL BULK
+ OAI221_X1
X$62016 \$27496 \$25996 \$26497 \$28123 NWELL PWELL BULK MUX2_X1
X$62018 \$25996 \$26498 \$27497 NWELL PWELL BULK NOR2_X1
X$62023 \$27497 \$26499 \$25996 \$27185 NWELL PWELL BULK AOI21_X1
X$62025 \$26496 \$25996 \$26745 NWELL PWELL BULK NOR2_X1
X$62058 \$26070 \$26012 \$26010 \$26639 NWELL PWELL BULK AOI21_X1
X$62060 \$26010 \$26014 \$26070 NWELL PWELL BULK NOR2_X1
X$62080 \$26017 \$27510 \$26598 NWELL PWELL BULK XNOR2_X1
X$62085 \$26020 \$27513 \$26592 NWELL PWELL BULK XNOR2_X1
X$62093 \$26020 \$26021 NWELL PWELL BULK INV_X1
X$62196 \$34403 \$36524 \$39515 \$37072 \$26098 NWELL PWELL BULK AOI22_X4
X$62198 \$26098 \$40137 NWELL PWELL BULK INV_X1
X$62295 \$26200 \$28369 NWELL PWELL BULK INV_X1
X$62314 \$26207 \$26217 NWELL PWELL BULK INV_X1
X$62347 \$26398 \$27077 \$27078 \$26262 \$27080 \$27426 NWELL PWELL BULK
+ AOI221_X2
X$62352 \$26262 \$29143 \$29089 \$29145 \$29142 NWELL PWELL BULK AOI22_X1
X$62374 \$27839 \$26435 \$32157 \$26281 \$27835 \$33014 NWELL PWELL BULK
+ OAI221_X1
X$62388 \$30069 \$26292 \$29162 \$30070 \$29715 \$28507 NWELL PWELL BULK
+ AOI221_X2
X$62391 \$26406 \$26292 \$30066 NWELL PWELL BULK AND2_X1
X$62398 \$26405 \$27822 \$26294 \$30782 NWELL PWELL BULK OAI21_X1
X$62401 \$28752 \$26294 \$27678 \$30776 NWELL PWELL BULK OAI21_X1
X$62404 \$26294 \$31023 \$31652 \$30606 NWELL PWELL BULK OAI21_X1
X$62408 \$29715 \$26294 \$29169 NWELL PWELL BULK OR2_X1
X$62411 \$30778 \$31025 \$26294 \$30911 NWELL PWELL BULK NOR3_X1
X$62426 \$27434 \$27820 \$26298 \$28291 NWELL PWELL BULK AOI21_X1
X$62445 \$30967 \$26327 \$31461 \$31460 NWELL PWELL BULK MUX2_X1
X$62447 \$35198 \$26327 \$34902 \$35371 NWELL PWELL BULK MUX2_X1
X$62449 \$33033 \$26327 \$33034 \$32464 NWELL PWELL BULK MUX2_X1
X$62452 \$33396 \$26327 \$33031 \$32463 NWELL PWELL BULK MUX2_X1
X$62457 \$38509 \$26327 \$37728 \$38514 NWELL PWELL BULK MUX2_X1
X$62460 \$30359 \$26327 \$30200 \$30199 NWELL PWELL BULK MUX2_X1
X$62462 \$32628 \$26327 \$31705 \$32453 NWELL PWELL BULK MUX2_X1
X$62465 \$33835 \$26327 \$33276 \$34124 NWELL PWELL BULK MUX2_X1
X$62468 \$38899 \$26327 \$38719 \$38718 NWELL PWELL BULK MUX2_X1
X$62470 \$40323 \$26327 \$39788 \$40131 NWELL PWELL BULK MUX2_X1
X$62472 \$37430 \$26327 \$36480 \$37429 NWELL PWELL BULK MUX2_X1
X$62474 \$31724 \$26327 \$31726 \$32291 NWELL PWELL BULK MUX2_X1
X$62476 \$30983 \$26327 \$29846 \$31165 NWELL PWELL BULK MUX2_X1
X$62478 \$30980 \$26327 \$30976 \$30978 NWELL PWELL BULK MUX2_X1
X$62480 \$36029 \$26327 \$35205 \$36250 NWELL PWELL BULK MUX2_X1
X$62482 \$36498 \$26327 \$36497 \$37232 NWELL PWELL BULK MUX2_X1
X$62485 \$39231 \$26327 \$38749 \$39487 NWELL PWELL BULK MUX2_X1
X$62487 \$29864 \$26327 \$28461 \$29359 NWELL PWELL BULK MUX2_X1
X$62490 \$28469 \$26327 \$29098 \$28958 NWELL PWELL BULK MUX2_X1
X$62492 \$32091 \$26327 \$32465 \$32302 NWELL PWELL BULK MUX2_X1
X$62494 \$31476 \$26327 \$31179 \$31174 NWELL PWELL BULK MUX2_X1
X$62496 \$26327 \$27759 NWELL PWELL BULK BUF_X8
X$62499 \$29906 \$26327 \$29689 \$29417 NWELL PWELL BULK MUX2_X1
X$62536 M0_AXI_AWSIZE[1] \$26329 NWELL PWELL BULK BUF_X1
X$62538 \$26329 \$26335 \$27355 \$27926 NWELL PWELL BULK MUX2_X1
X$62541 \$27353 \$26372 \$26329 \$27032 NWELL PWELL BULK MUX2_X1
X$62544 \$26522 \$26524 \$26329 \$26330 NWELL PWELL BULK MUX2_X1
X$62553 \$41152 \$26331 \$41151 \$40695 NWELL PWELL BULK MUX2_X1
X$62556 \$41149 \$26331 \$40692 \$40691 NWELL PWELL BULK MUX2_X1
X$62558 \$30443 \$26331 \$29848 \$30747 NWELL PWELL BULK MUX2_X1
X$62561 \$32280 \$26331 \$31912 \$31722 NWELL PWELL BULK MUX2_X1
X$62563 \$30980 \$26331 \$30213 \$31474 NWELL PWELL BULK MUX2_X1
X$62566 \$31871 \$26331 \$31712 \$32082 NWELL PWELL BULK MUX2_X1
X$62568 \$30390 \$26331 \$30204 \$31125 NWELL PWELL BULK MUX2_X1
X$62570 \$37733 \$26331 \$37734 \$37983 NWELL PWELL BULK MUX2_X1
X$62572 \$33033 \$26331 \$33036 \$33611 NWELL PWELL BULK MUX2_X1
X$62575 \$33041 \$26331 \$34113 \$33634 NWELL PWELL BULK MUX2_X1
X$62578 \$34073 \$26331 \$33826 \$34599 NWELL PWELL BULK MUX2_X1
X$62580 \$36498 \$26331 \$36503 \$36504 NWELL PWELL BULK MUX2_X1
X$62582 \$33396 \$26331 \$33397 \$34059 NWELL PWELL BULK MUX2_X1
X$62584 \$31476 \$26331 \$32294 \$31941 NWELL PWELL BULK MUX2_X1
X$62587 \$28621 \$26331 \$28940 \$29873 NWELL PWELL BULK MUX2_X1
X$62590 \$33655 \$26331 \$34418 \$34136 NWELL PWELL BULK MUX2_X1
X$62593 \$33835 \$26331 \$33412 \$34132 NWELL PWELL BULK MUX2_X1
X$62596 \$37717 \$26331 \$36481 \$37572 NWELL PWELL BULK MUX2_X1
X$62599 \$30368 \$26331 \$30370 \$30134 NWELL PWELL BULK MUX2_X1
X$62601 \$27033 \$26331 \$27940 \$27356 NWELL PWELL BULK MUX2_X1
X$62604 \$31105 \$26331 \$31107 \$31464 NWELL PWELL BULK MUX2_X1
X$62606 \$26338 \$26331 \$26340 \$26339 NWELL PWELL BULK MUX2_X1
X$62608 \$27171 \$26331 \$27037 \$27184 NWELL PWELL BULK MUX2_X1
X$62613 \$33044 \$26331 \$32725 \$33287 NWELL PWELL BULK MUX2_X1
X$62615 \$38722 \$26331 \$39211 \$39212 NWELL PWELL BULK MUX2_X1
X$62618 \$40268 \$26331 \$40270 \$40271 NWELL PWELL BULK MUX2_X1
X$62620 \$38720 \$26331 \$39394 \$39772 NWELL PWELL BULK MUX2_X1
X$62622 \$36260 \$26331 \$35206 \$36031 NWELL PWELL BULK MUX2_X1
X$62624 \$37058 \$26331 \$36021 \$36484 NWELL PWELL BULK MUX2_X1
X$62626 \$38737 \$26331 \$39220 \$39451 NWELL PWELL BULK MUX2_X1
X$62628 \$33020 \$26331 \$33171 \$32640 NWELL PWELL BULK MUX2_X1
X$62631 \$32455 \$26331 \$32456 \$33188 NWELL PWELL BULK MUX2_X1
X$62634 \$31724 \$26331 \$31725 \$33632 NWELL PWELL BULK MUX2_X1
X$62636 \$40672 \$26331 \$41300 \$40874 NWELL PWELL BULK MUX2_X1
X$62638 \$40341 \$26331 \$40344 \$40873 NWELL PWELL BULK MUX2_X1
X$62640 \$30983 \$26331 \$29683 \$31169 NWELL PWELL BULK MUX2_X1
X$62642 \$31717 \$26331 \$32672 \$32085 NWELL PWELL BULK MUX2_X1
X$62644 \$34700 \$26331 \$34589 \$35203 NWELL PWELL BULK MUX2_X1
X$62646 \$35198 \$26331 \$35672 \$35392 NWELL PWELL BULK MUX2_X1
X$62648 \$36029 \$26331 \$35403 \$36267 NWELL PWELL BULK MUX2_X1
X$62650 \$40688 \$26331 \$40689 \$40921 NWELL PWELL BULK MUX2_X1
X$62652 \$39231 \$26331 \$38750 \$39984 NWELL PWELL BULK MUX2_X1
X$62655 \$39237 \$26331 \$40358 \$39507 NWELL PWELL BULK MUX2_X1
X$62658 \$26692 \$26331 NWELL PWELL BULK BUF_X16
X$62660 \$29864 \$26331 \$30031 \$29874 NWELL PWELL BULK MUX2_X1
X$62662 \$30986 \$26331 \$31193 \$31644 NWELL PWELL BULK MUX2_X1
X$62664 \$32091 \$26331 \$32715 \$32719 NWELL PWELL BULK MUX2_X1
X$62667 \$40398 \$26331 \$40143 \$39802 NWELL PWELL BULK MUX2_X1
X$62669 \$41716 \$26331 \$41156 \$40975 NWELL PWELL BULK MUX2_X1
X$62672 \$41368 \$26331 \$41371 \$41714 NWELL PWELL BULK MUX2_X1
X$62727 \$26332 \$27356 \$27255 \$27943 NWELL PWELL BULK MUX2_X2
X$62729 \$40806 \$26335 \$41156 \$41719 NWELL PWELL BULK MUX2_X1
X$62731 \$42180 \$26335 \$42182 \$42391 NWELL PWELL BULK MUX2_X1
X$62733 \$29846 \$26335 \$29848 \$29352 NWELL PWELL BULK MUX2_X1
X$62736 \$30200 \$26335 \$30868 \$30864 NWELL PWELL BULK MUX2_X1
X$62738 \$48199 \$26335 \$48473 \$48471 NWELL PWELL BULK MUX2_X1
X$62741 \$46737 \$26335 \$46988 \$46997 NWELL PWELL BULK MUX2_X1
X$62743 \$46304 \$26335 \$46335 \$46327 NWELL PWELL BULK MUX2_X1
X$62745 \$33034 \$26335 \$33826 \$34079 NWELL PWELL BULK MUX2_X1
X$62747 \$31726 \$26335 \$34113 \$34104 NWELL PWELL BULK MUX2_X1
X$62750 \$32465 \$26335 \$32725 \$32094 NWELL PWELL BULK MUX2_X1
X$62752 \$31179 \$26335 \$31193 \$31650 NWELL PWELL BULK MUX2_X1
X$62755 \$44359 \$26335 \$48351 \$48173 NWELL PWELL BULK MUX2_X1
X$62757 \$42499 \$26335 \$45796 \$45790 NWELL PWELL BULK MUX2_X1
X$62759 \$42619 \$26335 \$47301 \$47157 NWELL PWELL BULK MUX2_X1
X$62762 \$46006 \$26335 \$47282 \$46840 NWELL PWELL BULK MUX2_X1
X$62765 \$30042 \$29126 \$27772 \$26335 NWELL PWELL BULK NAND3_X4
X$62768 \$32086 \$26335 \$32021 \$31494 NWELL PWELL BULK MUX2_X1
X$62772 \$43492 \$26335 \$47704 \$47703 NWELL PWELL BULK MUX2_X1
X$62774 \$29098 \$26335 \$29409 \$29893 NWELL PWELL BULK MUX2_X1
X$62776 \$37728 \$26335 \$40321 \$39948 NWELL PWELL BULK MUX2_X1
X$62778 \$48582 \$26335 \$48913 \$48205 NWELL PWELL BULK MUX2_X1
X$62780 \$48427 \$26335 \$48196 \$48446 NWELL PWELL BULK MUX2_X1
X$62782 \$47187 \$26335 \$47190 \$48094 NWELL PWELL BULK MUX2_X1
X$62784 \$48179 \$26335 \$48180 \$48799 NWELL PWELL BULK MUX2_X1
X$62786 \$47508 \$26335 \$47968 \$47622 NWELL PWELL BULK MUX2_X1
X$62788 \$45339 \$26335 \$48359 \$48363 NWELL PWELL BULK MUX2_X1
X$62790 \$44899 \$26335 \$44803 \$44492 NWELL PWELL BULK MUX2_X1
X$62793 \$31461 \$26335 \$32240 \$31874 NWELL PWELL BULK MUX2_X1
X$62795 \$33276 \$26335 \$34418 \$34960 NWELL PWELL BULK MUX2_X1
X$62798 \$38719 \$26335 \$40654 \$40653 NWELL PWELL BULK MUX2_X1
X$62801 \$36497 \$26335 \$37734 \$38366 NWELL PWELL BULK MUX2_X1
X$62803 \$36480 \$26335 \$36670 \$36661 NWELL PWELL BULK MUX2_X1
X$62806 \$31705 \$26335 \$33547 \$33553 NWELL PWELL BULK MUX2_X1
X$62809 \$39788 \$26335 \$40871 \$40675 NWELL PWELL BULK MUX2_X1
X$62811 \$30976 \$26335 \$31912 \$31719 NWELL PWELL BULK MUX2_X1
X$62813 \$33031 \$26335 \$32672 \$32269 NWELL PWELL BULK MUX2_X1
X$62815 \$34902 \$26335 \$34589 \$34396 NWELL PWELL BULK MUX2_X1
X$62817 \$35205 \$26335 \$35206 \$35406 NWELL PWELL BULK MUX2_X1
X$62819 \$38749 \$26335 \$40358 \$40892 NWELL PWELL BULK MUX2_X1
X$62822 \$28461 \$26335 \$28940 \$29371 NWELL PWELL BULK MUX2_X1
X$62824 \$41254 \$26335 \$43485 \$43488 NWELL PWELL BULK MUX2_X1
X$62828 \$40684 \$26335 \$40692 \$40929 NWELL PWELL BULK MUX2_X1
X$62831 \$40142 \$26335 \$40143 \$40418 NWELL PWELL BULK MUX2_X1
X$62833 \$42517 \$26335 \$42717 \$42371 NWELL PWELL BULK MUX2_X1
X$62835 \$29689 \$26335 \$30038 \$30037 NWELL PWELL BULK MUX2_X1
X$62838 \$27051 \$26335 \$28992 \$28986 NWELL PWELL BULK MUX2_X1
X$62840 \$29427 \$26335 \$29922 \$29919 NWELL PWELL BULK MUX2_X1
X$62914 \$27184 \$26339 \$27255 \$27186 NWELL PWELL BULK MUX2_X2
X$62973 \$43082 \$26372 \$42517 \$43083 NWELL PWELL BULK MUX2_X1
X$62975 \$42526 \$26372 \$42180 \$42759 NWELL PWELL BULK MUX2_X1
X$62977 \$40398 \$26372 \$40142 \$40403 NWELL PWELL BULK MUX2_X1
X$62979 \$30443 \$26372 \$29846 \$30448 NWELL PWELL BULK MUX2_X1
X$62981 \$30202 \$26372 \$30200 \$30737 NWELL PWELL BULK MUX2_X1
X$62985 \$47753 \$26372 \$46737 \$47181 NWELL PWELL BULK MUX2_X1
X$62988 \$48462 \$26372 \$48199 \$48882 NWELL PWELL BULK MUX2_X1
X$62991 \$31876 \$26372 \$31461 \$31708 NWELL PWELL BULK MUX2_X1
X$62994 \$32227 \$26372 \$31705 \$32080 NWELL PWELL BULK MUX2_X1
X$62997 \$47430 \$26372 \$47187 \$47778 NWELL PWELL BULK MUX2_X1
X$63000 \$36260 \$26372 \$35205 \$36506 NWELL PWELL BULK MUX2_X1
X$63002 \$37733 \$26372 \$36497 \$37439 NWELL PWELL BULK MUX2_X1
X$63005 \$34073 \$26372 \$33034 \$34592 NWELL PWELL BULK MUX2_X1
X$63009 \$46834 \$26372 \$46006 \$46716 NWELL PWELL BULK MUX2_X1
X$63011 \$47629 \$26372 \$42619 \$47293 NWELL PWELL BULK MUX2_X1
X$63013 \$32410 \$26372 \$32086 \$31747 NWELL PWELL BULK MUX2_X1
X$63015 \$48919 \$26372 \$48582 \$48595 NWELL PWELL BULK MUX2_X1
X$63017 \$48380 \$26372 \$48179 \$48377 NWELL PWELL BULK MUX2_X1
X$63019 \$29119 \$26372 \$29098 \$29390 NWELL PWELL BULK MUX2_X1
X$63021 \$33655 \$26372 \$33276 \$33657 NWELL PWELL BULK MUX2_X1
X$63024 \$33044 \$26372 \$32465 \$33660 NWELL PWELL BULK MUX2_X1
X$63027 \$37191 \$26372 \$36480 \$37194 NWELL PWELL BULK MUX2_X1
X$63029 \$48072 \$26372 \$48427 \$47868 NWELL PWELL BULK MUX2_X1
X$63032 \$47008 \$26372 \$46304 \$46442 NWELL PWELL BULK MUX2_X1
X$63034 \$45371 \$26372 \$42499 \$45368 NWELL PWELL BULK MUX2_X1
X$63037 \$46934 \$26372 \$43492 \$46729 NWELL PWELL BULK MUX2_X1
X$63040 \$48765 \$26372 \$44359 \$48559 NWELL PWELL BULK MUX2_X1
X$63042 \$48311 \$26372 \$47508 \$47950 NWELL PWELL BULK MUX2_X1
X$63044 \$44159 \$26372 \$44899 \$44255 NWELL PWELL BULK MUX2_X1
X$63047 \$48775 \$26372 \$45339 \$48772 NWELL PWELL BULK MUX2_X1
X$63052 \$40262 \$26372 \$38719 \$40118 NWELL PWELL BULK MUX2_X1
X$63055 \$38549 \$26372 \$37728 \$38361 NWELL PWELL BULK MUX2_X1
X$63057 \$32280 \$26372 \$30976 \$32087 NWELL PWELL BULK MUX2_X1
X$63059 \$39237 \$26372 \$38749 \$40351 NWELL PWELL BULK MUX2_X1
X$63061 \$33041 \$26372 \$31726 \$33253 NWELL PWELL BULK MUX2_X1
X$63063 \$31717 \$26372 \$33031 \$31898 NWELL PWELL BULK MUX2_X1
X$63066 \$34700 \$26372 \$34902 \$34697 NWELL PWELL BULK MUX2_X1
X$63068 \$39485 \$26372 \$39788 \$39970 NWELL PWELL BULK MUX2_X1
X$63070 \$30231 \$26372 \$29689 \$30192 NWELL PWELL BULK MUX2_X1
X$63072 \$28621 \$26372 \$28461 \$28930 NWELL PWELL BULK MUX2_X1
X$63074 \$43481 \$26372 \$41254 \$43482 NWELL PWELL BULK MUX2_X1
X$63076 \$30986 \$26372 \$31179 \$31629 NWELL PWELL BULK MUX2_X1
X$63080 \$41149 \$26372 \$40684 \$41494 NWELL PWELL BULK MUX2_X1
X$63082 \$41716 \$26372 \$40806 \$41712 NWELL PWELL BULK MUX2_X1
X$63084 \$27772 \$29693 \$29126 \$26372 NWELL PWELL BULK AND3_X4
X$63087 \$28999 \$26372 \$29427 \$29428 NWELL PWELL BULK MUX2_X1
X$63089 \$27384 \$26372 \$27051 \$27655 NWELL PWELL BULK MUX2_X1
X$63185 \$27055 \$26375 \$27255 \$27257 NWELL PWELL BULK MUX2_X2
X$63195 \$27696 \$26382 \$27057 \$27268 NWELL PWELL BULK AOI21_X1
X$63197 \$26382 \$27694 \$28141 \$28138 \$27784 NWELL PWELL BULK FA_X1
X$63204 \$28151 \$26385 \$27400 \$27290 NWELL PWELL BULK MUX2_X1
X$63206 \$26385 \$27398 \$27787 NWELL PWELL BULK NAND2_X1
X$63208 \$26387 \$26385 \$28145 \$27785 NWELL PWELL BULK MUX2_X1
X$63210 \$27060 \$26385 \$27061 \$27277 NWELL PWELL BULK MUX2_X1
X$63214 \$26385 \$26731 NWELL PWELL BULK INV_X1
X$63232 \$26393 \$27064 \$26766 NWELL PWELL BULK NOR2_X1
X$63242 \$27419 \$27070 \$26399 NWELL PWELL BULK NAND2_X2
X$63251 \$26405 \$30068 NWELL PWELL BULK INV_X1
X$63255 \$31379 \$30263 \$27820 \$26405 NWELL PWELL BULK DFF_X2
X$63261 \$29029 \$26405 \$28499 NWELL PWELL BULK NAND2_X2
X$63275 \$28752 \$26406 NWELL PWELL BULK INV_X1
X$63277 \$29719 \$26406 \$27822 \$29984 NWELL PWELL BULK AOI21_X1
X$63284 \$27338 \$30068 \$26406 \$30161 NWELL PWELL BULK NAND3_X1
X$63296 \$26416 \$26882 \$26890 \$26419 \$26868 NWELL PWELL BULK AOI22_X2
X$63298 \$26420 \$26418 \$29640 NWELL PWELL BULK NOR2_X4
X$63300 \$58014 \$57723 \$26418 \$57298 \$57299 NWELL PWELL BULK AOI22_X4
X$63303 \$57116 \$26418 \$57304 \$42137 NWELL PWELL BULK OAI21_X2
X$63305 \$58076 \$58094 \$26420 \$26418 NWELL PWELL BULK AOI21_X4
X$63307 \$27665 \$27663 \$26420 \$26418 \$26890 NWELL PWELL BULK NOR4_X1
X$63312 \$26418 \$26420 \$28294 \$28299 \$27671 \$26813 \$27829 NWELL PWELL
+ BULK OAI33_X1
X$63315 \$27663 \$26420 \$26418 \$27438 \$28305 NWELL PWELL BULK NOR4_X2
X$63319 \$28513 \$26420 \$26418 \$27097 NWELL PWELL BULK NOR3_X2
X$63321 \$28513 \$26418 \$26420 \$53244 NWELL PWELL BULK OAI21_X4
X$63347 \$26419 \$27097 \$28512 \$28997 NWELL PWELL BULK NAND3_X1
X$63349 \$28512 \$27097 \$26419 \$29721 NWELL PWELL BULK AND3_X1
X$63359 \$58091 \$26420 \$41826 NWELL PWELL BULK NOR2_X1
X$63362 \$58092 \$58468 \$26420 NWELL PWELL BULK NOR2_X4
X$63393 \$26423 \$27096 \$27443 \$27093 NWELL PWELL BULK OAI21_X2
X$63396 \$27443 \$27096 \$26425 \$28294 NWELL PWELL BULK OAI21_X1
X$63398 \$26426 \$27098 NWELL PWELL BULK INV_X1
X$63403 \$26426 \$30582 \$29552 NWELL PWELL BULK XNOR2_X1
X$63428 \$27806 \$28227 \$27428 \$26438 NWELL PWELL BULK NOR3_X4
X$63488 \$27839 \$31782 \$32157 \$26467 \$27835 \$32158 NWELL PWELL BULK
+ OAI221_X1
X$63499 \$27839 \$27847 \$32157 \$26469 \$27835 \$32996 NWELL PWELL BULK
+ OAI221_X1
X$63560 \$26732 \$26736 \$26496 NWELL PWELL BULK XOR2_X1
X$63567 \$26499 \$26736 \$26498 \$26740 \$26497 NWELL PWELL BULK FA_X1
X$63584 \$26581 \$27957 \$26504 NWELL PWELL BULK NAND2_X2
X$63588 \$26504 \$28825 \$29270 NWELL PWELL BULK NAND2_X1
X$63590 \$26504 \$27513 \$27905 NWELL PWELL BULK NAND2_X1
X$63592 \$26504 \$27900 NWELL PWELL BULK INV_X2
X$63595 \$26504 \$28545 \$28808 NWELL PWELL BULK NAND2_X1
X$63598 \$26504 \$27531 \$27903 NWELL PWELL BULK NAND2_X1
X$63601 \$26504 \$27510 \$28024 NWELL PWELL BULK NAND2_X1
X$63614 \$26509 \$26598 \$26592 \$26581 NWELL PWELL BULK NAND3_X1
X$63630 S0_AXI_BVALID \$26545 NWELL PWELL BULK BUF_X1
X$63639 \$29683 \$26524 \$29846 \$30216 NWELL PWELL BULK MUX2_X1
X$63642 \$30031 \$26524 \$28461 \$30461 NWELL PWELL BULK MUX2_X1
X$63644 \$31725 \$26524 \$31726 \$31923 NWELL PWELL BULK MUX2_X1
X$63647 \$31106 \$26524 \$30200 \$30839 NWELL PWELL BULK MUX2_X1
X$63650 \$31707 \$26524 \$31461 \$31860 NWELL PWELL BULK MUX2_X1
X$63653 \$35403 \$26524 \$35205 \$35400 NWELL PWELL BULK MUX2_X1
X$63655 \$35672 \$26524 \$34902 \$36243 NWELL PWELL BULK MUX2_X1
X$63657 \$32294 \$26524 \$31179 \$32298 NWELL PWELL BULK MUX2_X1
X$63660 \$28470 \$26524 \$29098 \$28053 NWELL PWELL BULK MUX2_X1
X$63663 \$33412 \$26524 \$33276 \$33644 NWELL PWELL BULK MUX2_X1
X$63665 \$32715 \$26524 \$32465 \$32717 NWELL PWELL BULK MUX2_X1
X$63668 \$39393 \$26524 \$38719 \$39390 NWELL PWELL BULK MUX2_X1
X$63671 \$39774 \$26524 \$37728 \$39913 NWELL PWELL BULK MUX2_X1
X$63673 \$40866 \$26524 \$39788 \$41293 NWELL PWELL BULK MUX2_X1
X$63675 \$36652 \$26524 \$36480 \$36651 NWELL PWELL BULK MUX2_X1
X$63679 \$33974 \$26524 \$31705 \$33534 NWELL PWELL BULK MUX2_X1
X$63682 \$30213 \$26524 \$30976 \$30212 NWELL PWELL BULK MUX2_X1
X$63685 \$33397 \$26524 \$33031 \$33594 NWELL PWELL BULK MUX2_X1
X$63687 \$36503 \$26524 \$36497 \$36501 NWELL PWELL BULK MUX2_X1
X$63689 \$40689 \$26524 \$40684 \$41147 NWELL PWELL BULK MUX2_X1
X$63691 \$38750 \$26524 \$38749 \$39501 NWELL PWELL BULK MUX2_X1
X$63693 \$33036 \$26524 \$33034 \$33601 NWELL PWELL BULK MUX2_X1
X$63695 \$26524 \$27383 NWELL PWELL BULK BUF_X8
X$63764 \$26581 M2_AXI_BVALID NWELL PWELL BULK BUF_X1
X$63782 \$26594 \$46211 NWELL PWELL BULK INV_X1
X$63785 \$26594 \$38363 \$38978 \$46576 NWELL PWELL BULK NOR3_X1
X$63787 \$46423 \$37065 \$26594 \$46590 NWELL PWELL BULK OAI21_X2
X$63815 \$36039 \$36524 \$37072 \$26622 \$37748 NWELL PWELL BULK AOI22_X2
X$63819 \$26622 \$38632 NWELL PWELL BULK INV_X1
X$63837 \$26634 \$28049 NWELL PWELL BULK INV_X1
X$63839 \$26634 \$27503 \$28054 NWELL PWELL BULK XOR2_X1
X$63854 \$26648 S2_AXI_ARID[1] NWELL PWELL BULK BUF_X1
X$63893 \$27764 \$26692 \$27765 \$27766 NWELL PWELL BULK MUX2_X1
X$63896 \$30231 \$26692 \$30038 \$30232 NWELL PWELL BULK MUX2_X1
X$63898 \$28058 \$26692 \$28057 \$28650 NWELL PWELL BULK MUX2_X1
X$63901 \$31242 \$26692 \$30959 \$31251 NWELL PWELL BULK MUX2_X1
X$63904 \$28083 \$26692 \$28075 \$27055 NWELL PWELL BULK MUX2_X1
X$63906 \$29437 \$26692 \$29438 \$31246 NWELL PWELL BULK MUX2_X1
X$63908 \$29119 \$26692 \$29409 \$29899 NWELL PWELL BULK MUX2_X1
X$63913 \$28469 \$26692 \$28470 \$28707 NWELL PWELL BULK MUX2_X1
X$63917 \$29906 \$26692 \$29421 \$30036 NWELL PWELL BULK MUX2_X1
X$63919 \$26692 \$31495 NWELL PWELL BULK BUF_X16
X$63974 \$26732 \$26740 NWELL PWELL BULK INV_X1
X$64020 \$27075 \$26780 \$27803 \$27806 NWELL PWELL BULK AND3_X2
X$64022 \$26780 \$27075 \$27803 \$27805 NWELL PWELL BULK NAND3_X4
X$64024 \$26780 \$28484 \$27075 \$29149 NWELL PWELL BULK NAND3_X1
X$64030 \$26785 \$27798 \$27419 NWELL PWELL BULK OR2_X1
X$64032 \$27798 \$26785 \$27804 NWELL PWELL BULK NOR2_X1
X$64036 \$29150 \$26785 \$28227 NWELL PWELL BULK NOR2_X2
X$64041 \$29987 \$26785 \$27077 NWELL PWELL BULK OR2_X1
X$64043 \$26785 \$29150 \$28658 NWELL PWELL BULK OR2_X2
X$64230 M0_AXI_AWID[0] \$27051 NWELL PWELL BULK CLKBUF_X2
X$64233 \$27761 \$27383 \$27051 \$28060 NWELL PWELL BULK MUX2_X1
X$64236 \$27760 \$27759 \$27051 \$28056 NWELL PWELL BULK MUX2_X1
X$64255 \$27056 \$28138 NWELL PWELL BULK INV_X1
X$64257 \$27056 \$27694 \$27267 NWELL PWELL BULK XOR2_X1
X$64265 \$27783 \$27057 \$27784 \$28677 NWELL PWELL BULK MUX2_X1
X$64268 \$27057 \$28141 \$27696 NWELL PWELL BULK NOR2_X1
X$64270 \$27267 \$27057 \$27691 NWELL PWELL BULK NOR2_X1
X$64275 \$27060 \$27397 \$27283 \$27398 NWELL PWELL BULK HA_X1
X$64303 \$27067 \$27794 \$28730 NWELL PWELL BULK NOR2_X1
X$64312 \$27070 \$27406 \$27797 NWELL PWELL BULK NAND2_X1
X$64314 \$27079 \$27070 \$27080 NWELL PWELL BULK NOR2_X1
X$64322 \$27074 \$29145 \$30170 \$29980 NWELL PWELL BULK OAI21_X1
X$64340 \$27077 \$27406 \$28198 NWELL PWELL BULK NAND2_X1
X$64342 \$27077 \$27079 NWELL PWELL BULK INV_X1
X$64372 \$28658 \$27805 \$27090 NWELL PWELL BULK NAND2_X1
X$64377 \$27428 \$27090 \$27430 NWELL PWELL BULK NAND2_X1
X$64384 \$29626 \$29168 \$29169 \$27091 NWELL PWELL BULK OAI21_X4
X$64394 \$28507 \$27823 \$27091 \$29720 NWELL PWELL BULK NOR3_X1
X$64405 \$27096 \$27443 \$28513 NWELL PWELL BULK NOR2_X2
X$64411 \$55494 \$55495 \$56228 \$55492 \$27096 NWELL PWELL BULK AOI211_X2
X$64416 \$27098 \$27096 \$27443 \$27834 NWELL PWELL BULK OAI21_X2
X$64419 \$27096 \$54970 \$55425 NWELL PWELL BULK NOR2_X1
X$64432 \$27096 \$27443 \$28512 \$27663 NWELL PWELL BULK OAI21_X1
X$64437 \$29956 \$29726 \$28512 \$27097 \$30083 NWELL PWELL BULK NAND4_X4
X$64481 \$27867 \$27479 \$27866 \$27130 NWELL PWELL BULK AOI21_X1
X$64515 \$27898 \$27503 \$27897 \$28049 \$27143 NWELL PWELL BULK FA_X1
X$64518 \$28050 \$27504 \$27143 \$27179 NWELL PWELL BULK MUX2_X1
X$64558 \$33384 \$27186 \$34061 \$33386 \$33392 NWELL PWELL BULK OAI22_X2
X$64562 \$27186 \$38724 \$39463 NWELL PWELL BULK NOR2_X1
X$64564 \$27186 \$38355 \$35140 \$38968 NWELL PWELL BULK NOR3_X1
X$64607 M1_AXI_AWADDR[29] \$27222 NWELL PWELL BULK BUF_X1
X$64648 \$34462 \$27239 \$37369 NWELL PWELL BULK AND2_X1
X$64651 \$27239 \$35722 NWELL PWELL BULK INV_X2
X$64654 \$27239 \$34195 \$35038 NWELL PWELL BULK NOR2_X1
X$64658 \$33048 \$33852 \$33853 \$27239 \$34179 \$32322 \$34664 NWELL PWELL
+ BULK OAI33_X1
X$64663 \$30752 \$36524 \$37072 \$27239 \$38659 NWELL PWELL BULK AOI22_X2
X$64692 \$42518 \$42723 \$27255 \$35465 NWELL PWELL BULK MUX2_X2
X$64694 \$31268 \$27255 NWELL PWELL BULK BUF_X16
X$64697 \$41714 \$40975 \$27255 \$35915 NWELL PWELL BULK MUX2_X2
X$64700 \$41858 \$42078 \$27255 \$35943 NWELL PWELL BULK MUX2_X2
X$64702 \$40921 \$40691 \$27255 \$36046 NWELL PWELL BULK MUX2_X2
X$64705 \$40695 \$39802 \$27255 \$35417 NWELL PWELL BULK MUX2_X2
X$64707 \$31169 \$30747 \$27255 \$31622 NWELL PWELL BULK MUX2_X2
X$64709 \$31474 \$31722 \$27255 \$31924 NWELL PWELL BULK MUX2_X2
X$64711 \$30134 \$31125 \$27255 \$31137 NWELL PWELL BULK MUX2_X2
X$64713 \$36267 \$36031 \$27255 \$35682 NWELL PWELL BULK MUX2_X2
X$64715 \$36504 \$37983 \$27255 \$36039 NWELL PWELL BULK MUX2_X2
X$64717 \$33611 \$34599 \$27255 \$34706 NWELL PWELL BULK MUX2_X2
X$64719 \$35392 \$35203 \$27255 \$36045 NWELL PWELL BULK MUX2_X2
X$64722 \$34059 \$32085 \$27255 \$33398 NWELL PWELL BULK MUX2_X2
X$64724 \$31941 \$31644 \$27255 \$31949 NWELL PWELL BULK MUX2_X2
X$64726 \$29874 \$29873 \$27255 \$30218 NWELL PWELL BULK MUX2_X2
X$64729 \$30036 \$30232 \$27255 \$30752 NWELL PWELL BULK MUX2_X2
X$64731 \$28650 \$27766 \$27255 \$28993 NWELL PWELL BULK MUX2_X2
X$64733 \$31251 \$31246 \$27255 \$31257 NWELL PWELL BULK MUX2_X2
X$64740 \$28707 \$29899 \$27255 \$30033 NWELL PWELL BULK MUX2_X2
X$64743 \$33632 \$33634 \$27255 \$33411 NWELL PWELL BULK MUX2_X2
X$64745 \$34132 \$34136 \$27255 \$34721 NWELL PWELL BULK MUX2_X2
X$64747 \$32719 \$33287 \$27255 \$33664 NWELL PWELL BULK MUX2_X2
X$64751 \$32640 \$27255 \$33188 \$33024 NWELL PWELL BULK MUX2_X1
X$64754 \$39984 \$39507 \$27255 \$34403 NWELL PWELL BULK MUX2_X2
X$64756 \$39212 \$39451 \$27255 \$39954 NWELL PWELL BULK MUX2_X2
X$64759 \$39772 \$40271 \$27255 \$40122 NWELL PWELL BULK MUX2_X2
X$64763 \$31464 \$27255 \$32082 \$33385 NWELL PWELL BULK MUX2_X1
X$64766 \$37572 \$27255 \$36484 \$37721 NWELL PWELL BULK MUX2_X1
X$64768 \$40874 \$27255 \$40873 \$41142 NWELL PWELL BULK MUX2_X1
X$64770 \$27255 \$30036 \$31228 NWELL PWELL BULK OR2_X1
X$64772 \$27255 \$31691 NWELL PWELL BULK INV_X1
X$64823 \$33384 \$27257 \$49793 \$34764 \$49503 NWELL PWELL BULK OAI22_X2
X$64826 \$27257 \$38724 \$51320 NWELL PWELL BULK NOR2_X1
X$64828 \$27257 \$39834 \$37129 \$36426 \$49514 \$48226 NWELL PWELL BULK
+ OAI221_X1
X$64831 \$27257 \$38803 \$35140 \$51997 NWELL PWELL BULK NOR3_X1
X$64894 \$27409 \$27406 \$27301 \$27719 NWELL PWELL BULK AOI21_X1
X$64898 \$27301 \$29980 \$30173 \$29145 \$29981 NWELL PWELL BULK AOI22_X1
X$64900 \$27406 \$27301 \$27794 \$28732 NWELL PWELL BULK OAI21_X1
X$64924 \$29715 \$27338 NWELL PWELL BULK INV_X2
X$64927 \$27338 \$28759 \$28278 NWELL PWELL BULK NOR2_X2
X$64930 \$28759 \$27338 \$29029 NWELL PWELL BULK OR2_X1
X$64934 \$30070 \$27338 \$30160 NWELL PWELL BULK NOR2_X1
X$64937 \$27338 \$30647 \$30283 NWELL PWELL BULK OR2_X1
X$64939 \$27665 \$30160 \$27338 \$30279 NWELL PWELL BULK AOI21_X4
X$64942 \$27338 \$30286 \$29978 NWELL PWELL BULK OR2_X1
X$64997 \$30502 \$27383 \$29427 \$30234 NWELL PWELL BULK MUX2_X1
X$65004 \$29126 \$29693 \$27773 \$27383 NWELL PWELL BULK NOR3_X4
X$65006 \$29421 \$27383 \$29689 \$29416 NWELL PWELL BULK MUX2_X1
X$65008 \$30187 \$27383 NWELL PWELL BULK BUF_X8
X$65023 \$27772 \$27387 \$27768 NWELL PWELL BULK NAND2_X1
X$65028 \$27767 \$27389 \$28104 \$28109 NWELL PWELL BULK HA_X1
X$65030 \$27773 \$27389 \$28100 NWELL PWELL BULK NAND2_X1
X$65033 \$27772 \$27389 \$30241 NWELL PWELL BULK NAND2_X1
X$65037 \$27772 \$27390 \$27391 NWELL PWELL BULK NAND2_X1
X$65040 \$27390 \$28111 \$28107 NWELL PWELL BULK XOR2_X1
X$65056 \$28148 \$27787 \$27400 \$28674 NWELL PWELL BULK MUX2_X1
X$65084 \$27419 \$28185 \$28196 NWELL PWELL BULK NAND2_X1
X$65089 \$28196 \$27421 NWELL PWELL BULK INV_X1
X$65098 \$28497 \$27422 \$29055 \$29582 NWELL PWELL BULK AOI21_X2
X$65100 \$28743 \$28658 \$27805 \$27422 \$29156 NWELL PWELL BULK NAND4_X1
X$65102 \$29158 \$27422 \$27835 NWELL PWELL BULK OR2_X4
X$65105 \$27422 \$28227 \$27806 \$28745 NWELL PWELL BULK OAI21_X2
X$65109 \$28262 \$27422 \$28644 NWELL PWELL BULK NAND2_X1
X$65120 \$27423 \$27804 \$27671 NWELL PWELL BULK NOR2_X1
X$65125 \$29158 \$27426 \$28299 \$29151 NWELL PWELL BULK OAI21_X1
X$65130 \$27426 \$27839 NWELL PWELL BULK BUF_X4
X$65133 \$27807 \$27426 \$29569 NWELL PWELL BULK NAND2_X1
X$65157 \$27428 \$28658 \$27805 \$29158 NWELL PWELL BULK NAND3_X2
X$65167 \$28492 \$27807 \$27429 NWELL PWELL BULK NAND2_X1
X$65187 \$28278 \$27435 \$28499 \$27824 \$28264 NWELL PWELL BULK OAI22_X4
X$65191 \$27435 \$28278 \$27819 NWELL PWELL BULK NOR2_X1
X$65201 \$56234 \$27443 NWELL PWELL BULK BUF_X4
X$65254 \$27860 \$27475 NWELL PWELL BULK INV_X2
X$65260 \$27477 \$27478 \$27479 NWELL PWELL BULK NAND2_X1
X$65263 \$27477 \$27869 \$27870 NWELL PWELL BULK NAND2_X1
X$65265 \$27477 \$28530 \$28912 NWELL PWELL BULK NAND2_X1
X$65267 \$27477 \$29743 \$29207 NWELL PWELL BULK NAND2_X1
X$65269 \$27477 \$28531 NWELL PWELL BULK INV_X2
X$65271 \$27477 \$28790 \$28789 NWELL PWELL BULK NAND2_X1
X$65274 \$28518 \$27477 \$I240990 \$30089 NWELL PWELL BULK HA_X1
X$65286 \$27860 \$27478 \$28317 NWELL PWELL BULK XNOR2_X2
X$65292 \$27867 \$27870 \$27871 \$27481 NWELL PWELL BULK AOI21_X1
X$65327 \$27899 \$27898 \$27504 \$28041 NWELL PWELL BULK AOI21_X1
X$65330 \$27504 \$27897 \$27899 NWELL PWELL BULK NOR2_X1
X$65340 S1_AXI_ARREADY \$27507 NWELL PWELL BULK BUF_X1
X$65347 \$35367 \$34522 \$35373 \$27509 NWELL PWELL BULK DFF_X1
X$65350 \$36704 \$36705 \$36225 \$27509 NWELL PWELL BULK DFF_X1
X$65352 \$37987 \$37173 \$37984 \$27509 NWELL PWELL BULK DFF_X1
X$65354 \$36236 \$36173 \$36235 \$27509 NWELL PWELL BULK DFF_X1
X$65356 \$36722 \$36736 \$36727 \$27509 NWELL PWELL BULK DFF_X1
X$65359 \$34078 \$33949 \$34081 \$27509 NWELL PWELL BULK DFF_X1
X$65361 \$34559 \$34921 \$34563 \$27509 NWELL PWELL BULK DFF_X1
X$65363 \$I177758 \$33945 \$35391 \$27509 NWELL PWELL BULK DFF_X1
X$65366 \$34823 \$35311 \$35386 \$27509 NWELL PWELL BULK DFF_X1
X$65369 \$34827 \$35377 \$35379 \$27509 NWELL PWELL BULK DFF_X1
X$65372 \$32682 \$32596 \$33200 \$27509 NWELL PWELL BULK DFF_X1
X$65375 \$32193 \$33518 \$33144 \$27509 NWELL PWELL BULK DFF_X1
X$65377 \$29749 \$27509 NWELL PWELL BULK BUF_X4
X$65379 \$36175 \$36176 \$36229 \$27509 NWELL PWELL BULK DFF_X1
X$65381 \$I175632 \$33573 \$33581 \$27509 NWELL PWELL BULK DFF_X1
X$65383 \$I175633 \$33140 \$33590 \$27509 NWELL PWELL BULK DFF_X1
X$65386 \$34826 \$33950 \$34909 \$27509 NWELL PWELL BULK DFF_X1
X$65388 \$I175492 \$33143 \$33142 \$27509 NWELL PWELL BULK DFF_X1
X$65390 \$I175673 \$33944 \$34568 \$27509 NWELL PWELL BULK DFF_X1
X$65392 \$I178257 \$28545 \$29764 \$27509 NWELL PWELL BULK DFF_X1
X$65395 \$I174687 \$28840 \$29289 \$27509 NWELL PWELL BULK DFF_X1
X$65398 \$31900 \$32275 \$31904 \$27509 NWELL PWELL BULK DFF_X1
X$65400 \$31817 \$31073 \$31154 \$27509 NWELL PWELL BULK DFF_X1
X$65403 \$32716 \$32704 \$32705 \$27509 NWELL PWELL BULK DFF_X1
X$65406 \$I179163 \$27510 \$28030 \$27509 NWELL PWELL BULK DFF_X1
X$65408 \$32691 \$32698 \$32274 \$27509 NWELL PWELL BULK DFF_X1
X$65411 \$31077 \$31146 \$31587 \$27509 NWELL PWELL BULK DFF_X1
X$65414 \$31080 \$30850 \$30827 \$27509 NWELL PWELL BULK DFF_X1
X$65416 \$31828 \$31826 \$31546 \$27509 NWELL PWELL BULK DFF_X1
X$65418 \$I174276 \$33138 \$33505 \$27509 NWELL PWELL BULK DFF_X1
X$65421 \$31076 \$31075 \$31152 \$27509 NWELL PWELL BULK DFF_X1
X$65539 \$35092 \$27644 \$35284 NWELL PWELL BULK XOR2_X1
X$65541 \$27837 \$34281 \$27644 \$34271 NWELL PWELL BULK AND3_X1
X$65543 \$27644 \$32025 \$34492 NWELL PWELL BULK NOR2_X1
X$65549 \$32479 \$32477 \$33064 \$32122 \$32509 \$30997 \$27654 NWELL PWELL
+ BULK OAI33_X1
X$65551 \$27654 \$32126 NWELL PWELL BULK BUF_X2
X$65593 \$27678 \$30782 \$31025 \$30279 NWELL PWELL BULK AOI21_X2
X$65596 \$30631 \$27678 \$30285 \$30636 NWELL PWELL BULK NAND3_X1
X$65612 \$27780 \$27691 \$27781 NWELL PWELL BULK XNOR2_X1
X$65633 M0_AXI_ARLEN[5] \$27916 NWELL PWELL BULK BUF_X2
X$65646 \$27739 \$27745 \$27741 \$27978 NWELL PWELL BULK MUX2_X1
X$65653 M1_AXI_AWADDR[18] \$27741 NWELL PWELL BULK BUF_X1
X$65665 \$I178885 \$27743 \$27742 \$29099 NWELL PWELL BULK DFF_X1
X$65675 \$29343 \$27745 \$27749 \$29839 NWELL PWELL BULK MUX2_X1
X$65677 \$28455 \$27745 \$27752 \$27753 NWELL PWELL BULK MUX2_X1
X$65680 \$31467 \$27745 \$30971 \$31881 NWELL PWELL BULK MUX2_X1
X$65682 \$29262 \$27745 \$28446 \$29254 NWELL PWELL BULK MUX2_X1
X$65685 \$37437 \$27745 \$36494 \$37951 NWELL PWELL BULK MUX2_X1
X$65687 \$34008 \$27745 \$33814 \$34561 NWELL PWELL BULK MUX2_X1
X$65689 \$45400 \$27745 \$41129 \$45641 NWELL PWELL BULK MUX2_X1
X$65692 \$29808 \$27745 \$27964 \$29674 NWELL PWELL BULK MUX2_X1
X$65696 \$30405 \$27745 \$29677 \$30874 NWELL PWELL BULK MUX2_X1
X$65698 \$34691 \$27745 \$34692 \$35331 NWELL PWELL BULK MUX2_X1
X$65700 \$37937 \$27745 \$35194 \$37581 NWELL PWELL BULK MUX2_X1
X$65704 \$28695 \$27745 \$29329 \$28883 NWELL PWELL BULK MUX2_X1
X$65729 M1_AXI_AWADDR[31] \$27749 NWELL PWELL BULK BUF_X1
X$65747 M1_AXI_AWADDR[22] \$27752 NWELL PWELL BULK CLKBUF_X2
X$65762 \$31496 \$32410 \$31747 \$27758 NWELL PWELL BULK DFF_X1
X$65764 \$I175768 \$32715 \$32717 \$27758 NWELL PWELL BULK DFF_X1
X$65766 \$I177043 \$33044 \$33660 \$27758 NWELL PWELL BULK DFF_X1
X$65768 \$I175117 \$29409 \$29893 \$27758 NWELL PWELL BULK DFF_X1
X$65770 \$31732 \$32095 \$31663 \$27758 NWELL PWELL BULK DFF_X1
X$65773 \$32749 \$27758 \$32101 \$31735 NWELL PWELL BULK DFF_X2
X$65775 \$I175127 \$32725 \$32094 \$27758 NWELL PWELL BULK DFF_X1
X$65778 \$I179002 \$31202 \$31657 \$27758 NWELL PWELL BULK DFF_X1
X$65780 \$I179003 \$30223 \$31200 \$27758 NWELL PWELL BULK DFF_X1
X$65782 \$I178997 \$30990 \$30931 \$27758 NWELL PWELL BULK DFF_X1
X$65785 \$I179278 \$31215 \$30228 \$27758 NWELL PWELL BULK DFF_X1
X$65788 \$I175115 \$30487 \$30484 \$27758 NWELL PWELL BULK DFF_X1
X$65790 \$I174351 \$32091 \$32302 \$27758 NWELL PWELL BULK DFF_X1
X$65792 \$32499 \$27758 \$31992 \$32495 NWELL PWELL BULK DFF_X2
X$65794 \$I179313 \$31742 \$32003 \$27758 NWELL PWELL BULK DFF_X1
X$65797 \$31746 \$32390 \$32121 \$27758 NWELL PWELL BULK DFF_X1
X$65799 \$30959 \$30502 \$30234 \$27758 NWELL PWELL BULK DFF_X1
X$65801 \$31745 \$32386 \$31492 \$27758 NWELL PWELL BULK DFF_X1
X$65804 \$32023 \$32021 \$31494 \$27758 NWELL PWELL BULK DFF_X1
X$65807 \$I179276 \$30231 \$30192 \$27758 NWELL PWELL BULK DFF_X1
X$65810 \$I179236 \$30993 \$31226 \$27758 NWELL PWELL BULK DFF_X1
X$65813 \$I179238 \$30038 \$30037 \$27758 NWELL PWELL BULK DFF_X1
X$65816 \$28058 \$27760 \$28056 \$27758 NWELL PWELL BULK DFF_X1
X$65818 \$I175031 \$29421 \$29416 \$27758 NWELL PWELL BULK DFF_X1
X$65821 \$I179282 \$29906 \$29417 \$27758 NWELL PWELL BULK DFF_X1
X$65823 \$31242 \$30957 \$31238 \$27758 NWELL PWELL BULK DFF_X1
X$65825 \$27765 \$28992 \$28986 \$27758 NWELL PWELL BULK DFF_X1
X$65827 \$28057 \$27761 \$28060 \$27758 NWELL PWELL BULK DFF_X1
X$65829 \$I179235 \$31740 \$32356 \$27758 NWELL PWELL BULK DFF_X1
X$65831 \$32111 \$32113 \$32366 \$27758 NWELL PWELL BULK DFF_X1
X$65852 \$30957 \$27759 \$29427 \$31238 NWELL PWELL BULK MUX2_X1
X$65858 \$29126 \$30042 \$27773 \$27759 NWELL PWELL BULK NOR3_X4
X$65862 \$31741 \$27759 NWELL PWELL BULK BUF_X8
X$65879 \$27773 \$27767 \$28098 NWELL PWELL BULK NAND2_X1
X$65883 \$27772 \$27767 \$29009 NWELL PWELL BULK NAND2_X1
X$65889 \$27867 \$28100 \$28095 \$27769 NWELL PWELL BULK AOI21_X1
X$65892 \$27773 \$27772 NWELL PWELL BULK INV_X4
X$65895 \$27772 \$28109 \$28111 NWELL PWELL BULK NAND2_X1
X$65898 \$27772 \$29695 \$I241022 \$29130 NWELL PWELL BULK HA_X1
X$65902 \$27772 \$28104 \$28095 NWELL PWELL BULK NAND2_X1
X$65921 \$27773 \$29473 \$28477 \$I241603 NWELL PWELL BULK HA_X1
X$65923 \$27773 \$27778 \$28116 NWELL PWELL BULK NAND2_X1
X$65931 \$30952 \$31245 \$27773 NWELL PWELL BULK NAND2_X4
X$65935 \$27773 \$30042 \$30240 NWELL PWELL BULK NAND2_X1
X$65937 \$27773 \$29126 \$28713 NWELL PWELL BULK NAND2_X1
X$65951 \$32125 \$27778 \$32509 NWELL PWELL BULK XOR2_X2
X$65986 \$29145 \$27795 \$28736 \$29143 NWELL PWELL BULK OAI21_X1
X$66025 \$28227 \$27806 \$27807 NWELL PWELL BULK NOR2_X1
X$66039 \$51480 \$32157 \$27811 \$51339 NWELL PWELL BULK MUX2_X1
X$66043 \$28499 \$28264 \$27818 NWELL PWELL BULK NOR2_X1
X$66045 \$27819 \$27818 \$27823 NWELL PWELL BULK NOR2_X2
X$66052 \$27820 \$29719 NWELL PWELL BULK INV_X1
X$66062 \$29719 \$27822 \$29163 \$29168 NWELL PWELL BULK AOI21_X2
X$66071 \$27822 \$30161 \$30636 \$30635 NWELL PWELL BULK AOI21_X1
X$66091 \$28291 \$28760 \$27824 \$28763 NWELL PWELL BULK OAI21_X1
X$66131 \$34281 \$27837 \$34795 \$35092 NWELL PWELL BULK HA_X1
X$66134 \$31781 \$27837 \$32553 \$34612 NWELL PWELL BULK NOR3_X1
X$66188 \$27860 \$28518 \$28784 \$28526 NWELL PWELL BULK MUX2_X1
X$66209 \$27864 \$28518 \$28525 \$28786 NWELL PWELL BULK MUX2_X1
X$66211 \$27864 \$27869 \$28529 NWELL PWELL BULK XNOR2_X2
X$66224 \$28531 \$28530 \$27866 NWELL PWELL BULK NAND2_X1
X$66227 \$27867 \$55374 \$54902 \$54058 \$52908 \$53214 \$54057 NWELL PWELL
+ BULK OAI33_X1
X$66230 \$61550 \$60353 \$27867 \$61137 \$60672 \$61136 NWELL PWELL BULK
+ AOI221_X1
X$66232 \$44926 \$27867 NWELL PWELL BULK BUF_X32
X$66234 \$27867 \$43533 \$43825 \$43532 NWELL PWELL BULK AOI21_X1
X$66236 \$27867 \$42888 \$43197 \$43199 NWELL PWELL BULK AOI21_X1
X$66238 \$27867 \$42451 \$42453 \$42537 NWELL PWELL BULK AOI21_X1
X$66240 \$27867 \$42193 \$42456 \$41874 NWELL PWELL BULK AOI21_X1
X$66242 \$42196 \$27867 \$42542 NWELL PWELL BULK NOR2_X1
X$66245 \$27867 \$42460 \$42893 \$42458 NWELL PWELL BULK AOI21_X1
X$66248 \$27867 \$43960 \$43827 \$44224 NWELL PWELL BULK AOI21_X1
X$66250 \$27867 \$43835 \$43834 \$43537 NWELL PWELL BULK AOI21_X1
X$66252 \$42899 \$27867 \$43301 NWELL PWELL BULK NOR2_X1
X$66255 \$27867 \$42896 \$43210 \$42543 NWELL PWELL BULK AOI21_X1
X$66257 \$41173 \$27867 \$41174 NWELL PWELL BULK NOR2_X1
X$66260 \$39843 \$27867 \$39758 NWELL PWELL BULK NOR2_X1
X$66262 \$36108 \$27867 \$36109 NWELL PWELL BULK NOR2_X1
X$66266 \$37415 \$37112 \$27867 \$36985 NWELL PWELL BULK NOR3_X1
X$66268 \$40091 \$27867 \$40190 NWELL PWELL BULK NOR2_X1
X$66271 \$40203 \$27867 \$40610 NWELL PWELL BULK NOR2_X1
X$66274 \$27867 \$38268 \$37805 \$38266 NWELL PWELL BULK OR3_X1
X$66277 \$27867 \$39162 \$39836 NWELL PWELL BULK OR2_X1
X$66279 \$57958 \$27867 \$57960 NWELL PWELL BULK NOR2_X1
X$66281 \$57708 \$27867 \$59239 NWELL PWELL BULK NOR2_X1
X$66284 \$27867 \$56095 \$56340 \$55799 NWELL PWELL BULK AOI21_X1
X$66287 \$56102 \$27867 \$56103 NWELL PWELL BULK NOR2_X1
X$66289 \$27867 \$57700 \$57701 \$57929 NWELL PWELL BULK AOI21_X1
X$66291 \$61173 \$60705 \$60702 \$27867 \$62065 NWELL PWELL BULK NOR4_X1
X$66295 \$62208 \$27867 \$62550 NWELL PWELL BULK NOR2_X1
X$66297 \$61512 \$27867 \$61127 NWELL PWELL BULK NOR2_X1
X$66300 \$27867 \$60591 \$59401 NWELL PWELL BULK OR2_X1
X$66302 \$61125 \$27867 \$60666 NWELL PWELL BULK NOR2_X1
X$66305 \$27867 \$62533 \$62204 NWELL PWELL BULK OR2_X1
X$66307 \$27867 \$54354 \$54360 \$53666 NWELL PWELL BULK AOI21_X1
X$66310 \$27867 \$56577 \$56996 \$56622 NWELL PWELL BULK AOI21_X1
X$66312 \$27867 \$56343 \$56344 \$56995 NWELL PWELL BULK AOI21_X1
X$66314 \$27867 \$41535 \$41440 \$41098 NWELL PWELL BULK AOI21_X1
X$66317 \$27867 \$40745 \$41192 \$41099 NWELL PWELL BULK AOI21_X1
X$66320 \$42119 \$42117 \$27867 \$39853 \$41900 \$42208 NWELL PWELL BULK
+ AOI221_X1
X$66322 \$27867 \$42548 \$42827 \$43222 NWELL PWELL BULK AOI21_X1
X$66325 \$38842 \$39853 \$39697 \$27867 \$39329 \$39693 \$39701 NWELL PWELL
+ BULK OAI33_X1
X$66327 \$27867 \$40031 \$39327 \$39723 NWELL PWELL BULK AOI21_X1
X$66330 \$38842 \$39853 \$40577 \$27867 \$40216 \$41081 \$40572 NWELL PWELL
+ BULK OAI33_X1
X$66333 \$38842 \$39853 \$41538 \$27867 \$41768 \$41199 \$41767 NWELL PWELL
+ BULK OAI33_X1
X$66335 \$42488 \$42474 \$42546 \$27867 \$42830 NWELL PWELL BULK NOR4_X1
X$66337 \$27867 \$41536 \$41784 \$42115 NWELL PWELL BULK AOI21_X1
X$66339 \$27867 \$35549 \$35545 \$35748 NWELL PWELL BULK AOI21_X1
X$66342 \$27867 \$35558 \$35276 \$35745 NWELL PWELL BULK AOI21_X1
X$66345 \$27867 \$35535 \$35281 \$35114 NWELL PWELL BULK AOI21_X1
X$66347 \$27867 \$37053 \$35744 \$36592 NWELL PWELL BULK AOI21_X1
X$66349 \$33264 \$27867 \$33121 NWELL PWELL BULK NOR2_X1
X$66352 \$33484 \$27867 \$33482 NWELL PWELL BULK NOR2_X1
X$66355 \$33011 \$27867 \$33115 NWELL PWELL BULK NOR2_X1
X$66357 \$27867 \$36364 \$35283 \$35282 NWELL PWELL BULK AOI21_X1
X$66360 \$34263 \$27867 \$34495 NWELL PWELL BULK NOR2_X1
X$66362 \$27867 \$35286 \$35881 \$35880 NWELL PWELL BULK AOI21_X1
X$66364 \$38842 \$39853 \$39861 \$27867 \$39331 \$39996 \$39685 NWELL PWELL
+ BULK OAI33_X1
X$66368 \$27867 \$35753 \$35755 \$36122 NWELL PWELL BULK AOI21_X1
X$66370 \$27867 \$37017 \$37015 \$36127 NWELL PWELL BULK AOI21_X1
X$66373 \$27867 \$35750 \$35751 \$36357 NWELL PWELL BULK AOI21_X1
X$66375 \$27867 \$44592 \$44593 \$44854 NWELL PWELL BULK AOI21_X1
X$66378 \$27867 \$45191 \$45192 \$45179 NWELL PWELL BULK AOI21_X1
X$66381 \$27867 \$44839 \$44848 \$44589 NWELL PWELL BULK AOI21_X1
X$66383 \$27867 \$45274 \$45600 \$45595 NWELL PWELL BULK AOI21_X1
X$66385 \$27867 \$53107 \$53601 \$53216 \$52908 \$53214 \$53594 NWELL PWELL
+ BULK OAI33_X1
X$66387 \$51339 \$27867 \$52037 NWELL PWELL BULK NOR2_X1
X$66389 \$51215 \$27867 \$51338 NWELL PWELL BULK NOR2_X1
X$66391 \$52043 \$27867 \$51340 NWELL PWELL BULK NOR2_X1
X$66394 \$27867 \$53669 \$53917 NWELL PWELL BULK OR2_X1
X$66397 \$27867 \$52129 \$52472 \$52052 NWELL PWELL BULK AOI21_X1
X$66399 \$27867 \$53251 \$53253 \$53255 NWELL PWELL BULK AOI21_X1
X$66402 \$27867 \$53250 \$53680 \$53687 NWELL PWELL BULK AOI21_X1
X$66405 \$52769 \$27867 \$52772 NWELL PWELL BULK NOR2_X1
X$66407 \$51235 \$27867 \$50767 NWELL PWELL BULK NOR2_X1
X$66410 \$27867 \$51643 \$52026 \$51642 NWELL PWELL BULK AOI21_X1
X$66412 \$47811 \$27867 \$47211 NWELL PWELL BULK NOR2_X1
X$66414 \$27867 \$54086 \$53913 \$54997 NWELL PWELL BULK AOI21_X1
X$66416 \$27867 \$29732 \$30707 \$29733 NWELL PWELL BULK AOI21_X1
X$66418 \$35596 \$27867 \$35072 NWELL PWELL BULK NOR2_X1
X$66420 \$27867 \$32830 \$32836 \$33374 NWELL PWELL BULK AOI21_X1
X$66422 \$27867 \$31523 \$32001 \$31616 NWELL PWELL BULK AOI21_X1
X$66424 \$27867 \$31790 \$32916 \$32350 NWELL PWELL BULK AOI21_X1
X$66426 \$30607 \$27867 \$29739 NWELL PWELL BULK NOR2_X1
X$66429 \$31421 \$27867 \$30793 NWELL PWELL BULK NOR2_X1
X$66433 \$32960 \$27867 \$33675 NWELL PWELL BULK NOR2_X1
X$66435 \$27867 \$29207 \$29458 \$29206 NWELL PWELL BULK AOI21_X1
X$66438 \$31042 \$27867 \$30806 NWELL PWELL BULK NOR2_X1
X$66440 \$27867 \$28789 \$28899 \$28791 NWELL PWELL BULK AOI21_X1
X$66442 \$31965 \$27867 \$31663 NWELL PWELL BULK NOR2_X1
X$66446 \$30227 \$27867 \$30228 NWELL PWELL BULK NOR2_X1
X$66448 \$27867 \$31041 \$31347 \$30799 NWELL PWELL BULK AOI21_X1
X$66450 \$27867 \$30309 \$30310 \$30311 NWELL PWELL BULK AOI21_X1
X$66452 \$40446 \$27867 \$40972 NWELL PWELL BULK NOR2_X1
X$66454 \$40719 \$41025 \$27867 \$40172 NWELL PWELL BULK NOR3_X1
X$66456 \$40703 \$27867 \$41384 NWELL PWELL BULK NOR2_X1
X$66458 \$27867 \$28931 \$28782 NWELL PWELL BULK OR2_X1
X$66460 \$27867 \$28713 \$29009 \$29124 NWELL PWELL BULK AOI21_X1
X$66462 \$29552 \$27867 \$29912 NWELL PWELL BULK NOR2_X1
X$66464 \$27867 \$37426 \$35112 \$40183 NWELL PWELL BULK AOI21_X1
X$66468 \$27867 \$40156 \$40072 \$40974 NWELL PWELL BULK AOI21_X1
X$66470 \$27867 \$30240 \$30241 \$30510 NWELL PWELL BULK AOI21_X1
X$66473 \$32012 \$27867 \$31621 NWELL PWELL BULK NOR2_X1
X$66626 \$28531 \$28790 \$27871 NWELL PWELL BULK NAND2_X1
X$66636 \$I179150 \$27875 \$28582 \$28890 NWELL PWELL BULK DFF_X1
X$66643 \$I178484 \$27876 \$28889 \$28890 NWELL PWELL BULK DFF_X1
X$66682 \$27888 S2_AXI_ARLEN[7] NWELL PWELL BULK BUF_X1
X$66686 \$40632 \$27889 \$40639 \$40041 NWELL PWELL BULK MUX2_X1
X$66688 \$37129 \$39322 \$38840 \$27889 \$39087 \$40038 NWELL PWELL BULK
+ AOI221_X2
X$66691 \$45283 \$27889 \$45200 \$45285 NWELL PWELL BULK MUX2_X1
X$66694 \$30104 \$38343 \$27889 \$37512 NWELL PWELL BULK OAI21_X1
X$66696 \$41810 \$27889 \$41811 \$41522 NWELL PWELL BULK MUX2_X1
X$66698 \$44537 \$46765 \$27889 NWELL PWELL BULK NAND2_X4
X$66702 \$45203 \$27889 \$44545 \$44863 NWELL PWELL BULK MUX2_X1
X$66705 \$27889 \$30104 \$28118 NWELL PWELL BULK NAND2_X1
X$66726 \$29758 \$29229 \$27893 \$I241560 NWELL PWELL BULK HA_X1
X$66728 \$28539 \$27893 \$28540 \$28077 NWELL PWELL BULK MUX2_X1
X$66731 \$28852 \$27893 \$29360 NWELL PWELL BULK NOR2_X1
X$66733 \$28072 \$28067 \$27893 \$27894 NWELL PWELL BULK AOI21_X1
X$66736 \$27893 \$28542 \$28072 NWELL PWELL BULK NOR2_X1
X$66755 \$27900 \$28810 \$29267 NWELL PWELL BULK NAND2_X1
X$66757 \$27900 \$28825 \$28003 NWELL PWELL BULK NAND2_X1
X$66759 \$27900 \$29281 \$28572 NWELL PWELL BULK NAND2_X1
X$66761 \$27900 \$29275 \$29241 NWELL PWELL BULK NAND2_X1
X$66763 \$27900 \$28545 \$28564 NWELL PWELL BULK NAND2_X1
X$66765 \$27900 \$28840 \$27901 NWELL PWELL BULK NAND2_X1
X$66799 \$27913 M2_AXI_BRESP[1] NWELL PWELL BULK BUF_X1
X$66801 M2_AXI_BREADY \$27957 NWELL PWELL BULK BUF_X1
X$66820 M2_AXI_ARVALID \$27922 NWELL PWELL BULK BUF_X1
X$66833 \$33384 \$27943 \$34012 \$33386 \$32457 NWELL PWELL BULK OAI22_X2
X$66836 \$27943 \$38355 \$35140 \$38531 NWELL PWELL BULK NOR3_X1
X$66838 \$27943 \$38724 \$38723 NWELL PWELL BULK NOR2_X1
X$66867 M1_AXI_AWSIZE[2] \$27964 NWELL PWELL BULK BUF_X1
X$66942 \$34721 \$36524 \$37072 \$28042 \$39060 NWELL PWELL BULK AOI22_X2
X$66946 \$28042 \$38083 NWELL PWELL BULK INV_X1
X$66990 \$28067 \$29354 \$28542 \$28848 \$28540 NWELL PWELL BULK FA_X1
X$67072 \$28130 S0_AXI_ARID[1] NWELL PWELL BULK BUF_X1
X$67159 \$28291 \$28760 \$28624 NWELL PWELL BULK NOR2_X1
X$67168 \$28299 \$30063 \$30064 \$30592 NWELL PWELL BULK OR3_X1
X$67173 \$39850 \$28299 NWELL PWELL BULK INV_X2
X$67176 \$28299 \$41113 \$40211 \$40742 \$39848 NWELL PWELL BULK OAI22_X1
X$67191 \$28518 \$28316 NWELL PWELL BULK INV_X2
X$67195 \$28316 \$28531 \$30315 \$I241634 NWELL PWELL BULK HA_X1
X$67261 M1_AXI_AWSIZE[1] \$28446 NWELL PWELL BULK BUF_X1
X$67290 M0_AXI_AWADDR[25] \$28461 NWELL PWELL BULK BUF_X1
X$67306 M1_AXI_AWADDR[27] \$28464 NWELL PWELL BULK CLKBUF_X2
X$67345 \$29484 \$28477 \$29030 \$29486 NWELL PWELL BULK MUX2_X1
X$67347 \$29131 \$28477 \$28718 NWELL PWELL BULK NOR2_X1
X$67352 \$28477 \$29478 \$28721 NWELL PWELL BULK NOR2_X1
X$67355 \$28721 \$28720 \$28477 \$28673 NWELL PWELL BULK AOI21_X1
X$67371 \$28492 \$28745 \$29569 \$32149 NWELL PWELL BULK AOI21_X2
X$67386 \$28758 \$28507 \$29601 \$29627 NWELL PWELL BULK MUX2_X1
X$67405 \$30297 \$28512 NWELL PWELL BULK INV_X1
X$67426 \$35154 \$28515 \$33097 \$35157 NWELL PWELL BULK MUX2_X1
X$67429 \$32145 \$28515 \$31363 \$31768 NWELL PWELL BULK MUX2_X1
X$67432 \$34636 \$28515 \$33472 \$35150 NWELL PWELL BULK MUX2_X1
X$67435 \$34360 \$28515 \$33736 \$34365 NWELL PWELL BULK MUX2_X1
X$67438 \$33273 \$28515 \$30861 \$33113 NWELL PWELL BULK MUX2_X1
X$67441 \$34328 \$28515 \$33111 \$34487 NWELL PWELL BULK MUX2_X1
X$67446 \$31012 \$30764 \$31014 \$28515 NWELL PWELL BULK NOR3_X4
X$67460 \$28525 \$28518 \$28929 \$28785 NWELL PWELL BULK MUX2_X1
X$67463 \$28784 \$28518 \$28523 \$28931 NWELL PWELL BULK MUX2_X1
X$67467 \$28518 \$29195 \$30141 NWELL PWELL BULK NAND2_X1
X$67470 \$29201 \$28518 \$30088 \$29741 NWELL PWELL BULK MUX2_X1
X$67486 \$28784 \$28525 \$28929 \$29195 NWELL PWELL BULK HA_X1
X$67504 \$28530 \$28790 \$28907 \$29210 NWELL PWELL BULK HA_X1
X$67509 \$28531 \$29208 \$29458 NWELL PWELL BULK NAND2_X1
X$67511 \$28531 \$29210 \$29209 NWELL PWELL BULK NAND2_X1
X$67513 \$28531 \$29468 \$28914 NWELL PWELL BULK NAND2_X1
X$67516 \$28531 \$28907 \$28899 NWELL PWELL BULK NAND2_X1
X$67534 \$28544 S2_AXI_ARLEN[6] NWELL PWELL BULK BUF_X1
X$67537 \$28825 \$28545 \$29275 \$29281 NWELL PWELL BULK HA_X1
X$67552 \$28840 \$28572 \$29292 NWELL PWELL BULK XNOR2_X1
X$67582 \$34266 \$28612 \$35080 NWELL PWELL BULK XOR2_X1
X$67585 \$28612 \$32157 \$34271 \$31781 \$35286 NWELL PWELL BULK NAND4_X1
X$67588 \$28612 \$35094 \$37621 \$33904 NWELL PWELL BULK NOR3_X1
X$67665 \$I176460 \$28695 \$28883 \$29099 NWELL PWELL BULK DFF_X1
X$67691 \$28717 \$28718 \$29022 NWELL PWELL BULK XNOR2_X1
X$67693 \$28717 \$30952 NWELL PWELL BULK INV_X2
X$67699 \$29130 \$28719 NWELL PWELL BULK INV_X1
X$67701 \$28720 \$29132 \$29478 \$28719 \$29030 NWELL PWELL BULK FA_X1
X$67708 \$28725 \$29503 \$29138 \$30047 NWELL PWELL BULK DFF_X1
X$67714 \$28729 \$28730 \$28734 \$30170 NWELL PWELL BULK OAI21_X1
X$67719 \$28732 \$28734 \$28736 NWELL PWELL BULK NAND2_X1
X$67721 \$29151 \$29712 \$28734 NWELL PWELL BULK NOR2_X1
X$67742 \$29574 \$28745 \$29157 \$29158 \$29156 \$32053 NWELL PWELL BULK
+ OAI221_X2
X$67744 \$29715 \$28752 \$30068 \$30069 NWELL PWELL BULK AOI21_X1
X$67747 \$31514 \$30263 \$30273 \$28752 NWELL PWELL BULK DFF_X2
X$67755 \$30068 \$28752 \$31025 NWELL PWELL BULK NAND2_X1
X$67767 \$28755 \$29640 \$28768 \$29639 NWELL PWELL BULK AOI21_X1
X$67780 \$28759 \$32044 \$31515 \$30263 NWELL PWELL BULK DFF_X1
X$67790 \$29978 \$28760 NWELL PWELL BULK INV_X1
X$67802 \$28764 \$29726 NWELL PWELL BULK BUF_X2
X$67811 \$28771 \$29173 \$29663 \$28973 NWELL PWELL BULK MUX2_X1
X$67887 \$31542 \$31922 \$28806 NWELL PWELL BULK NAND2_X2
X$67889 \$28806 \$28846 \$29233 NWELL PWELL BULK NAND2_X1
X$67892 \$28806 \$30346 \$30413 NWELL PWELL BULK NAND2_X1
X$67894 \$28806 \$29237 \$29235 NWELL PWELL BULK NAND2_X1
X$67896 \$28806 \$31064 \$31541 NWELL PWELL BULK NAND2_X1
X$67899 \$28806 \$30854 \$31175 NWELL PWELL BULK NAND2_X1
X$67901 \$28806 \$29229 NWELL PWELL BULK INV_X2
X$67904 \$29753 \$28806 \$I241105 \$29227 NWELL PWELL BULK HA_X1
X$67950 \$29229 \$28846 \$30107 NWELL PWELL BULK NAND2_X1
X$67955 \$28846 \$29237 \$29315 \$29761 NWELL PWELL BULK HA_X1
X$67958 \$29227 \$28848 NWELL PWELL BULK INV_X1
X$67965 \$29227 \$29354 \$28852 NWELL PWELL BULK XOR2_X1
X$67982 \$28864 \$36589 NWELL PWELL BULK INV_X1
X$67985 \$37132 \$34366 \$I245624 \$28864 NWELL PWELL BULK DFF_X2
X$68014 \$I175196 \$29866 \$29212 \$28890 NWELL PWELL BULK DFF_X1
X$68017 \$I177380 \$37527 \$37525 \$28890 NWELL PWELL BULK DFF_X1
X$68020 \$I178482 \$30319 \$30808 \$28890 NWELL PWELL BULK DFF_X1
X$68022 \$I174703 \$30326 \$30324 \$28890 NWELL PWELL BULK DFF_X1
X$68024 \$I177460 \$37145 \$36949 \$28890 NWELL PWELL BULK DFF_X1
X$68026 \$I177469 \$36341 \$36134 \$28890 NWELL PWELL BULK DFF_X1
X$68028 \$I175195 \$29748 \$29747 \$28890 NWELL PWELL BULK DFF_X1
X$68031 \$I177456 \$37528 \$37142 \$28890 NWELL PWELL BULK DFF_X1
X$68033 \$I175193 \$31301 \$31313 \$28890 NWELL PWELL BULK DFF_X1
X$68038 \$34498 \$33911 \$34496 \$28890 NWELL PWELL BULK DFF_X1
X$68040 \$I177471 \$36132 \$36130 \$28890 NWELL PWELL BULK DFF_X1
X$68042 \$I175211 \$30092 \$29871 \$28890 NWELL PWELL BULK DFF_X1
X$68047 \$I176855 \$32573 \$32570 \$28890 NWELL PWELL BULK DFF_X1
X$68049 \$I177329 \$33123 \$33672 \$28890 NWELL PWELL BULK DFF_X1
X$68051 \$36986 \$36604 \$36997 \$28890 NWELL PWELL BULK DFF_X1
X$68054 \$I178549 \$37835 \$37609 \$28890 NWELL PWELL BULK DFF_X1
X$68057 \$41550 \$28890 \$I245743 \$41552 NWELL PWELL BULK DFF_X2
X$68059 \$41043 \$28890 \$I245609 \$41412 NWELL PWELL BULK DFF_X2
X$68061 \$41046 \$28890 \$I245733 \$41042 NWELL PWELL BULK DFF_X2
X$68064 \$I177088 \$40551 \$40571 \$28890 NWELL PWELL BULK DFF_X1
X$68066 \$41069 \$28890 \$I245541 \$39865 NWELL PWELL BULK DFF_X2
X$68069 \$38855 \$39347 \$38465 \$28890 NWELL PWELL BULK DFF_X1
X$68073 \$I176909 \$32571 \$32564 \$28890 NWELL PWELL BULK DFF_X1
X$68076 \$I179141 \$31963 \$31608 \$28890 NWELL PWELL BULK DFF_X1
X$68078 \$39978 \$28890 \$I245658 \$38570 NWELL PWELL BULK DFF_X2
X$68080 \$I175428 \$38469 \$38856 \$28890 NWELL PWELL BULK DFF_X1
X$68083 \$37142 \$28890 \$I245726 \$39971 NWELL PWELL BULK DFF_X2
X$68139 \$36045 \$36524 \$37072 \$28915 \$37456 NWELL PWELL BULK AOI22_X2
X$68142 \$28915 \$37266 NWELL PWELL BULK INV_X1
X$68145 \$29333 \$28915 \$36275 \$30890 \$36065 NWELL PWELL BULK NOR4_X4
X$68212 \$28977 \$29173 \$29728 \$29660 NWELL PWELL BULK MUX2_X1
X$68229 \$28993 \$39834 \$46329 \$36426 \$37129 \$45271 NWELL PWELL BULK
+ OAI221_X2
X$68232 \$33384 \$28993 \$49489 \$34764 \$49707 NWELL PWELL BULK OAI22_X2
X$68234 \$28993 \$38724 \$51594 NWELL PWELL BULK NOR2_X1
X$68237 \$28993 \$38803 \$35140 \$51595 NWELL PWELL BULK NOR3_X1
X$68260 \$29002 \$29721 \$30652 \$30157 NWELL PWELL BULK NAND3_X1
X$68330 M0_AXI_AWADDR[13] \$29098 NWELL PWELL BULK BUF_X1
X$68344 \$30368 \$30359 \$30199 \$29099 NWELL PWELL BULK DFF_X1
X$68347 \$30370 \$31106 \$30839 \$29099 NWELL PWELL BULK DFF_X1
X$68350 \$30390 \$30202 \$30737 \$29099 NWELL PWELL BULK DFF_X1
X$68353 \$29797 \$29779 \$29780 \$29099 NWELL PWELL BULK DFF_X1
X$68355 \$30411 \$29321 \$29310 \$29099 NWELL PWELL BULK DFF_X1
X$68358 \$30023 \$29681 \$29823 \$29099 NWELL PWELL BULK DFF_X1
X$68360 \$I176593 \$31715 \$32084 \$29099 NWELL PWELL BULK DFF_X1
X$68363 \$30741 \$30405 \$30874 \$29099 NWELL PWELL BULK DFF_X1
X$68368 \$31107 \$31707 \$31860 \$29099 NWELL PWELL BULK DFF_X1
X$68370 \$31105 \$30967 \$31460 \$29099 NWELL PWELL BULK DFF_X1
X$68372 \$32455 \$32227 \$32080 \$29099 NWELL PWELL BULK DFF_X1
X$68374 \$31871 \$31876 \$31708 \$29099 NWELL PWELL BULK DFF_X1
X$68376 \$I175080 \$31467 \$31881 \$29099 NWELL PWELL BULK DFF_X1
X$68379 \$30204 \$30868 \$30864 \$29099 NWELL PWELL BULK DFF_X1
X$68382 \$31712 \$32240 \$31874 \$29099 NWELL PWELL BULK DFF_X1
X$68385 \$30205 \$30400 \$30139 \$29099 NWELL PWELL BULK DFF_X1
X$68388 \$I176713 \$30980 \$30978 \$29099 NWELL PWELL BULK DFF_X1
X$68390 \$I178855 \$30443 \$30448 \$29099 NWELL PWELL BULK DFF_X1
X$68392 \$I176691 \$30213 \$30212 \$29099 NWELL PWELL BULK DFF_X1
X$68394 \$I178705 \$30983 \$31165 \$29099 NWELL PWELL BULK DFF_X1
X$68397 \$I178884 \$29105 \$29104 \$29099 NWELL PWELL BULK DFF_X1
X$68399 \$I176377 \$30430 \$30428 \$29099 NWELL PWELL BULK DFF_X1
X$68404 \$I178849 \$31717 \$31898 \$29099 NWELL PWELL BULK DFF_X1
X$68406 \$I176696 \$31912 \$31719 \$29099 NWELL PWELL BULK DFF_X1
X$68409 \$I178722 \$30744 \$30743 \$29099 NWELL PWELL BULK DFF_X1
X$68412 \$I174445 \$30210 \$30025 \$29099 NWELL PWELL BULK DFF_X1
X$68414 \$I176384 \$32672 \$32269 \$29099 NWELL PWELL BULK DFF_X1
X$68417 \$I176464 \$30972 \$31138 \$29099 NWELL PWELL BULK DFF_X1
X$68465 \$30244 \$29126 \$32122 NWELL PWELL BULK XOR2_X2
X$68480 \$30181 \$29695 \$29460 \$29127 NWELL PWELL BULK MUX2_X1
X$68488 \$29128 \$30042 \$30997 NWELL PWELL BULK XOR2_X2
X$68495 \$29130 \$29132 \$29131 NWELL PWELL BULK XOR2_X1
X$68508 \$29139 \$29140 \$29519 \$29518 NWELL PWELL BULK MUX2_X1
X$68510 \$29139 \$29703 \$30564 \$30052 NWELL PWELL BULK HA_X1
X$68514 \$30557 \$29140 \$29139 \$29965 NWELL PWELL BULK MUX2_X1
X$68523 \$31014 \$29140 \$34476 \$I241512 NWELL PWELL BULK HA_X1
X$68525 \$29140 \$33326 NWELL PWELL BULK INV_X1
X$68527 \$30259 \$30052 \$29140 \$30570 NWELL PWELL BULK AOI21_X1
X$68530 \$30052 \$30259 \$29140 \$30940 NWELL PWELL BULK AND3_X1
X$68532 \$31342 \$29140 \$30769 NWELL PWELL BULK NAND2_X1
X$68534 \$29140 \$31344 \$30769 \$30770 NWELL PWELL BULK OAI21_X1
X$68536 \$30257 \$29140 \$29703 \$30053 NWELL PWELL BULK MUX2_X1
X$68538 \$29703 \$29140 \$30564 \$30563 NWELL PWELL BULK MUX2_X1
X$68559 \$29149 \$29145 \$30060 NWELL PWELL BULK OR2_X1
X$68562 \$29145 \$29548 \$29547 NWELL PWELL BULK NAND2_X1
X$68608 \$29168 \$29169 \$29970 NWELL PWELL BULK NOR2_X1
X$68616 \$34630 \$29172 \$33736 \$35143 NWELL PWELL BULK MUX2_X1
X$68618 \$33471 \$29172 \$33472 \$33756 NWELL PWELL BULK MUX2_X1
X$68622 \$33715 \$29172 \$33111 \$33717 NWELL PWELL BULK MUX2_X1
X$68625 \$33092 \$29172 \$33090 \$33788 NWELL PWELL BULK MUX2_X1
X$68628 \$33765 \$29172 \$33097 \$33766 NWELL PWELL BULK MUX2_X1
X$68632 \$30762 \$30764 \$31014 \$29172 NWELL PWELL BULK NOR3_X4
X$68635 \$31355 \$29172 \$31363 \$31348 NWELL PWELL BULK MUX2_X1
X$68639 \$32383 \$29172 \$30861 \$31774 NWELL PWELL BULK MUX2_X1
X$68655 \$32147 \$29173 \$32422 \$32414 NWELL PWELL BULK MUX2_X1
X$68658 \$32035 \$29173 \$32034 \$32032 NWELL PWELL BULK MUX2_X1
X$68660 \$32426 \$29173 \$32955 \$32065 NWELL PWELL BULK MUX2_X1
X$68662 \$34367 \$29173 \$33734 \$33726 NWELL PWELL BULK MUX2_X1
X$68665 \$34481 \$29173 \$33895 \$33474 NWELL PWELL BULK MUX2_X1
X$68668 \$32551 \$29173 \$33695 \$33005 NWELL PWELL BULK MUX2_X1
X$68671 \$34621 \$29173 \$34310 \$33902 NWELL PWELL BULK MUX2_X1
X$68673 \$32944 \$29173 \$32945 \$32537 NWELL PWELL BULK MUX2_X1
X$68678 \$30934 \$29173 \$31021 \$31512 NWELL PWELL BULK MUX2_X1
X$68684 \$32978 \$29173 \$32977 \$32152 NWELL PWELL BULK MUX2_X1
X$68686 \$34332 \$29173 \$32548 \$34304 NWELL PWELL BULK MUX2_X1
X$68688 \$35147 \$29173 \$33758 \$32538 NWELL PWELL BULK MUX2_X1
X$68690 \$33751 \$29173 \$33102 \$33747 NWELL PWELL BULK MUX2_X1
X$68692 \$34358 \$29173 \$33475 \$33107 NWELL PWELL BULK MUX2_X1
X$68733 \$30083 \$29189 \$29732 NWELL PWELL BULK NAND2_X1
X$68736 \$30290 \$30300 \$29189 \$30689 NWELL PWELL BULK MUX2_X1
X$68738 \$30084 \$29189 \$30713 \$30795 NWELL PWELL BULK HA_X1
X$68750 \$29201 \$29743 \$29502 NWELL PWELL BULK XNOR2_X2
X$68759 \$29203 S2_AXI_ARLEN[4] NWELL PWELL BULK BUF_X1
X$68769 \$29208 \$29209 \$29744 NWELL PWELL BULK XNOR2_X1
X$68803 \$30335 \$29752 \$29225 \$30124 NWELL PWELL BULK HA_X1
X$68805 \$29753 \$29225 \$29364 NWELL PWELL BULK NAND2_X1
X$68807 \$29758 \$29752 \$29226 NWELL PWELL BULK NAND2_X1
X$68818 \$29229 \$29761 \$29763 NWELL PWELL BULK NAND2_X1
X$68821 \$29229 \$29315 \$29236 NWELL PWELL BULK NAND2_X1
X$68823 \$29229 \$29762 \$30403 NWELL PWELL BULK NAND2_X1
X$68826 \$29229 \$29345 \$29335 NWELL PWELL BULK NAND2_X1
X$68830 \$29229 \$29237 \$30108 NWELL PWELL BULK NAND2_X1
X$68852 \$29762 \$29763 \$29239 NWELL PWELL BULK XNOR2_X1
X$68859 \$29260 M2_AXI_BID[0] NWELL PWELL BULK BUF_X1
X$68925 \$29309 \$32462 NWELL PWELL BULK INV_X1
X$68931 \$41140 \$37065 \$29309 \$41841 NWELL PWELL BULK OAI21_X2
X$68933 \$29309 \$38363 \$37685 \$41139 NWELL PWELL BULK NOR3_X1
X$68956 M1_AXI_AWADDR[17] \$29329 NWELL PWELL BULK BUF_X1
X$68970 \$31622 \$36524 \$37072 \$29333 \$38002 NWELL PWELL BULK AOI22_X2
X$68973 \$29333 \$37995 NWELL PWELL BULK INV_X1
X$69023 \$30334 \$29360 \$29837 NWELL PWELL BULK XNOR2_X1
X$69039 \$36046 \$36524 \$37072 \$29365 \$39798 NWELL PWELL BULK AOI22_X2
X$69042 \$29365 \$39800 NWELL PWELL BULK INV_X1
X$69090 M0_AXI_AWID[1] \$29427 NWELL PWELL BULK CLKBUF_X2
X$69129 \$29695 \$29473 NWELL PWELL BULK INV_X1
X$69209 \$29582 \$33899 \$I241099 \$34489 NWELL PWELL BULK HA_X1
X$69211 \$29582 \$35136 NWELL PWELL BULK INV_X1
X$69213 \$32157 \$29582 \$35744 NWELL PWELL BULK NAND2_X1
X$69236 \$29967 \$29715 \$29626 NWELL PWELL BULK NAND2_X1
X$69238 \$29626 \$29628 NWELL PWELL BULK INV_X1
X$69259 \$55425 \$29640 \$56234 \$55366 NWELL PWELL BULK OAI21_X4
X$69302 M1_AXI_AWBURST[1] \$29677 NWELL PWELL BULK BUF_X1
X$69324 M0_AXI_AWADDR[14] \$29689 NWELL PWELL BULK CLKBUF_X2
X$69340 \$30042 \$29693 NWELL PWELL BULK INV_X1
X$69347 \$30521 \$29695 \$30514 \$30044 NWELL PWELL BULK MUX2_X1
X$69349 \$29695 \$31503 \$32033 \$32420 NWELL PWELL BULK OAI21_X1
X$69351 \$31500 \$30998 \$29695 NWELL PWELL BULK NOR2_X2
X$69354 \$30246 \$29695 \$30181 \$30182 NWELL PWELL BULK MUX2_X1
X$69365 \$I175234 \$30557 \$29701 \$30047 NWELL PWELL BULK DFF_X1
X$69375 \$I175341 \$29703 \$30254 \$30047 NWELL PWELL BULK DFF_X1
X$69384 \$30063 \$29712 NWELL PWELL BULK INV_X1
X$69393 \$29720 \$29721 \$29715 \$29723 NWELL PWELL BULK NOR3_X1
X$69395 \$29715 \$30157 \$30285 \$30281 \$30154 NWELL PWELL BULK AOI22_X1
X$69397 \$30288 \$30263 \$30285 \$29715 NWELL PWELL BULK DFF_X2
X$69413 \$29720 \$29721 \$30281 NWELL PWELL BULK NOR2_X1
X$69419 \$30077 \$29726 \$29721 \$29940 NWELL PWELL BULK AND3_X2
X$69431 \$31026 \$29723 \$30279 \$31647 NWELL PWELL BULK MUX2_X1
X$69433 \$31642 \$29723 \$31408 NWELL PWELL BULK OR2_X1
X$69436 \$31409 \$29723 \$30786 \$31410 NWELL PWELL BULK AOI21_X1
X$69455 \$30077 \$30300 \$30084 \$29735 NWELL PWELL BULK MUX2_X1
X$69479 \$29749 \$32602 NWELL PWELL BULK BUF_X4
X$69483 \$29749 \$39355 NWELL PWELL BULK BUF_X4
X$69486 \$29749 \$36169 NWELL PWELL BULK BUF_X4
X$69491 \$29749 \$38891 NWELL PWELL BULK BUF_X4
X$69499 \$29749 \$33492 NWELL PWELL BULK BUF_X4
X$69501 \$29749 \$30823 NWELL PWELL BULK BUF_X4
X$69524 \$29749 \$33935 NWELL PWELL BULK BUF_X4
X$69530 \$29753 \$29752 \$30457 NWELL PWELL BULK NAND2_X1
X$69535 \$29753 \$30124 \$29828 NWELL PWELL BULK NAND2_X1
X$69538 \$29753 \$29758 NWELL PWELL BULK INV_X4
X$69540 \$29753 \$31539 \$31061 \$31861 NWELL PWELL BULK AND3_X4
X$69543 \$31063 \$31061 \$29753 \$31810 NWELL PWELL BULK NAND3_X4
X$69545 \$29753 \$29754 \$30438 NWELL PWELL BULK NAND2_X1
X$69547 \$32827 \$30334 \$29753 NWELL PWELL BULK NOR2_X4
X$69551 \$29753 \$30335 \$31058 NWELL PWELL BULK NAND2_X1
X$69555 \$29753 \$31057 \$30819 NWELL PWELL BULK NAND2_X1
X$69570 \$29754 \$29828 \$29826 NWELL PWELL BULK XOR2_X1
X$69581 \$31061 \$31063 \$29758 \$32181 NWELL PWELL BULK NOR3_X4
X$69584 \$29758 \$30344 \$30433 NWELL PWELL BULK NAND2_X1
X$69586 \$31061 \$31539 \$29758 \$31191 NWELL PWELL BULK NOR3_X4
X$69589 \$29758 \$31063 \$30455 NWELL PWELL BULK NAND2_X1
X$69592 \$29758 \$30335 \$30465 NWELL PWELL BULK NAND2_X1
X$69596 \$29758 \$31061 \$31599 NWELL PWELL BULK NAND2_X1
X$69634 \$29795 S2_AXI_ARID[3] NWELL PWELL BULK BUF_X1
X$69645 \$38734 \$37065 \$29806 \$39433 NWELL PWELL BULK OAI21_X2
X$69647 \$29806 \$32459 NWELL PWELL BULK INV_X1
X$69650 \$29806 \$38363 \$37685 \$39405 NWELL PWELL BULK NOR3_X1
X$69689 M0_AXI_AWADDR[18] \$29846 NWELL PWELL BULK BUF_X1
X$69739 \$29885 \$39259 NWELL PWELL BULK INV_X1
X$69741 \$35915 \$36524 \$39576 \$37072 \$29885 NWELL PWELL BULK AOI22_X4
X$69789 \$29936 S2_AXI_ARLEN[0] NWELL PWELL BULK BUF_X1
X$69820 \$30286 \$29967 \$31410 \$30263 NWELL PWELL BULK DFF_X1
X$69860 \$30010 \$30066 \$30604 \$30165 NWELL PWELL BULK OAI21_X1
X$69876 \$33070 \$30033 \$35237 NWELL PWELL BULK NOR2_X1
X$69878 \$35943 \$33664 \$30033 \$33070 \$37470 NWELL PWELL BULK OR4_X2
X$69881 \$34148 \$36513 \$30033 \$36514 \$38148 NWELL PWELL BULK AOI22_X1
X$69883 \$30752 \$30033 \$33064 NWELL PWELL BULK AND2_X1
X$69885 \$33307 \$30033 \$32787 \$32478 NWELL PWELL BULK NAND3_X2
X$69888 \$30033 \$32745 \$32748 \$33307 \$35708 NWELL PWELL BULK NAND4_X2
X$69890 \$33307 \$30033 \$32787 \$31486 \$33853 NWELL PWELL BULK NAND4_X1
X$69893 \$34148 \$33845 \$30033 \$33829 \$32469 NWELL PWELL BULK AOI22_X1
X$69942 \$33093 \$33787 \$33465 \$30047 NWELL PWELL BULK DFF_X1
X$69945 \$33091 \$33092 \$33788 \$30047 NWELL PWELL BULK DFF_X1
X$69948 \$I175909 \$33088 \$33463 \$30047 NWELL PWELL BULK DFF_X1
X$69950 \$I176490 \$35743 \$35275 \$30047 NWELL PWELL BULK DFF_X1
X$69953 \$I177010 \$34473 \$34340 \$30047 NWELL PWELL BULK DFF_X1
X$69956 \$35272 \$35273 \$35591 \$30047 NWELL PWELL BULK DFF_X1
X$69959 \$I176929 \$31767 \$32142 \$30047 NWELL PWELL BULK DFF_X1
X$69961 \$32945 \$33314 \$33316 \$30047 NWELL PWELL BULK DFF_X1
X$69963 \$35171 \$33887 \$34474 \$30047 NWELL PWELL BULK DFF_X1
X$69965 \$I176302 \$32137 \$32135 \$30047 NWELL PWELL BULK DFF_X1
X$69967 \$32944 \$33765 \$33766 \$30047 NWELL PWELL BULK DFF_X1
X$69969 \$35622 \$35263 \$35921 \$30047 NWELL PWELL BULK DFF_X1
X$69972 \$I176881 \$35183 \$34780 \$30047 NWELL PWELL BULK DFF_X1
X$69974 \$34780 \$30047 \$I245533 \$35264 NWELL PWELL BULK DFF_X2
X$69977 \$37647 \$30047 \$I245542 \$37126 NWELL PWELL BULK DFF_X2
X$69980 \$I177018 \$35269 \$35740 \$30047 NWELL PWELL BULK DFF_X1
X$69982 \$I176664 \$36112 \$36113 \$30047 NWELL PWELL BULK DFF_X1
X$69985 \$I175900 \$38437 \$38280 \$30047 NWELL PWELL BULK DFF_X1
X$69987 \$31761 \$32905 \$31760 \$30047 NWELL PWELL BULK DFF_X1
X$69990 \$32919 \$32056 \$32054 \$30047 NWELL PWELL BULK DFF_X1
X$69993 \$30943 \$30047 \$I245572 \$30762 NWELL PWELL BULK DFF_X2
X$69999 \$32908 \$32903 \$32899 \$30047 NWELL PWELL BULK DFF_X1
X$70002 \$30549 \$30945 \$31309 \$30047 NWELL PWELL BULK DFF_X1
X$70005 \$31765 \$30047 \$I245553 \$30764 NWELL PWELL BULK DFF_X2
X$70010 \$I177201 \$36110 \$36585 \$30047 NWELL PWELL BULK DFF_X1
X$70078 \$31026 \$30070 NWELL PWELL BULK INV_X1
X$70104 \$30077 \$30800 \$30887 NWELL PWELL BULK XNOR2_X2
X$70113 \$30290 \$30081 NWELL PWELL BULK INV_X1
X$70123 \$30083 \$31343 \$31520 \$I241534 NWELL PWELL BULK HA_X1
X$70125 \$30083 \$30084 \$30298 NWELL PWELL BULK NAND2_X1
X$70128 \$30083 \$30300 NWELL PWELL BULK INV_X2
X$70143 \$30088 \$30141 \$30607 NWELL PWELL BULK XOR2_X1
X$70151 \$30089 \$30882 \$30584 NWELL PWELL BULK XOR2_X1
X$70154 \$30089 \$30804 NWELL PWELL BULK INV_X1
X$70166 \$30102 \$30100 \$30097 NWELL PWELL BULK NAND2_X1
X$70168 \$31047 \$30326 \$30098 NWELL PWELL BULK NAND2_X1
X$70173 \$30330 \$30326 \$30100 \$30327 NWELL PWELL BULK HA_X1
X$70179 \$30101 S2_AXI_ARID[2] NWELL PWELL BULK BUF_X1
X$70183 \$30102 \$30326 \$31796 NWELL PWELL BULK NAND2_X1
X$70186 \$30102 \$30327 \$30499 NWELL PWELL BULK NAND2_X1
X$70189 \$31533 \$31258 \$30102 \$31820 NWELL PWELL BULK NAND3_X4
X$70191 \$32166 \$31258 \$30102 \$31078 NWELL PWELL BULK NAND3_X4
X$70194 \$30102 \$30329 \$30103 NWELL PWELL BULK NAND2_X1
X$70196 \$30102 \$31046 \$I241115 \$30815 NWELL PWELL BULK HA_X1
X$70199 \$30102 \$30330 \$31264 NWELL PWELL BULK NAND2_X1
X$70202 \$31047 \$30102 NWELL PWELL BULK INV_X4
X$70204 \$30102 \$30812 \$31044 NWELL PWELL BULK NAND2_X1
X$70215 \$37392 \$37127 \$I241095 \$30104 NWELL PWELL BULK HA_X1
X$70218 \$30104 \$39322 NWELL PWELL BULK INV_X1
X$70221 \$30104 \$42555 \$42909 NWELL PWELL BULK NAND2_X1
X$70238 \$41230 \$39959 \$40244 \$30109 NWELL PWELL BULK MUX2_X1
X$70241 \$30109 S1_AXI_WDATA[7] NWELL PWELL BULK BUF_X1
X$70246 \$30347 S2_AXI_ARVALID NWELL PWELL BULK BUF_X1
X$70305 \$I177816 \$30266 \$30165 \$30263 NWELL PWELL BULK DFF_X1
X$70328 \$41151 \$30187 \$40142 \$42045 NWELL PWELL BULK MUX2_X1
X$70331 \$41371 \$30187 \$40806 \$41363 NWELL PWELL BULK MUX2_X1
X$70333 \$47179 \$30187 \$46737 \$47404 NWELL PWELL BULK MUX2_X1
X$70336 \$47775 \$30187 \$47187 \$47425 NWELL PWELL BULK MUX2_X1
X$70338 \$49216 \$30187 \$47508 \$49222 NWELL PWELL BULK MUX2_X1
X$70340 \$48592 \$30187 \$48582 \$49364 NWELL PWELL BULK MUX2_X1
X$70343 \$49730 \$30187 \$48199 \$49129 NWELL PWELL BULK MUX2_X1
X$70346 \$47007 \$30187 \$46304 \$46998 NWELL PWELL BULK MUX2_X1
X$70348 \$47349 \$30187 \$43492 \$47686 NWELL PWELL BULK MUX2_X1
X$70351 \$49611 \$30187 \$44359 \$49101 NWELL PWELL BULK MUX2_X1
X$70354 \$45215 \$30187 \$46006 \$46135 NWELL PWELL BULK MUX2_X1
X$70357 \$46848 \$30187 \$42499 \$46413 NWELL PWELL BULK MUX2_X1
X$70360 \$49715 \$30187 \$48427 \$49126 NWELL PWELL BULK MUX2_X1
X$70363 \$45135 \$30187 \$44899 \$45518 NWELL PWELL BULK MUX2_X1
X$70365 \$49990 \$30187 \$45339 \$49625 NWELL PWELL BULK MUX2_X1
X$70367 \$49664 \$30187 \$48179 \$49660 NWELL PWELL BULK MUX2_X1
X$70369 \$42767 \$30187 \$41254 \$42774 NWELL PWELL BULK MUX2_X1
X$70371 \$43277 \$30187 \$42517 \$43278 NWELL PWELL BULK MUX2_X1
X$70375 \$43129 \$30187 \$42180 \$43127 NWELL PWELL BULK MUX2_X1
X$70380 \$46171 \$30187 \$42619 \$46417 NWELL PWELL BULK MUX2_X1
X$70407 \$32390 \$30187 \$32086 \$32121 NWELL PWELL BULK MUX2_X1
X$70435 M0_AXI_ARID[3] \$30861 NWELL PWELL BULK BUF_X2
X$70453 M0_AXI_AWBURST[1] \$30200 NWELL PWELL BULK BUF_X1
X$70482 \$35695 \$33845 \$30218 \$33829 \$35486 NWELL PWELL BULK AOI22_X1
X$70486 \$35695 \$36513 \$36514 \$30218 \$37457 NWELL PWELL BULK AOI22_X2
X$70489 \$32479 \$35915 \$30218 \$35465 \$35417 NWELL PWELL BULK OR4_X4
X$70491 \$35417 \$35465 \$30218 \$35915 \$35719 NWELL PWELL BULK NOR4_X4
X$70510 M1_AXI_AWADDR[24] \$30224 NWELL PWELL BULK BUF_X1
X$70525 \$31974 \$31484 \$31735 \$31488 \$30227 NWELL PWELL BULK AOI22_X1
X$70537 \$31228 \$31691 \$30232 \$32787 NWELL PWELL BULK OAI21_X4
X$70559 M0_AXI_ARLEN[0] \$30249 NWELL PWELL BULK BUF_X2
X$70576 \$30764 \$30257 \$30261 NWELL PWELL BULK XNOR2_X2
X$70593 \$30762 \$30557 \$30260 NWELL PWELL BULK XNOR2_X2
X$70604 \$31510 \$31017 \$30262 NWELL PWELL BULK XNOR2_X2
X$70613 \$32955 \$32961 \$32950 \$30263 NWELL PWELL BULK DFF_X1
X$70616 \$32426 \$32145 \$31768 \$30263 NWELL PWELL BULK DFF_X1
X$70618 \$32147 \$32541 \$32967 \$30263 NWELL PWELL BULK DFF_X1
X$70621 \$32978 \$32974 \$32148 \$30263 NWELL PWELL BULK DFF_X1
X$70624 \$32977 \$32396 \$32153 \$30263 NWELL PWELL BULK DFF_X1
X$70627 \$I176352 \$30265 \$30933 \$30263 NWELL PWELL BULK DFF_X1
X$70632 \$32422 \$31656 \$31658 \$30263 NWELL PWELL BULK DFF_X1
X$70636 \$I178103 \$30790 \$31454 \$30263 NWELL PWELL BULK DFF_X1
X$70640 \$I175265 \$31026 \$31771 \$30263 NWELL PWELL BULK DFF_X1
X$70642 \$32035 \$32383 \$31774 \$30263 NWELL PWELL BULK DFF_X1
X$70645 \$I175065 \$31029 \$31423 \$30263 NWELL PWELL BULK DFF_X1
X$70648 \$32034 \$32998 \$31776 \$30263 NWELL PWELL BULK DFF_X1
X$70650 \$I175685 \$31031 \$31634 \$30263 NWELL PWELL BULK DFF_X1
X$70656 \$I177188 \$35885 \$35748 \$30263 NWELL PWELL BULK DFF_X1
X$70659 \$I177132 \$36118 \$35745 \$30263 NWELL PWELL BULK DFF_X1
X$70662 \$36595 \$36594 \$36592 \$30263 NWELL PWELL BULK DFF_X1
X$70664 \$34481 \$34636 \$35150 \$30263 NWELL PWELL BULK DFF_X1
X$70667 \$34358 \$34360 \$34365 \$30263 NWELL PWELL BULK DFF_X1
X$70669 \$33102 \$33748 \$33752 \$30263 NWELL PWELL BULK DFF_X1
X$70671 \$33475 \$33728 \$33732 \$30263 NWELL PWELL BULK DFF_X1
X$70674 \$33734 \$33735 \$33743 \$30263 NWELL PWELL BULK DFF_X1
X$70676 \$33895 \$34375 \$34374 \$30263 NWELL PWELL BULK DFF_X1
X$70678 \$34367 \$34630 \$35143 \$30263 NWELL PWELL BULK DFF_X1
X$70707 \$30264 \$30266 \$30604 NWELL PWELL BULK NAND2_X1
X$70710 \$30264 \$30265 \$30932 NWELL PWELL BULK NAND2_X1
X$70715 \$30266 \$30265 \$31023 NWELL PWELL BULK NOR2_X1
X$70733 \$30635 \$30281 \$30784 NWELL PWELL BULK NAND2_X1
X$70743 \$30285 \$30652 NWELL PWELL BULK INV_X1
X$70760 \$30290 \$30308 \$30307 NWELL PWELL BULK XNOR2_X2
X$70774 \$30297 \$31623 \$31421 NWELL PWELL BULK XNOR2_X1
X$70782 \$31037 \$30300 \$31035 \$31036 NWELL PWELL BULK MUX2_X1
X$70787 \$30300 \$30713 \$30707 NWELL PWELL BULK NAND2_X1
X$70789 \$30300 \$30801 \$I241128 \$31786 NWELL PWELL BULK HA_X1
X$70791 \$30300 \$30729 \$30723 NWELL PWELL BULK NAND2_X1
X$70793 \$30795 \$30300 \$31521 NWELL PWELL BULK AND2_X1
X$70807 \$30797 \$30887 \$30307 \$30347 NWELL PWELL BULK NAND3_X4
X$70811 \$30801 \$30308 \$30309 NWELL PWELL BULK NAND2_X1
X$70818 \$31343 \$31995 \$30310 NWELL PWELL BULK NAND2_X1
X$70827 \$31529 \$30315 \$30805 \$31977 NWELL PWELL BULK MUX2_X1
X$70830 \$30584 \$30315 \$30582 NWELL PWELL BULK NOR2_X1
X$70832 \$30317 \$31320 \$30315 \$31042 NWELL PWELL BULK AOI21_X1
X$70834 \$30315 \$30879 \$30317 NWELL PWELL BULK NOR2_X1
X$70860 \$31047 \$30330 \$30486 NWELL PWELL BULK NAND2_X1
X$70872 \$30477 \$30333 \$30332 \$30478 NWELL PWELL BULK MUX2_X1
X$70875 \$30817 \$31052 \$31055 \$31235 \$30332 NWELL PWELL BULK FA_X1
X$70879 \$31237 \$30333 \$31593 NWELL PWELL BULK NOR2_X1
X$70882 \$31047 \$31531 \$30333 \$I241482 NWELL PWELL BULK HA_X1
X$70885 \$30333 \$31055 \$30818 NWELL PWELL BULK NOR2_X1
X$70888 \$30818 \$30817 \$30333 \$30468 NWELL PWELL BULK AOI21_X1
X$70897 \$42220 \$30334 \$41909 \$41202 NWELL PWELL BULK NOR3_X1
X$70900 \$30334 \$41909 \$41910 NWELL PWELL BULK NOR2_X2
X$70916 \$30344 \$30346 \$30345 NWELL PWELL BULK XNOR2_X1
X$70922 \$31065 \$30345 \$31066 \$31542 NWELL PWELL BULK NAND3_X2
X$70930 \$30347 \$30376 \$30801 NWELL PWELL BULK NAND2_X2
X$70938 \$34529 \$30348 NWELL PWELL BULK BUF_X8
X$70940 \$30348 \$32600 \$33150 NWELL PWELL BULK NOR2_X1
X$70942 \$33526 \$33153 \$30348 \$34029 NWELL PWELL BULK AOI21_X1
X$70945 \$30348 \$33551 \$33526 NWELL PWELL BULK NOR2_X1
X$70948 \$33150 \$32200 \$30348 \$33191 NWELL PWELL BULK AOI21_X1
X$70950 \$30348 \$33944 \$33943 NWELL PWELL BULK NOR2_X1
X$70952 \$33943 \$33513 \$30348 \$34568 NWELL PWELL BULK AOI21_X1
X$70954 \$30348 \$33138 \$33936 NWELL PWELL BULK NOR2_X1
X$70957 \$30349 \$30350 \$30348 \$30386 NWELL PWELL BULK AOI21_X1
X$70960 \$30348 \$30831 \$30349 NWELL PWELL BULK NOR2_X1
X$70963 \$36816 \$35780 \$30348 \$36159 NWELL PWELL BULK AOI21_X1
X$70965 \$30348 \$36163 \$36816 NWELL PWELL BULK NOR2_X1
X$70967 \$30348 \$37244 \$37252 NWELL PWELL BULK NOR2_X1
X$70970 \$37252 \$37247 \$30348 \$37160 NWELL PWELL BULK AOI21_X1
X$70973 \$30348 \$32181 NWELL PWELL BULK BUF_X8
X$70976 \$33936 \$33506 \$30348 \$33505 NWELL PWELL BULK AOI21_X1
X$70999 \$36216 \$36220 \$30350 NWELL PWELL BULK NOR2_X2
X$71001 \$30353 \$30350 \$30352 \$30351 NWELL PWELL BULK AOI21_X1
X$71003 \$31855 \$30350 \$31861 \$31553 NWELL PWELL BULK AOI21_X1
X$71006 \$31810 \$30350 \$31558 \$31848 NWELL PWELL BULK OAI21_X1
X$71018 \$43615 \$30352 \$42959 \$43666 NWELL PWELL BULK MUX2_X1
X$71021 \$34046 \$32200 \$30352 \$34053 NWELL PWELL BULK AOI21_X1
X$71023 \$30352 \$34041 \$34046 NWELL PWELL BULK NOR2_X1
X$71025 \$33988 \$33153 \$30352 \$33528 NWELL PWELL BULK AOI21_X1
X$71028 \$30352 \$34850 \$34869 NWELL PWELL BULK NOR2_X1
X$71030 \$34869 \$34838 \$30352 \$35339 NWELL PWELL BULK AOI21_X1
X$71033 \$30352 \$33957 \$33988 NWELL PWELL BULK NOR2_X1
X$71036 \$42274 \$40252 \$30352 \$41967 NWELL PWELL BULK AOI21_X1
X$71038 \$39901 \$30352 \$37876 \$39915 NWELL PWELL BULK MUX2_X1
X$71041 \$30352 \$41581 \$42274 NWELL PWELL BULK NOR2_X1
X$71043 \$38059 \$37247 \$30352 \$38062 NWELL PWELL BULK AOI21_X1
X$71046 \$30352 \$38049 \$38059 NWELL PWELL BULK NOR2_X1
X$71048 \$30352 \$33945 \$35310 NWELL PWELL BULK NOR2_X1
X$71050 \$35310 \$33513 \$30352 \$35391 NWELL PWELL BULK AOI21_X1
X$71052 \$30352 \$33140 \$33583 NWELL PWELL BULK NOR2_X1
X$71055 \$33583 \$33506 \$30352 \$33590 NWELL PWELL BULK AOI21_X1
X$71059 \$30352 \$31086 \$30353 NWELL PWELL BULK NOR2_X1
X$71062 \$36802 \$35780 \$30352 \$36164 NWELL PWELL BULK AOI21_X1
X$71065 \$30352 \$36165 \$36802 NWELL PWELL BULK NOR2_X1
X$71068 \$34169 \$32583 \$30352 \$33616 NWELL PWELL BULK AOI21_X1
X$71071 \$30352 \$31191 NWELL PWELL BULK BUF_X8
X$71073 \$30352 \$33612 \$34169 NWELL PWELL BULK NOR2_X1
X$71105 S2_AXI_ARREADY \$30376 NWELL PWELL BULK BUF_X2
X$71235 \$30812 \$30499 \$30513 NWELL PWELL BULK XOR2_X1
X$71258 \$30525 \$30536 \$30532 \$30759 NWELL PWELL BULK HA_X1
X$71261 \$30525 \$30527 NWELL PWELL BULK INV_X1
X$71266 \$30527 \$30998 \$31500 \$31276 NWELL PWELL BULK OR3_X1
X$71345 \$30911 \$30647 \$30786 NWELL PWELL BULK NOR2_X1
X$71405 \$33742 \$30752 \$36081 \$35717 \$36929 NWELL PWELL BULK NAND4_X2
X$71408 \$30752 \$35244 \$36077 NWELL PWELL BULK NAND2_X1
X$71411 \$35238 \$36513 \$30752 \$36514 \$37476 NWELL PWELL BULK AOI22_X1
X$71413 \$35717 \$33742 \$30752 \$34747 NWELL PWELL BULK NAND3_X2
X$71418 \$32479 \$36537 \$36538 \$30752 \$36867 NWELL PWELL BULK NOR4_X1
X$71447 \$30762 \$31012 NWELL PWELL BULK INV_X2
X$71451 \$31014 \$30762 \$31010 NWELL PWELL BULK NAND2_X1
X$71463 \$31014 \$30764 \$32439 NWELL PWELL BULK NAND2_X1
X$71481 \$31023 \$30776 \$31381 NWELL PWELL BULK AND2_X1
X$71514 \$31037 \$31039 \$30797 NWELL PWELL BULK XNOR2_X2
X$71527 \$30801 \$30800 \$31041 NWELL PWELL BULK NAND2_X1
X$71534 \$30801 \$31527 \$31988 NWELL PWELL BULK NAND2_X1
X$71538 \$30801 \$31039 \$31523 NWELL PWELL BULK NAND2_X1
X$71541 \$30801 \$31995 \$31790 NWELL PWELL BULK NAND2_X1
X$71545 \$30801 \$31343 NWELL PWELL BULK INV_X2
X$71553 \$31320 \$30882 \$30879 \$30804 \$30805 NWELL PWELL BULK FA_X1
X$71572 \$30815 \$31052 \$31237 NWELL PWELL BULK XOR2_X1
X$71575 \$30815 \$31235 NWELL PWELL BULK INV_X1
X$71590 \$I177368 \$30854 \$30822 \$30823 NWELL PWELL BULK DFF_X1
X$71593 \$30822 \$30823 \$I245670 \$31811 NWELL PWELL BULK DFF_X2
X$71596 \$I177294 \$31064 \$31808 \$30823 NWELL PWELL BULK DFF_X1
X$71598 \$I176794 \$32586 \$32183 \$30823 NWELL PWELL BULK DFF_X1
X$71601 \$31808 \$30823 \$I245608 \$33222 NWELL PWELL BULK DFF_X2
X$71603 \$32578 \$32802 \$32576 \$30823 NWELL PWELL BULK DFF_X1
X$71606 \$I174928 \$33498 \$33628 \$30823 NWELL PWELL BULK DFF_X1
X$71608 \$I178455 \$33918 \$34209 \$30823 NWELL PWELL BULK DFF_X1
X$71610 \$36918 \$35497 \$35505 \$30823 NWELL PWELL BULK DFF_X1
X$71612 \$I175309 \$33621 \$33625 \$30823 NWELL PWELL BULK DFF_X1
X$71615 \$32579 \$32783 \$32785 \$30823 NWELL PWELL BULK DFF_X1
X$71617 \$33129 \$33130 \$33234 \$30823 NWELL PWELL BULK DFF_X1
X$71620 \$I178456 \$35004 \$35484 \$30823 NWELL PWELL BULK DFF_X1
X$71623 \$34810 \$34808 \$35766 \$30823 NWELL PWELL BULK DFF_X1
X$71625 \$36148 \$36890 \$36905 \$30823 NWELL PWELL BULK DFF_X1
X$71628 \$36898 \$37285 \$37293 \$30823 NWELL PWELL BULK DFF_X1
X$71630 \$36151 \$36880 \$36613 \$30823 NWELL PWELL BULK DFF_X1
X$71633 \$33925 \$34180 \$34182 \$30823 NWELL PWELL BULK DFF_X1
X$71635 \$I178739 \$33612 \$33616 \$30823 NWELL PWELL BULK DFF_X1
X$71637 \$I176703 \$32582 \$32580 \$30823 NWELL PWELL BULK DFF_X1
X$71639 \$34144 \$33928 \$34149 \$30823 NWELL PWELL BULK DFF_X1
X$71641 \$35299 \$34974 \$34976 \$30823 NWELL PWELL BULK DFF_X1
X$71644 \$35470 \$35860 \$35768 \$30823 NWELL PWELL BULK DFF_X1
X$71647 \$34813 \$34507 \$34583 \$30823 NWELL PWELL BULK DFF_X1
X$71651 \$I175022 \$32588 \$32584 \$30823 NWELL PWELL BULK DFF_X1
X$71653 \$36856 \$36864 \$36615 \$30823 NWELL PWELL BULK DFF_X1
X$71656 \$32292 \$31812 \$31921 \$30823 NWELL PWELL BULK DFF_X1
X$71658 \$32293 \$32734 \$32732 \$30823 NWELL PWELL BULK DFF_X1
X$71661 \$33504 \$33932 \$34139 \$30823 NWELL PWELL BULK DFF_X1
X$71663 \$36290 \$36291 \$36287 \$30823 NWELL PWELL BULK DFF_X1
X$71694 M1_AXI_WDATA[22] \$30826 NWELL PWELL BULK BUF_X1
X$71697 \$31073 \$31072 \$30826 \$31154 NWELL PWELL BULK MUX2_X1
X$71700 \$30826 \$31078 \$31075 \$31152 NWELL PWELL BULK MUX2_X1
X$71703 \$30826 \$32176 \$32704 \$32705 NWELL PWELL BULK MUX2_X1
X$71705 \$30826 \$31820 \$32275 \$31904 NWELL PWELL BULK MUX2_X1
X$71712 \$31141 \$31078 \$30850 \$30827 NWELL PWELL BULK MUX2_X1
X$71715 \$38175 \$30828 \$37533 \$37594 NWELL PWELL BULK MUX2_X1
X$71717 \$36151 \$30828 \$36856 \$37273 NWELL PWELL BULK MUX2_X1
X$71720 \$40454 \$30828 \$39873 \$40444 NWELL PWELL BULK MUX2_X1
X$71723 \$39581 \$30828 \$39579 \$39869 NWELL PWELL BULK MUX2_X1
X$71726 \$32798 \$30828 \$32579 \$32788 NWELL PWELL BULK MUX2_X1
X$71729 \$32578 \$30828 \$31947 \$32804 NWELL PWELL BULK MUX2_X1
X$71732 \$36155 \$30828 \$35302 \$36156 NWELL PWELL BULK MUX2_X1
X$71735 \$31080 \$30828 \$31131 \$31081 NWELL PWELL BULK MUX2_X1
X$71737 \$33504 \$30828 \$33596 \$34962 NWELL PWELL BULK MUX2_X1
X$71740 \$36290 \$30828 \$35299 \$36851 NWELL PWELL BULK MUX2_X1
X$71743 \$34810 \$30828 \$35470 \$35295 NWELL PWELL BULK MUX2_X1
X$71746 \$32292 \$30828 \$32293 \$32187 NWELL PWELL BULK MUX2_X1
X$71749 \$34802 \$30828 \$36322 \$36144 NWELL PWELL BULK MUX2_X1
X$71752 \$36141 \$30828 \$35877 \$36143 NWELL PWELL BULK MUX2_X1
X$71755 \$34144 \$30828 \$34582 \$34508 NWELL PWELL BULK MUX2_X1
X$71758 \$33639 \$30828 \$33129 \$33494 NWELL PWELL BULK MUX2_X1
X$71761 \$41692 \$30828 \$41685 \$41693 NWELL PWELL BULK MUX2_X1
X$71763 \$41922 \$30828 \$42373 \$42374 NWELL PWELL BULK MUX2_X1
X$71765 \$42739 \$30828 \$42736 \$42732 NWELL PWELL BULK MUX2_X1
X$71767 \$42383 \$30828 \$42234 \$42581 NWELL PWELL BULK MUX2_X1
X$71769 \$43099 \$30828 \$43343 \$42588 NWELL PWELL BULK MUX2_X1
X$71771 \$42365 \$30828 \$42358 \$42587 NWELL PWELL BULK MUX2_X1
X$71773 \$32682 \$30828 \$32597 \$32671 NWELL PWELL BULK MUX2_X1
X$71775 \$42933 \$30828 \$43332 \$42582 NWELL PWELL BULK MUX2_X1
X$71777 \$38861 \$30828 \$39570 \$39969 NWELL PWELL BULK MUX2_X1
X$71780 \$41364 \$30828 \$41367 \$41564 NWELL PWELL BULK MUX2_X1
X$71782 \$41040 \$30828 \$41035 \$41402 NWELL PWELL BULK MUX2_X1
X$71784 \$41395 \$30828 \$41373 \$41707 NWELL PWELL BULK MUX2_X1
X$71786 \$32170 \$30828 \$32172 \$32174 NWELL PWELL BULK MUX2_X1
X$71789 \$31084 \$30828 \$31832 \$31833 NWELL PWELL BULK MUX2_X1
X$71792 \$31126 \$30828 \$31120 \$31834 NWELL PWELL BULK MUX2_X1
X$71795 \$33125 \$33492 \$I245606 \$30828 NWELL PWELL BULK DFF_X2
X$71797 \$31076 \$30828 \$31900 \$32276 NWELL PWELL BULK MUX2_X1
X$71799 \$31817 \$30828 \$32716 \$32282 NWELL PWELL BULK MUX2_X1
X$71802 \$36148 \$30828 \$36898 \$37279 NWELL PWELL BULK MUX2_X1
X$71804 \$36920 \$30828 \$36918 \$35763 NWELL PWELL BULK MUX2_X1
X$71807 \$39966 \$30828 \$39567 \$40476 NWELL PWELL BULK MUX2_X1
X$71810 \$38472 \$30828 \$38473 \$38559 NWELL PWELL BULK MUX2_X1
X$71812 \$38475 \$30828 \$37851 \$38476 NWELL PWELL BULK MUX2_X1
X$71814 \$35023 \$30828 \$33914 \$35869 NWELL PWELL BULK MUX2_X1
X$71816 \$38200 \$30828 \$37317 \$38205 NWELL PWELL BULK MUX2_X1
X$71819 \$33925 \$30828 \$34813 \$35296 NWELL PWELL BULK MUX2_X1
X$71822 \$32691 \$30828 \$32193 \$32694 NWELL PWELL BULK MUX2_X1
X$71824 \$31077 \$30828 \$31828 \$32194 NWELL PWELL BULK MUX2_X1
X$71826 \$32189 \$30828 \$32287 \$32730 NWELL PWELL BULK MUX2_X1
X$71829 \$30828 \$34520 NWELL PWELL BULK BUF_X16
X$71875 \$30849 \$31078 \$30829 \$31122 NWELL PWELL BULK MUX2_X1
X$71881 \$30831 \$31103 \$31086 \$31561 NWELL PWELL BULK MUX2_X1
X$71885 \$41225 \$39959 \$40385 \$30832 NWELL PWELL BULK MUX2_X1
X$71887 \$30832 S1_AXI_WID[0] NWELL PWELL BULK BUF_X1
X$71895 S1_AXI_WREADY \$31569 NWELL PWELL BULK CLKBUF_X2
X$71908 M1_AXI_WDATA[4] \$30849 NWELL PWELL BULK BUF_X1
X$71910 \$30849 \$32176 \$32199 \$32260 NWELL PWELL BULK MUX2_X1
X$71914 \$31083 \$31072 \$30849 \$31130 NWELL PWELL BULK MUX2_X1
X$71917 \$30849 \$31820 \$31552 \$31579 NWELL PWELL BULK MUX2_X1
X$71927 \$31063 \$30854 \$31065 NWELL PWELL BULK XNOR2_X1
X$71977 \$33398 \$36524 \$37072 \$30890 \$37623 NWELL PWELL BULK AOI22_X2
X$71982 \$30890 \$37270 NWELL PWELL BULK INV_X1
X$72031 \$30952 M0_AXI_AWREADY NWELL PWELL BULK BUF_X1
X$72062 \$37065 \$30970 \$50540 \$50692 NWELL PWELL BULK OAI21_X1
X$72065 \$30970 \$38363 \$38978 \$50538 NWELL PWELL BULK NOR3_X1
X$72069 \$30970 \$33391 NWELL PWELL BULK INV_X1
X$72075 M1_AXI_AWADDR[30] \$30971 NWELL PWELL BULK BUF_X1
X$72092 M0_AXI_AWADDR[30] \$30976 NWELL PWELL BULK BUF_X1
X$72133 \$32477 \$32479 \$32478 \$30992 NWELL PWELL BULK OR3_X1
X$72135 \$31485 \$30992 \$31677 NWELL PWELL BULK NOR2_X1
X$72137 \$31215 \$31488 \$30992 \$31975 NWELL PWELL BULK OAI21_X1
X$72140 \$31482 \$31484 \$30992 \$30993 \$31224 NWELL PWELL BULK NAND4_X1
X$72145 \$30993 \$31215 \$31485 NWELL PWELL BULK NOR2_X1
X$72153 \$30997 \$32509 \$32122 \$33307 NWELL PWELL BULK OR3_X4
X$72155 \$32122 \$32509 \$30997 \$33070 NWELL PWELL BULK NOR3_X4
X$72164 \$30998 \$31500 \$31754 \$32033 NWELL PWELL BULK OR3_X1
X$72168 \$31500 \$30998 \$31286 \$31692 NWELL PWELL BULK OAI21_X1
X$72170 \$31295 \$30998 \$31004 \$31680 NWELL PWELL BULK AOI21_X1
X$72172 \$30998 \$31500 \$31503 \$32038 NWELL PWELL BULK OR3_X1
X$72175 \$34204 \$35132 \$35127 \$33070 \$35140 \$35656 \$30998 NWELL PWELL
+ BULK OAI33_X1
X$72182 \$31002 \$31001 NWELL PWELL BULK INV_X1
X$72198 \$31004 \$31500 \$31755 NWELL PWELL BULK NAND2_X1
X$72201 \$31680 \$32038 \$31755 \$31005 NWELL PWELL BULK NAND3_X1
X$72215 \$31013 \$31767 \$31335 NWELL PWELL BULK NAND2_X1
X$72217 \$31013 \$32438 \$32534 NWELL PWELL BULK NAND2_X1
X$72219 \$31013 \$33326 \$I241118 \$33468 NWELL PWELL BULK HA_X1
X$72221 \$31014 \$31013 NWELL PWELL BULK INV_X4
X$72223 \$31013 \$32919 \$31670 NWELL PWELL BULK NAND2_X1
X$72225 \$31013 \$32056 \$31319 NWELL PWELL BULK NAND2_X1
X$72228 \$31013 \$32138 \$32922 NWELL PWELL BULK NAND2_X1
X$72233 \$31013 \$32137 \$32924 NWELL PWELL BULK NAND2_X1
X$72242 \$31014 \$31510 \$31016 NWELL PWELL BULK NAND2_X1
X$72248 \$31014 \$32056 \$31762 NWELL PWELL BULK NAND2_X1
X$72253 \$31014 \$32137 \$32531 NWELL PWELL BULK NAND2_X1
X$72259 \$37813 \$40682 \$31014 NWELL PWELL BULK NAND2_X4
X$72305 \$31035 \$31521 \$32012 NWELL PWELL BULK XNOR2_X1
X$72321 \$I178709 \$31039 \$31616 \$31789 NWELL PWELL BULK DFF_X1
X$72330 \$31046 \$33911 \$34251 NWELL PWELL BULK NAND2_X1
X$72332 \$31046 \$33912 \$34596 NWELL PWELL BULK NAND2_X1
X$72334 \$31046 \$32573 \$32851 NWELL PWELL BULK NAND2_X1
X$72337 \$31046 \$33239 \$33489 NWELL PWELL BULK NAND2_X1
X$72339 \$31046 \$32571 \$32847 NWELL PWELL BULK NAND2_X1
X$72341 \$31531 \$31046 NWELL PWELL BULK INV_X2
X$72349 \$31835 \$31837 \$31047 NWELL PWELL BULK NAND2_X4
X$72352 \$31047 \$31258 \$31050 NWELL PWELL BULK NAND2_X1
X$72357 \$31047 \$31533 \$31957 NWELL PWELL BULK NAND2_X1
X$72359 \$31258 \$31533 \$31047 \$32575 NWELL PWELL BULK NOR3_X4
X$72362 \$31047 \$32166 \$31258 \$32176 NWELL PWELL BULK OR3_X4
X$72365 \$31047 \$31963 \$31283 NWELL PWELL BULK NAND2_X1
X$72382 \$31056 S2_AXI_ARLEN[5] NWELL PWELL BULK BUF_X1
X$72393 \$31061 \$31064 \$31066 NWELL PWELL BULK XNOR2_X1
X$72410 \$31063 \$31539 NWELL PWELL BULK INV_X1
X$72427 \$31071 \$31593 \$31070 NWELL PWELL BULK XNOR2_X1
X$72431 \$31071 \$31835 NWELL PWELL BULK INV_X1
X$72437 \$37863 \$31072 \$37862 \$37586 NWELL PWELL BULK MUX2_X1
X$72440 \$37855 \$31072 \$37856 \$38128 NWELL PWELL BULK MUX2_X1
X$72442 \$36291 \$31072 \$35462 \$36287 NWELL PWELL BULK MUX2_X1
X$72444 \$31812 \$31072 \$31813 \$31921 NWELL PWELL BULK MUX2_X1
X$72447 \$33928 \$31072 \$33929 \$34149 NWELL PWELL BULK MUX2_X1
X$72449 \$34522 \$31072 \$34523 \$35373 NWELL PWELL BULK MUX2_X1
X$72451 \$35787 \$31072 \$35788 \$36246 NWELL PWELL BULK MUX2_X1
X$72454 \$32596 \$31072 \$31141 \$33200 NWELL PWELL BULK MUX2_X1
X$72457 \$39372 \$31072 \$39371 \$39482 NWELL PWELL BULK MUX2_X1
X$72460 \$38944 \$31072 \$39365 \$39502 NWELL PWELL BULK MUX2_X1
X$72462 \$37166 \$31072 \$37167 \$37234 NWELL PWELL BULK MUX2_X1
X$72464 \$36173 \$31072 \$33517 \$36235 NWELL PWELL BULK MUX2_X1
X$72466 \$36736 \$31072 \$36720 \$36727 NWELL PWELL BULK MUX2_X1
X$72468 \$37216 \$31072 \$36634 \$37174 NWELL PWELL BULK MUX2_X1
X$72470 \$39878 \$31072 \$40235 \$40422 NWELL PWELL BULK MUX2_X1
X$72472 \$41236 \$31072 \$40862 \$40867 NWELL PWELL BULK MUX2_X1
X$72474 \$40327 \$31072 \$39896 \$39928 NWELL PWELL BULK MUX2_X1
X$72476 \$39462 \$31072 \$37548 \$39459 NWELL PWELL BULK MUX2_X1
X$72479 \$42649 \$31072 \$42601 \$43035 NWELL PWELL BULK MUX2_X1
X$72481 \$41992 \$31072 \$40784 \$42000 NWELL PWELL BULK MUX2_X1
X$72483 \$33950 \$31072 \$33146 \$34909 NWELL PWELL BULK MUX2_X1
X$72488 \$31072 \$32575 NWELL PWELL BULK BUF_X8
X$72491 \$32698 \$31072 \$31547 \$32274 NWELL PWELL BULK MUX2_X1
X$72532 \$36611 \$31078 \$36880 \$36613 NWELL PWELL BULK MUX2_X1
X$72535 \$37147 \$31078 \$37848 \$38184 NWELL PWELL BULK MUX2_X1
X$72538 \$40228 \$31078 \$41006 \$40495 NWELL PWELL BULK MUX2_X1
X$72540 \$31802 \$31078 \$31537 \$32313 NWELL PWELL BULK MUX2_X1
X$72543 \$38866 \$31078 \$39961 \$39871 NWELL PWELL BULK MUX2_X1
X$72545 \$37862 \$31078 \$38544 \$38536 NWELL PWELL BULK MUX2_X1
X$72547 \$37856 \$31078 \$38120 \$38979 NWELL PWELL BULK MUX2_X1
X$72549 \$34800 \$31078 \$34802 \$35050 NWELL PWELL BULK MUX2_X1
X$72553 \$34505 \$31078 \$36317 \$36926 NWELL PWELL BULK MUX2_X1
X$72555 \$31813 \$31078 \$31914 \$31917 NWELL PWELL BULK MUX2_X1
X$72557 \$37536 \$31078 \$38561 \$38163 NWELL PWELL BULK MUX2_X1
X$72560 \$38859 \$31078 \$39000 \$39012 NWELL PWELL BULK MUX2_X1
X$72563 \$37548 \$31078 \$37946 \$37943 NWELL PWELL BULK MUX2_X1
X$72565 \$34523 \$31078 \$35361 \$34884 NWELL PWELL BULK MUX2_X1
X$72567 \$42232 \$31078 \$42743 \$42577 NWELL PWELL BULK MUX2_X1
X$72569 \$41930 \$31078 \$42029 \$42031 NWELL PWELL BULK MUX2_X1
X$72571 \$40784 \$31078 \$40842 \$40315 NWELL PWELL BULK MUX2_X1
X$72573 \$39896 \$31078 \$39434 \$39445 NWELL PWELL BULK MUX2_X1
X$72575 \$35788 \$31078 \$36751 \$36767 NWELL PWELL BULK MUX2_X1
X$72577 \$33146 \$31078 \$33563 \$33566 NWELL PWELL BULK MUX2_X1
X$72579 \$33517 \$31078 \$34921 \$34563 NWELL PWELL BULK MUX2_X1
X$72581 \$36720 \$31078 \$37173 \$37984 NWELL PWELL BULK MUX2_X1
X$72584 \$40862 \$31078 \$41238 \$41649 NWELL PWELL BULK MUX2_X1
X$72586 \$37167 \$31078 \$37226 \$37227 NWELL PWELL BULK MUX2_X1
X$72589 \$42586 \$31078 \$43103 \$43096 NWELL PWELL BULK MUX2_X1
X$72591 \$42592 \$31078 \$42245 \$42596 NWELL PWELL BULK MUX2_X1
X$72593 \$40235 \$31078 \$41331 \$41345 NWELL PWELL BULK MUX2_X1
X$72596 \$40978 \$31078 \$41353 \$41690 NWELL PWELL BULK MUX2_X1
X$72599 \$41562 \$31078 \$42053 \$42059 NWELL PWELL BULK MUX2_X1
X$72601 \$39365 \$31078 \$40896 \$40370 NWELL PWELL BULK MUX2_X1
X$72603 \$39371 \$31078 \$39480 \$38887 NWELL PWELL BULK MUX2_X1
X$72606 \$42601 \$31078 \$43368 \$43391 NWELL PWELL BULK MUX2_X1
X$72608 \$36634 \$31078 \$36698 \$36702 NWELL PWELL BULK MUX2_X1
X$72610 \$32178 \$31078 \$31806 \$32301 NWELL PWELL BULK MUX2_X1
X$72614 \$33501 \$31078 \$34180 \$34182 NWELL PWELL BULK MUX2_X1
X$72617 \$31547 \$31078 \$31146 \$31587 NWELL PWELL BULK MUX2_X1
X$72619 \$33929 \$31078 \$33932 \$34139 NWELL PWELL BULK MUX2_X1
X$72622 \$35462 \$31078 \$36274 \$36279 NWELL PWELL BULK MUX2_X1
X$72684 \$32671 \$31081 \$31815 \$32198 NWELL PWELL BULK MUX2_X2
X$72690 \$31555 \$31103 \$31085 \$31559 NWELL PWELL BULK MUX2_X1
X$72692 \$31810 \$31085 \$31558 NWELL PWELL BULK NAND2_X1
X$72714 \$35783 \$31103 \$35306 \$36249 NWELL PWELL BULK MUX2_X1
X$72717 \$36163 \$31103 \$36165 \$36166 NWELL PWELL BULK MUX2_X1
X$72720 \$57773 \$31103 \$58573 \$57775 NWELL PWELL BULK MUX2_X1
X$72722 \$54138 \$31103 \$53800 \$54195 NWELL PWELL BULK MUX2_X1
X$72724 \$38949 \$31103 \$39506 \$38883 NWELL PWELL BULK MUX2_X1
X$72726 \$54649 \$31103 \$55550 \$53802 NWELL PWELL BULK MUX2_X1
X$72728 \$63180 \$31103 \$62872 \$62874 NWELL PWELL BULK MUX2_X1
X$72731 \$63183 \$31103 \$62920 \$61376 NWELL PWELL BULK MUX2_X1
X$72734 \$60804 \$31103 \$60769 \$60795 NWELL PWELL BULK MUX2_X1
X$72736 \$60771 \$31103 \$60774 \$60775 NWELL PWELL BULK MUX2_X1
X$72739 \$33551 \$31103 \$33957 \$33997 NWELL PWELL BULK MUX2_X1
X$72742 \$32605 \$31103 \$32608 \$33556 NWELL PWELL BULK MUX2_X1
X$72744 \$32600 \$31103 \$34041 \$33522 NWELL PWELL BULK MUX2_X1
X$72747 \$51687 \$31103 \$52204 \$51690 NWELL PWELL BULK MUX2_X1
X$72749 \$52968 \$31103 \$52185 \$52608 NWELL PWELL BULK MUX2_X1
X$72751 \$49238 \$31103 \$49573 \$49574 NWELL PWELL BULK MUX2_X1
X$72754 \$50627 \$31103 \$50644 \$50947 NWELL PWELL BULK MUX2_X1
X$72756 \$38896 \$31103 \$39901 \$40254 NWELL PWELL BULK MUX2_X1
X$72758 \$41578 \$31103 \$41581 \$41582 NWELL PWELL BULK MUX2_X1
X$72760 \$33944 \$31103 \$33945 \$34564 NWELL PWELL BULK MUX2_X1
X$72762 \$34840 \$31103 \$34850 \$36203 NWELL PWELL BULK MUX2_X1
X$72764 \$48303 \$31103 \$48319 \$47974 NWELL PWELL BULK MUX2_X1
X$72766 \$47606 \$31103 \$47608 \$47607 NWELL PWELL BULK MUX2_X1
X$72769 \$49207 \$31103 \$49558 \$49570 NWELL PWELL BULK MUX2_X1
X$72771 \$52170 \$31103 \$52601 \$52655 NWELL PWELL BULK MUX2_X1
X$72773 \$53292 \$31103 \$53797 \$53377 NWELL PWELL BULK MUX2_X1
X$72775 \$52605 \$31103 \$52179 \$52625 NWELL PWELL BULK MUX2_X1
X$72777 \$56749 \$31103 \$56750 \$57382 NWELL PWELL BULK MUX2_X1
X$72779 \$54143 \$31103 \$54147 \$54174 NWELL PWELL BULK MUX2_X1
X$72781 \$55551 \$31103 \$55552 \$54150 NWELL PWELL BULK MUX2_X1
X$72783 \$61251 \$31103 \$62468 \$62291 NWELL PWELL BULK MUX2_X1
X$72785 \$61912 \$31103 \$61253 \$61374 NWELL PWELL BULK MUX2_X1
X$72787 \$59503 \$31103 \$59502 \$59530 NWELL PWELL BULK MUX2_X1
X$72789 \$58980 \$31103 \$60065 \$58982 NWELL PWELL BULK MUX2_X1
X$72791 \$42998 \$31103 \$43615 \$44026 NWELL PWELL BULK MUX2_X1
X$72794 \$43647 \$31103 \$42977 \$44028 NWELL PWELL BULK MUX2_X1
X$72796 \$40816 \$31103 \$41241 \$40789 NWELL PWELL BULK MUX2_X1
X$72798 \$37877 \$31103 \$37878 \$38492 NWELL PWELL BULK MUX2_X1
X$72800 \$36185 \$31103 \$36639 \$36187 NWELL PWELL BULK MUX2_X1
X$72802 \$37244 \$31103 \$38049 \$37867 NWELL PWELL BULK MUX2_X1
X$72804 \$33138 \$31103 \$33140 \$33511 NWELL PWELL BULK MUX2_X1
X$72806 \$32589 \$31103 NWELL PWELL BULK BUF_X32
X$72809 \$33143 \$31103 \$33573 \$33946 NWELL PWELL BULK MUX2_X1
X$72811 \$34938 \$31103 \$33940 \$34569 NWELL PWELL BULK MUX2_X1
X$72815 \$32629 \$31103 \$32610 \$32621 NWELL PWELL BULK MUX2_X1
X$72902 \$31137 \$38355 \$35140 \$50301 NWELL PWELL BULK NOR3_X1
X$72905 \$31137 \$38724 \$50539 NWELL PWELL BULK NOR2_X1
X$72908 \$33384 \$31137 \$34045 \$33386 \$33209 NWELL PWELL BULK OAI22_X2
X$72922 M1_AXI_WDATA[13] \$31141 NWELL PWELL BULK BUF_X1
X$72926 \$31141 \$31820 \$31548 \$31583 NWELL PWELL BULK MUX2_X1
X$72928 \$31141 \$32176 \$32265 \$32196 NWELL PWELL BULK MUX2_X1
X$72964 M0_AXI_AWADDR[12] \$31179 NWELL PWELL BULK BUF_X1
X$72982 \$44782 \$31191 NWELL PWELL BULK BUF_X8
X$72984 \$31191 \$38478 \$38873 NWELL PWELL BULK NOR2_X1
X$72987 \$38873 \$39549 \$31191 \$38984 NWELL PWELL BULK AOI21_X1
X$72989 \$43845 \$43333 \$31191 \$43118 NWELL PWELL BULK AOI21_X1
X$72992 \$31191 \$42937 \$43845 NWELL PWELL BULK NOR2_X1
X$72998 \$35004 \$31191 \$33131 \$35484 NWELL PWELL BULK MUX2_X1
X$73066 M0_AXI_AWVALID \$31245 NWELL PWELL BULK CLKBUF_X2
X$73081 \$31257 \$38803 \$35140 \$42532 NWELL PWELL BULK NOR3_X1
X$73084 \$31257 \$38724 \$42531 NWELL PWELL BULK NOR2_X1
X$73087 \$36426 \$41424 \$39834 \$31257 \$37129 \$41123 NWELL PWELL BULK
+ OAI221_X2
X$73089 \$33384 \$31257 \$40188 \$34764 \$40185 NWELL PWELL BULK OAI22_X2
X$73108 \$31258 \$33912 \$32839 NWELL PWELL BULK XNOR2_X2
X$73121 \$43780 \$43526 \$31268 \$43949 NWELL PWELL BULK MUX2_X2
X$73123 \$44902 \$44580 \$31268 \$46444 NWELL PWELL BULK MUX2_X2
X$73126 \$46657 \$46743 \$31268 \$47436 NWELL PWELL BULK MUX2_X2
X$73129 \$47757 \$47184 \$31268 \$47532 NWELL PWELL BULK MUX2_X2
X$73132 \$48552 \$31268 \$48321 \$48325 NWELL PWELL BULK MUX2_X1
X$73134 \$46164 \$31268 \$46015 \$47511 NWELL PWELL BULK MUX2_X1
X$73136 \$49468 \$31268 \$48561 \$50323 NWELL PWELL BULK MUX2_X1
X$73139 \$49107 \$31268 \$48176 \$49284 NWELL PWELL BULK MUX2_X1
X$73141 \$49658 \$31268 \$48565 \$49473 NWELL PWELL BULK MUX2_X1
X$73144 \$49347 \$50057 \$31268 \$49850 NWELL PWELL BULK MUX2_X2
X$73146 \$49363 \$49130 \$31268 \$49374 NWELL PWELL BULK MUX2_X2
X$73148 \$48095 \$48207 \$31268 \$48206 NWELL PWELL BULK MUX2_X2
X$73151 \$48487 \$31268 \$48924 \$49137 NWELL PWELL BULK MUX2_X1
X$73153 \$47163 \$31268 \$48021 \$47698 NWELL PWELL BULK MUX2_X1
X$73155 \$46720 \$31268 \$47653 \$50537 NWELL PWELL BULK MUX2_X1
X$73158 \$47278 \$31268 \$46412 \$47155 NWELL PWELL BULK MUX2_X1
X$73186 \$32405 \$31749 \$31268 \$32848 NWELL PWELL BULK MUX2_X2
X$73256 \$31343 \$31527 \$31347 NWELL PWELL BULK NAND2_X1
X$73259 \$31343 \$32160 \$32001 NWELL PWELL BULK NAND2_X1
X$73263 \$31343 \$32161 \$31795 NWELL PWELL BULK NAND2_X1
X$73266 \$31343 \$31793 \$32346 NWELL PWELL BULK NAND2_X1
X$73268 \$31343 \$31791 \$32916 NWELL PWELL BULK NAND2_X1
X$73291 M0_AXI_ARLEN[6] \$31363 NWELL PWELL BULK BUF_X2
X$73348 \$31434 S2_AXI_ARID[0] NWELL PWELL BULK BUF_X1
X$73355 \$31440 S2_AXI_ARLEN[1] NWELL PWELL BULK BUF_X1
X$73390 M0_AXI_AWBURST[0] \$31461 NWELL PWELL BULK BUF_X1
X$73419 \$31482 \$33057 \$32487 \$32778 NWELL PWELL BULK AND3_X1
X$73421 \$34731 \$35019 \$34729 \$31482 NWELL PWELL BULK NAND3_X2
X$73423 \$31677 \$31482 \$31730 \$31965 NWELL PWELL BULK AOI21_X1
X$73425 \$31490 \$31735 \$31482 \$31736 NWELL PWELL BULK AOI21_X1
X$73428 \$31486 \$31482 \$31975 \$31974 NWELL PWELL BULK OAI21_X1
X$73430 \$31738 \$31482 \$31992 \$31739 NWELL PWELL BULK NAND3_X1
X$73443 \$32097 \$32322 \$31484 NWELL PWELL BULK OR2_X2
X$73445 \$31484 \$31488 \$32110 \$33321 \$34186 NWELL PWELL BULK NAND4_X2
X$73447 \$31735 \$31484 \$32102 \$31731 NWELL PWELL BULK OAI21_X1
X$73452 \$31484 \$31488 \$31485 \$31490 NWELL PWELL BULK AOI21_X1
X$73455 \$32118 \$31484 \$32110 \$32490 NWELL PWELL BULK MUX2_X2
X$73457 \$32102 \$31736 \$31486 \$31484 \$32336 NWELL PWELL BULK OAI22_X1
X$73460 \$31484 \$32112 \$32792 \$32797 NWELL PWELL BULK OR3_X1
X$73478 \$32095 \$31486 NWELL PWELL BULK INV_X1
X$73480 \$31735 \$31486 \$32110 \$32487 NWELL PWELL BULK AND3_X1
X$73483 \$31486 \$31733 \$31731 \$31730 NWELL PWELL BULK OAI21_X1
X$73488 \$31486 \$31735 \$32768 NWELL PWELL BULK NAND2_X1
X$73492 \$32110 \$31486 \$32483 NWELL PWELL BULK NAND2_X1
X$73500 \$34729 \$35019 \$34731 \$31488 NWELL PWELL BULK AND3_X2
X$73503 \$33429 \$31488 \$32487 \$34673 NWELL PWELL BULK AOI21_X2
X$73518 \$32386 \$31741 \$32086 \$31492 NWELL PWELL BULK MUX2_X1
X$73523 \$43785 \$31495 \$43790 \$43526 NWELL PWELL BULK MUX2_X1
X$73525 \$42388 \$31495 \$43129 \$41858 NWELL PWELL BULK MUX2_X1
X$73528 \$42526 \$31495 \$42182 \$42078 NWELL PWELL BULK MUX2_X1
X$73531 \$31496 \$31495 \$32023 \$31749 NWELL PWELL BULK MUX2_X1
X$73533 \$43947 \$31495 \$44494 \$44580 NWELL PWELL BULK MUX2_X1
X$73535 \$45515 \$31495 \$45523 \$44902 NWELL PWELL BULK MUX2_X1
X$73537 \$47015 \$31495 \$46052 \$46743 NWELL PWELL BULK MUX2_X1
X$73540 \$47182 \$31495 \$47416 \$47184 NWELL PWELL BULK MUX2_X1
X$73543 \$48087 \$31495 \$48090 \$48095 NWELL PWELL BULK MUX2_X1
X$73545 \$46319 \$31495 \$46652 \$46657 NWELL PWELL BULK MUX2_X1
X$73548 \$48075 \$31495 \$48456 \$50057 NWELL PWELL BULK MUX2_X1
X$73550 \$48551 \$31495 \$48717 \$48552 NWELL PWELL BULK MUX2_X1
X$73552 \$49978 \$31495 \$49467 \$49468 NWELL PWELL BULK MUX2_X1
X$73554 \$46012 \$31495 \$46542 \$46164 NWELL PWELL BULK MUX2_X1
X$73557 \$46008 \$31495 \$45631 \$47278 NWELL PWELL BULK MUX2_X1
X$73560 \$46877 \$31495 \$46875 \$46720 NWELL PWELL BULK MUX2_X1
X$73562 \$48560 \$31495 \$48757 \$48561 NWELL PWELL BULK MUX2_X1
X$73564 \$49110 \$31495 \$49649 \$49658 NWELL PWELL BULK MUX2_X1
X$73566 \$48780 \$31495 \$48175 \$48176 NWELL PWELL BULK MUX2_X1
X$73568 \$31745 \$31495 \$31746 \$32405 NWELL PWELL BULK MUX2_X1
X$73571 \$49357 \$31495 \$49491 \$49363 NWELL PWELL BULK MUX2_X1
X$73573 \$48591 \$31495 \$48593 \$48487 NWELL PWELL BULK MUX2_X1
X$73576 \$48922 \$31495 \$48917 \$48924 NWELL PWELL BULK MUX2_X1
X$73578 \$48011 \$31495 \$47517 \$48021 NWELL PWELL BULK MUX2_X1
X$73581 \$48879 \$31495 \$49128 \$49347 NWELL PWELL BULK MUX2_X1
X$73583 \$48890 \$31495 \$48202 \$49130 NWELL PWELL BULK MUX2_X1
X$73585 \$47178 \$31495 \$47180 \$47757 NWELL PWELL BULK MUX2_X1
X$73587 \$47787 \$31495 \$48097 \$48207 NWELL PWELL BULK MUX2_X1
X$73590 \$45217 \$31495 \$45635 \$46015 NWELL PWELL BULK MUX2_X1
X$73592 \$47649 \$31495 \$47647 \$47653 NWELL PWELL BULK MUX2_X1
X$73594 \$46839 \$31495 \$46841 \$46412 NWELL PWELL BULK MUX2_X1
X$73597 \$47615 \$31495 \$47848 \$48321 NWELL PWELL BULK MUX2_X1
X$73601 \$46921 \$31495 \$47162 \$47163 NWELL PWELL BULK MUX2_X1
X$73604 \$49106 \$31495 \$49831 \$49107 NWELL PWELL BULK MUX2_X1
X$73607 \$48791 \$31495 \$48800 \$48565 NWELL PWELL BULK MUX2_X1
X$73611 \$43775 \$31495 \$42875 \$43780 NWELL PWELL BULK MUX2_X1
X$73614 \$43516 \$31495 \$43277 \$42518 NWELL PWELL BULK MUX2_X1
X$73616 \$43082 \$31495 \$42717 \$42723 NWELL PWELL BULK MUX2_X1
X$73669 \$38234 \$37110 \$38667 \$31500 NWELL PWELL BULK OAI21_X2
X$73703 \$32563 \$32560 \$31520 \$32960 NWELL PWELL BULK AOI21_X1
X$73705 \$32973 \$31520 \$32159 \$32981 NWELL PWELL BULK MUX2_X1
X$73707 \$31785 \$31520 \$31623 NWELL PWELL BULK NOR2_X1
X$73710 \$31520 \$32941 \$32563 NWELL PWELL BULK NOR2_X1
X$73722 \$32161 \$31527 \$31794 \$31789 NWELL PWELL BULK DFF_X1
X$73725 \$31527 \$31995 \$31791 \$31793 NWELL PWELL BULK HA_X1
X$73738 \$31531 \$33911 \$35060 NWELL PWELL BULK NAND2_X1
X$73741 \$31531 \$34498 \$34252 NWELL PWELL BULK NAND2_X1
X$73743 \$31531 \$34247 \$33663 NWELL PWELL BULK NAND2_X1
X$73746 \$31531 \$33487 \$32568 NWELL PWELL BULK NAND2_X1
X$73749 \$31531 \$33123 \$32565 NWELL PWELL BULK NAND2_X1
X$73752 \$31531 \$32573 \$33659 NWELL PWELL BULK NAND2_X1
X$73755 \$31531 \$42914 \$43454 \$43229 NWELL PWELL BULK AOI21_X4
X$73771 \$31533 \$32166 NWELL PWELL BULK INV_X1
X$73780 \$31533 \$33239 \$33246 NWELL PWELL BULK XNOR2_X2
X$73796 \$31542 S0_AXI_WVALID NWELL PWELL BULK BUF_X1
X$73802 \$31813 \$31820 \$31545 \$31911 NWELL PWELL BULK MUX2_X1
X$73805 \$31547 \$31820 \$31826 \$31546 NWELL PWELL BULK MUX2_X1
X$73810 M1_AXI_WDATA[16] \$31547 NWELL PWELL BULK BUF_X1
X$73813 \$31547 \$32176 \$33518 \$33144 NWELL PWELL BULK MUX2_X1
X$73832 \$31861 \$31555 \$31855 NWELL PWELL BULK NOR2_X1
X$73838 \$31561 \$32206 \$31559 \$32611 NWELL PWELL BULK MUX2_X1
X$73844 \$31858 S1_AXI_WVALID NWELL PWELL BULK BUF_X1
X$73849 S0_AXI_RID[0] \$32214 NWELL PWELL BULK CLKBUF_X3
X$73854 \$31858 \$31569 \$36131 NWELL PWELL BULK NAND2_X2
X$73904 \$31949 \$36045 \$36046 \$31622 \$32745 NWELL PWELL BULK NOR4_X4
X$73906 \$31949 \$36045 \$36046 \$31622 \$36843 NWELL PWELL BULK OR4_X2
X$73908 \$34917 \$36513 \$31622 \$36514 \$38587 NWELL PWELL BULK AOI22_X1
X$73911 \$34917 \$33845 \$31622 \$33829 \$33830 NWELL PWELL BULK AOI22_X1
X$73942 \$32044 \$31642 NWELL PWELL BULK INV_X1
X$74011 M0_AXI_AWADDR[6] \$31705 NWELL PWELL BULK BUF_X1
X$74046 \$I178746 \$33389 \$34028 \$31723 NWELL PWELL BULK DFF_X1
X$74049 \$I175397 \$36498 \$37232 \$31723 NWELL PWELL BULK DFF_X1
X$74052 \$I174365 \$36496 \$36493 \$31723 NWELL PWELL BULK DFF_X1
X$74054 \$33983 \$34548 \$33973 \$31723 NWELL PWELL BULK DFF_X1
X$74056 \$33171 \$33974 \$33534 \$31723 NWELL PWELL BULK DFF_X1
X$74059 \$36025 \$35836 \$35665 \$31723 NWELL PWELL BULK DFF_X1
X$74061 \$I178729 \$34577 \$34885 \$31723 NWELL PWELL BULK DFF_X1
X$74063 \$I174829 \$34008 \$34561 \$31723 NWELL PWELL BULK DFF_X1
X$74065 \$I178747 \$34696 \$34694 \$31723 NWELL PWELL BULK DFF_X1
X$74068 \$32456 \$33547 \$33553 \$31723 NWELL PWELL BULK DFF_X1
X$74071 \$33020 \$32628 \$32453 \$31723 NWELL PWELL BULK DFF_X1
X$74073 \$I174482 \$35198 \$35371 \$31723 NWELL PWELL BULK DFF_X1
X$74075 \$I178703 \$31725 \$31923 \$31723 NWELL PWELL BULK DFF_X1
X$74077 \$I176620 \$31724 \$32291 \$31723 NWELL PWELL BULK DFF_X1
X$74079 \$I178803 \$32280 \$32087 \$31723 NWELL PWELL BULK DFF_X1
X$74082 \$I176685 \$34113 \$34104 \$31723 NWELL PWELL BULK DFF_X1
X$74084 \$I175650 \$33041 \$33253 \$31723 NWELL PWELL BULK DFF_X1
X$74087 \$I175415 \$34073 \$34592 \$31723 NWELL PWELL BULK DFF_X1
X$74089 \$I178734 \$35403 \$35400 \$31723 NWELL PWELL BULK DFF_X1
X$74092 \$I178760 \$33397 \$33594 \$31723 NWELL PWELL BULK DFF_X1
X$74095 \$I175423 \$33396 \$32463 \$31723 NWELL PWELL BULK DFF_X1
X$74098 \$I175441 \$34700 \$34697 \$31723 NWELL PWELL BULK DFF_X1
X$74100 \$I178759 \$34589 \$34396 \$31723 NWELL PWELL BULK DFF_X1
X$74104 \$I178769 \$35672 \$36243 \$31723 NWELL PWELL BULK DFF_X1
X$74106 \$I175395 \$37438 \$37223 \$31723 NWELL PWELL BULK DFF_X1
X$74109 \$I175440 \$36029 \$36250 \$31723 NWELL PWELL BULK DFF_X1
X$74112 \$I178686 \$35206 \$35406 \$31723 NWELL PWELL BULK DFF_X1
X$74115 \$I178732 \$33826 \$34079 \$31723 NWELL PWELL BULK DFF_X1
X$74117 \$I175528 \$33033 \$32464 \$31723 NWELL PWELL BULK DFF_X1
X$74120 \$I176074 \$33036 \$33601 \$31723 NWELL PWELL BULK DFF_X1
X$74153 M0_AXI_AWADDR[15] \$31726 NWELL PWELL BULK BUF_X1
X$74172 \$31732 \$31733 \$32095 \$32101 \$31738 NWELL PWELL BULK OAI22_X1
X$74175 \$31735 \$32102 \$31732 \$32339 NWELL PWELL BULK OAI21_X1
X$74178 \$32322 \$32097 \$31733 NWELL PWELL BULK NOR2_X1
X$74186 \$35028 \$34735 \$34148 \$31735 \$33857 NWELL PWELL BULK NAND4_X1
X$74188 \$31735 \$32095 \$33854 NWELL PWELL BULK OR2_X1
X$74194 \$31735 \$32483 \$31739 \$32106 NWELL PWELL BULK OAI21_X1
X$74223 \$31740 \$32118 NWELL PWELL BULK INV_X1
X$74225 \$41152 \$31741 \$40142 \$41359 NWELL PWELL BULK MUX2_X1
X$74228 \$41368 \$31741 \$40806 \$41498 NWELL PWELL BULK MUX2_X1
X$74231 \$42388 \$31741 \$42180 \$42523 NWELL PWELL BULK MUX2_X1
X$74234 \$44898 \$31741 \$44899 \$45513 NWELL PWELL BULK MUX2_X1
X$74237 \$48877 \$31741 \$48427 \$49344 NWELL PWELL BULK MUX2_X1
X$74240 \$46316 \$31741 \$46304 \$46049 NWELL PWELL BULK MUX2_X1
X$74242 \$48165 \$31741 \$47508 \$48549 NWELL PWELL BULK MUX2_X1
X$74244 \$49259 \$31741 \$44359 \$49256 NWELL PWELL BULK MUX2_X1
X$74247 \$49266 \$31741 \$45339 \$49272 NWELL PWELL BULK MUX2_X1
X$74250 \$49646 \$31741 \$48179 \$49289 NWELL PWELL BULK MUX2_X1
X$74252 \$49352 \$31741 \$48199 \$49717 NWELL PWELL BULK MUX2_X1
X$74255 \$46013 \$31741 \$42499 \$46151 NWELL PWELL BULK MUX2_X1
X$74257 \$40688 \$31741 \$40684 \$41146 NWELL PWELL BULK MUX2_X1
X$74260 \$48204 \$31741 \$48582 \$48901 NWELL PWELL BULK MUX2_X1
X$74263 \$48085 \$31741 \$47187 \$47766 NWELL PWELL BULK MUX2_X1
X$74265 \$46978 \$31741 \$46737 \$46976 NWELL PWELL BULK MUX2_X1
X$74267 \$46913 \$31741 \$43492 \$47161 NWELL PWELL BULK MUX2_X1
X$74269 \$46124 \$31741 \$46006 \$46131 NWELL PWELL BULK MUX2_X1
X$74271 \$46864 \$31741 \$42619 \$46867 NWELL PWELL BULK MUX2_X1
X$74273 \$43476 \$31741 \$41254 \$43773 NWELL PWELL BULK MUX2_X1
X$74275 \$43516 \$31741 \$42517 \$43740 NWELL PWELL BULK MUX2_X1
X$74306 \$31742 \$32377 NWELL PWELL BULK INV_X1
X$74334 \$31767 \$32534 \$32436 NWELL PWELL BULK XOR2_X1
X$74346 \$34271 \$31781 \$35754 \$34266 NWELL PWELL BULK HA_X1
X$74359 \$31786 \$32363 \$31785 NWELL PWELL BULK XOR2_X1
X$74365 \$31786 \$32971 NWELL PWELL BULK INV_X1
X$74369 \$37825 \$38843 \$38841 \$31789 NWELL PWELL BULK DFF_X1
X$74372 \$41098 \$31789 \$I245590 \$38289 NWELL PWELL BULK DFF_X2
X$74374 \$39685 \$31789 \$I245736 \$38456 NWELL PWELL BULK DFF_X2
X$74376 \$39701 \$31789 \$I245591 \$37830 NWELL PWELL BULK DFF_X2
X$74378 \$41767 \$31789 \$I245753 \$37613 NWELL PWELL BULK DFF_X2
X$74380 \$42115 \$31789 \$I245734 \$38457 NWELL PWELL BULK DFF_X2
X$74383 \$I175459 \$35749 \$35114 \$31789 NWELL PWELL BULK DFF_X1
X$74385 \$34310 \$34317 \$33900 \$31789 NWELL PWELL BULK DFF_X1
X$74387 \$34621 \$34328 \$34487 \$31789 NWELL PWELL BULK DFF_X1
X$74390 \$34332 \$33715 \$33717 \$31789 NWELL PWELL BULK DFF_X1
X$74392 \$33695 \$33696 \$33480 \$31789 NWELL PWELL BULK DFF_X1
X$74394 \$32551 \$33273 \$33113 \$31789 NWELL PWELL BULK DFF_X1
X$74397 \$33482 \$31789 \$34269 \$33683 NWELL PWELL BULK DFF_X2
X$74400 \$32548 \$33705 \$33109 \$31789 NWELL PWELL BULK DFF_X1
X$74403 \$33115 \$31789 \$33689 \$33269 NWELL PWELL BULK DFF_X2
X$74407 \$34495 \$31789 \$60539 \$34606 NWELL PWELL BULK DFF_X2
X$74409 \$I175402 \$38847 \$40572 \$31789 NWELL PWELL BULK DFF_X1
X$74411 \$I178020 \$37020 \$36127 \$31789 NWELL PWELL BULK DFF_X1
X$74413 \$I178256 \$36125 \$35880 \$31789 NWELL PWELL BULK DFF_X1
X$74416 \$36122 \$31789 \$I245577 \$36126 NWELL PWELL BULK DFF_X2
X$74418 \$I177183 \$36600 \$35282 \$31789 NWELL PWELL BULK DFF_X1
X$74421 \$I175491 \$35752 \$36357 \$31789 NWELL PWELL BULK DFF_X1
X$74425 \$I178764 \$32160 \$32923 \$31789 NWELL PWELL BULK DFF_X1
X$74430 \$33121 \$31789 \$33680 \$32995 NWELL PWELL BULK DFF_X2
X$74433 \$32973 \$32159 \$32362 \$31789 NWELL PWELL BULK DFF_X1
X$74436 \$I178780 \$32560 \$33675 \$31789 NWELL PWELL BULK DFF_X1
X$74438 \$I174704 \$31995 \$32350 \$31789 NWELL PWELL BULK DFF_X1
X$74481 \$31802 \$31820 \$32175 \$32310 NWELL PWELL BULK MUX2_X1
X$74484 M1_AXI_WSTRB[3] \$31802 NWELL PWELL BULK CLKBUF_X2
X$74487 \$31802 \$32176 \$33130 \$33234 NWELL PWELL BULK MUX2_X1
X$74490 \$33643 \$32575 \$31802 \$33645 NWELL PWELL BULK MUX2_X1
X$74510 \$33131 \$31810 \$33621 \$33625 NWELL PWELL BULK MUX2_X1
X$74512 \$42959 \$31810 \$42977 \$42606 NWELL PWELL BULK MUX2_X1
X$74515 \$31810 \$51359 \$51447 NWELL PWELL BULK NAND2_X1
X$74517 \$31810 \$51171 \$51447 \$51659 NWELL PWELL BULK OAI21_X1
X$74520 \$31810 \$50217 \$51142 \$50608 NWELL PWELL BULK OAI21_X1
X$74522 \$31810 \$50609 \$51142 NWELL PWELL BULK NAND2_X1
X$74525 \$31810 \$54254 \$55626 \$55874 NWELL PWELL BULK OAI21_X1
X$74527 \$31810 \$54811 \$55626 NWELL PWELL BULK NAND2_X1
X$74529 \$31810 \$49541 \$50440 \$50598 NWELL PWELL BULK OAI21_X1
X$74533 \$31810 \$50599 \$50440 NWELL PWELL BULK NAND2_X1
X$74536 \$31810 \$61227 \$62673 \$62678 NWELL PWELL BULK OAI21_X1
X$74538 \$31810 \$61888 \$62673 NWELL PWELL BULK NAND2_X1
X$74540 \$31810 \$59482 \$59481 \$60162 NWELL PWELL BULK OAI21_X1
X$74543 \$31810 \$59674 \$59481 NWELL PWELL BULK NAND2_X1
X$74546 \$31810 \$55297 \$54868 \$55306 NWELL PWELL BULK OAI21_X1
X$74548 \$31810 \$55527 \$54868 NWELL PWELL BULK NAND2_X1
X$74550 \$31810 \$58514 \$58124 \$57754 NWELL PWELL BULK OAI21_X1
X$74552 \$31810 \$58127 \$58124 NWELL PWELL BULK NAND2_X1
X$74554 \$31810 \$56709 \$57509 \$57751 NWELL PWELL BULK OAI21_X1
X$74556 \$31810 \$57350 \$57509 NWELL PWELL BULK NAND2_X1
X$74558 \$31810 \$58513 \$58954 NWELL PWELL BULK NAND2_X1
X$74560 \$31810 \$58952 \$58954 \$58953 NWELL PWELL BULK OAI21_X1
X$74562 \$31810 \$51842 \$51368 NWELL PWELL BULK NAND2_X1
X$74565 \$31810 \$51666 \$51368 \$51667 NWELL PWELL BULK OAI21_X1
X$74567 \$31810 \$47942 \$47623 \$47984 NWELL PWELL BULK OAI21_X1
X$74570 \$31810 \$47608 \$47623 NWELL PWELL BULK NAND2_X1
X$74572 \$31810 \$44127 \$45534 \$45538 NWELL PWELL BULK OAI21_X1
X$74576 \$31810 \$44950 \$45534 NWELL PWELL BULK NAND2_X1
X$74578 \$31810 \$52597 \$53290 \$53796 NWELL PWELL BULK OAI21_X1
X$74581 \$31810 \$53797 \$53290 NWELL PWELL BULK NAND2_X1
X$74584 \$31810 \$49558 \$50239 NWELL PWELL BULK NAND2_X1
X$74587 \$31810 \$49911 \$50239 \$49913 NWELL PWELL BULK OAI21_X1
X$74590 \$31810 \$50644 \$50946 NWELL PWELL BULK NAND2_X1
X$74592 \$31810 \$52185 \$53336 NWELL PWELL BULK NAND2_X1
X$74594 \$31810 \$50941 \$50946 \$50972 NWELL PWELL BULK OAI21_X1
X$74596 \$31810 \$52607 \$53336 \$52984 NWELL PWELL BULK OAI21_X1
X$74598 \$31810 \$58573 \$58981 NWELL PWELL BULK NAND2_X1
X$74601 \$31810 \$57380 \$58981 \$58581 NWELL PWELL BULK OAI21_X1
X$74603 \$31810 \$55885 \$56726 \$57361 NWELL PWELL BULK OAI21_X1
X$74606 \$31810 \$56896 \$56726 NWELL PWELL BULK NAND2_X1
X$74609 \$31810 \$63672 \$63677 NWELL PWELL BULK NAND2_X1
X$74611 \$31810 \$63487 \$62860 NWELL PWELL BULK NAND2_X1
X$74613 \$31810 \$62857 \$62860 \$62859 NWELL PWELL BULK OAI21_X1
X$74615 \$31810 \$61237 \$63677 \$63679 NWELL PWELL BULK OAI21_X1
X$74617 \$31810 \$61891 \$63479 \$63478 NWELL PWELL BULK OAI21_X1
X$74620 \$31810 \$63710 \$63479 NWELL PWELL BULK NAND2_X1
X$74623 \$31810 \$54142 \$54145 \$54634 NWELL PWELL BULK OAI21_X1
X$74625 \$31810 \$54147 \$54145 NWELL PWELL BULK NAND2_X1
X$74628 \$31810 \$54135 \$54652 \$53798 NWELL PWELL BULK OAI21_X1
X$74630 \$31810 \$53800 \$54652 NWELL PWELL BULK NAND2_X1
X$74632 \$31810 \$62475 \$63612 \$63178 NWELL PWELL BULK OAI21_X1
X$74634 \$31810 \$62872 \$63612 NWELL PWELL BULK NAND2_X1
X$74637 \$31810 \$62292 \$62927 \$63593 NWELL PWELL BULK OAI21_X1
X$74640 \$31810 \$62920 \$62927 NWELL PWELL BULK NAND2_X1
X$74643 \$31810 \$59499 \$59532 \$59529 NWELL PWELL BULK OAI21_X1
X$74646 \$31810 \$60065 \$59532 NWELL PWELL BULK NAND2_X1
X$74648 \$31810 \$60774 \$62352 NWELL PWELL BULK NAND2_X1
X$74651 \$31810 \$61351 \$62352 \$61263 NWELL PWELL BULK OAI21_X1
X$74653 \$31810 \$33153 \$33154 \$33170 NWELL PWELL BULK OAI21_X1
X$74655 \$31810 \$39877 \$39546 NWELL PWELL BULK NAND2_X1
X$74658 \$31810 \$39549 \$39546 \$39547 NWELL PWELL BULK OAI21_X1
X$74660 \$31810 \$43333 \$43109 \$43338 NWELL PWELL BULK OAI21_X1
X$74662 \$31810 \$43340 \$43109 NWELL PWELL BULK NAND2_X1
X$74664 \$31810 \$37247 \$38882 \$39509 NWELL PWELL BULK OAI21_X1
X$74666 \$31810 \$39506 \$38882 NWELL PWELL BULK NAND2_X1
X$74669 \$31810 \$41241 \$41262 NWELL PWELL BULK NAND2_X1
X$74671 \$31810 \$40252 \$41262 \$41263 NWELL PWELL BULK OAI21_X1
X$74673 \$31810 \$34838 \$36635 \$36637 NWELL PWELL BULK OAI21_X1
X$74675 \$31810 \$36639 \$36635 NWELL PWELL BULK NAND2_X1
X$74679 \$31810 \$33513 \$33575 \$33581 NWELL PWELL BULK OAI21_X1
X$74682 \$31810 \$33573 \$33575 NWELL PWELL BULK NAND2_X1
X$74684 \$31810 \$33940 \$34948 NWELL PWELL BULK NAND2_X1
X$74686 \$31810 \$32583 \$32184 \$32183 NWELL PWELL BULK OAI21_X1
X$74689 \$31810 \$32586 \$32184 NWELL PWELL BULK NAND2_X1
X$74693 \$31810 \$32608 \$32202 NWELL PWELL BULK NAND2_X1
X$74696 \$31810 \$32610 \$33154 NWELL PWELL BULK NAND2_X1
X$74698 \$31810 \$32200 \$32202 \$32255 NWELL PWELL BULK OAI21_X1
X$74700 \$31810 \$35306 \$35429 NWELL PWELL BULK NAND2_X1
X$74702 \$31810 \$33506 \$34948 \$33937 NWELL PWELL BULK OAI21_X1
X$74704 \$31810 \$35780 \$35429 \$35781 NWELL PWELL BULK OAI21_X1
X$74809 \$37876 \$31810 \$37878 \$37904 NWELL PWELL BULK MUX2_X1
X$74811 \$31811 \$32589 NWELL PWELL BULK BUF_X16
X$74816 M1_AXI_WDATA[25] \$31813 NWELL PWELL BULK BUF_X1
X$74825 \$31813 \$32176 \$32734 \$32732 NWELL PWELL BULK MUX2_X1
X$74830 \$35869 \$35763 \$31815 \$36319 NWELL PWELL BULK MUX2_X2
X$74832 \$36143 \$36144 \$31815 \$37306 NWELL PWELL BULK MUX2_X2
X$74834 \$37279 \$37273 \$31815 \$37274 NWELL PWELL BULK MUX2_X2
X$74836 \$36851 \$36156 \$31815 \$36157 NWELL PWELL BULK MUX2_X2
X$74838 \$37859 \$38113 \$31815 \$38104 NWELL PWELL BULK MUX2_X2
X$74841 \$35295 \$35296 \$31815 \$35297 NWELL PWELL BULK MUX2_X2
X$74843 \$32282 \$32276 \$31815 \$31819 NWELL PWELL BULK MUX2_X2
X$74846 \$32694 \$32194 \$31815 \$32687 NWELL PWELL BULK MUX2_X2
X$74848 \$31833 \$31834 \$31815 \$32258 NWELL PWELL BULK MUX2_X2
X$74851 \$32187 \$32730 \$31815 \$32729 NWELL PWELL BULK MUX2_X2
X$74853 \$33499 \$31815 NWELL PWELL BULK BUF_X16
X$74858 \$34508 \$34962 \$31815 \$35442 NWELL PWELL BULK MUX2_X2
X$74860 \$38918 \$37950 \$31815 \$38917 NWELL PWELL BULK MUX2_X2
X$74862 \$38485 \$31815 \$38955 \$38879 NWELL PWELL BULK MUX2_X1
X$74865 \$37206 \$37198 \$31815 \$36689 NWELL PWELL BULK MUX2_X2
X$74867 \$34906 \$34521 \$31815 \$34903 NWELL PWELL BULK MUX2_X2
X$74869 \$36629 \$37982 \$31815 \$37546 NWELL PWELL BULK MUX2_X2
X$74871 \$40236 \$40238 \$31815 \$41220 NWELL PWELL BULK MUX2_X2
X$74873 \$41644 \$41979 \$31815 \$41576 NWELL PWELL BULK MUX2_X2
X$74875 \$43019 \$42957 \$31815 \$43012 NWELL PWELL BULK MUX2_X2
X$74877 \$41270 \$42005 \$31815 \$41646 NWELL PWELL BULK MUX2_X2
X$74879 \$40320 \$39431 \$31815 \$40318 NWELL PWELL BULK MUX2_X2
X$74881 \$34890 \$31815 \$34834 \$35793 NWELL PWELL BULK MUX2_X1
X$74883 \$34922 \$34517 \$31815 \$35312 NWELL PWELL BULK MUX2_X2
X$74885 \$40353 \$39890 \$31815 \$39941 NWELL PWELL BULK MUX2_X2
X$74887 \$40245 \$40776 \$31815 \$40883 NWELL PWELL BULK MUX2_X2
X$74889 \$37870 \$31815 \$38007 \$38488 NWELL PWELL BULK MUX2_X1
X$74892 \$36760 \$36171 \$31815 \$36746 NWELL PWELL BULK MUX2_X2
X$74931 \$44637 \$42756 \$44636 \$43440 \$43349 \$31819 \$43593 NWELL PWELL
+ BULK OAI222_X2
X$74934 \$31819 \$43769 \$44638 NWELL PWELL BULK NOR2_X1
X$74937 \$31819 \$35401 \$35786 NWELL PWELL BULK NOR2_X1
X$74946 \$40228 \$31820 \$40757 \$41375 NWELL PWELL BULK MUX2_X1
X$74949 \$33929 \$31820 \$33934 \$34128 NWELL PWELL BULK MUX2_X1
X$74952 \$36611 \$31820 \$36864 \$36615 NWELL PWELL BULK MUX2_X1
X$74955 \$37147 \$31820 \$37299 \$37300 NWELL PWELL BULK MUX2_X1
X$74959 \$36720 \$31820 \$38932 \$38524 NWELL PWELL BULK MUX2_X1
X$74962 \$34523 \$31820 \$34526 \$34836 NWELL PWELL BULK MUX2_X1
X$74964 \$33146 \$31820 \$33560 \$33519 NWELL PWELL BULK MUX2_X1
X$74967 \$40235 \$31820 \$40392 \$39956 NWELL PWELL BULK MUX2_X1
X$74969 \$40978 \$31820 \$41346 \$41689 NWELL PWELL BULK MUX2_X1
X$74971 \$41930 \$31820 \$41673 \$41674 NWELL PWELL BULK MUX2_X1
X$74974 \$42601 \$31820 \$42254 \$42641 NWELL PWELL BULK MUX2_X1
X$74976 \$40784 \$31820 \$42256 \$42255 NWELL PWELL BULK MUX2_X1
X$74978 \$39896 \$31820 \$39920 \$39921 NWELL PWELL BULK MUX2_X1
X$74981 \$35788 \$31820 \$36172 \$36240 NWELL PWELL BULK MUX2_X1
X$74984 \$42586 \$31820 \$43345 \$43346 NWELL PWELL BULK MUX2_X1
X$74987 \$42592 \$31820 \$41927 \$42351 NWELL PWELL BULK MUX2_X1
X$74989 \$42232 \$31820 \$43438 \$42745 NWELL PWELL BULK MUX2_X1
X$74991 \$41562 \$31820 \$42722 \$42585 NWELL PWELL BULK MUX2_X1
X$74994 \$38859 \$31820 \$38994 \$38863 NWELL PWELL BULK MUX2_X1
X$74996 \$38866 \$31820 \$39556 \$39354 NWELL PWELL BULK MUX2_X1
X$74998 \$37856 \$31820 \$38482 \$38971 NWELL PWELL BULK MUX2_X1
X$75001 \$37862 \$31820 \$39361 \$39522 NWELL PWELL BULK MUX2_X1
X$75004 \$39365 \$31820 \$41571 \$41292 NWELL PWELL BULK MUX2_X1
X$75006 \$37167 \$31820 \$37993 \$37576 NWELL PWELL BULK MUX2_X1
X$75008 \$39371 \$31820 \$39935 \$39891 NWELL PWELL BULK MUX2_X1
X$75011 \$40862 \$31820 \$41935 \$42310 NWELL PWELL BULK MUX2_X1
X$75014 \$33517 \$31820 \$33949 \$34081 NWELL PWELL BULK MUX2_X1
X$75017 \$37548 \$31820 \$37929 \$37935 NWELL PWELL BULK MUX2_X1
X$75019 \$36634 \$31820 \$36692 \$36218 NWELL PWELL BULK MUX2_X1
X$75021 \$32178 \$31820 \$32783 \$32785 NWELL PWELL BULK MUX2_X1
X$75025 \$34505 \$31820 \$35497 \$35505 NWELL PWELL BULK MUX2_X1
X$75032 \$37536 \$31820 \$37852 \$37590 NWELL PWELL BULK MUX2_X1
X$75034 \$34800 \$31820 \$36322 \$36328 NWELL PWELL BULK MUX2_X1
X$75037 \$33501 \$31820 \$34507 \$34583 NWELL PWELL BULK MUX2_X1
X$75039 \$35462 \$31820 \$34973 \$35300 NWELL PWELL BULK MUX2_X1
X$75115 \$31835 M1_AXI_WREADY NWELL PWELL BULK BUF_X1
X$75123 M1_AXI_WVALID \$31837 NWELL PWELL BULK BUF_X1
X$75128 M1_AXI_WDATA[2] \$32178 NWELL PWELL BULK BUF_X1
X$75145 \$38211 \$38569 \$37602 \$31858 NWELL PWELL BULK NAND3_X4
X$75161 \$43647 \$31861 \$42959 \$43617 NWELL PWELL BULK MUX2_X1
X$75163 \$31861 \$51358 \$51172 NWELL PWELL BULK NOR2_X1
X$75165 \$31861 \$51366 \$51854 NWELL PWELL BULK NOR2_X1
X$75168 \$51854 \$51666 \$31861 \$51858 NWELL PWELL BULK AOI21_X1
X$75171 \$51172 \$51171 \$31861 \$51356 NWELL PWELL BULK AOI21_X1
X$75173 \$31861 \$50605 \$50603 NWELL PWELL BULK NOR2_X1
X$75176 \$50603 \$50217 \$31861 \$51157 NWELL PWELL BULK AOI21_X1
X$75179 \$55250 \$54254 \$31861 \$55122 NWELL PWELL BULK AOI21_X1
X$75181 \$31861 \$55124 \$55250 NWELL PWELL BULK NOR2_X1
X$75183 \$50434 \$49541 \$31861 \$49683 NWELL PWELL BULK AOI21_X1
X$75185 \$31861 \$50213 \$50434 NWELL PWELL BULK NOR2_X1
X$75187 \$61563 \$61227 \$31861 \$61232 NWELL PWELL BULK AOI21_X1
X$75189 \$31861 \$61890 \$61563 NWELL PWELL BULK NOR2_X1
X$75191 \$60747 \$59482 \$31861 \$60431 NWELL PWELL BULK AOI21_X1
X$75193 \$31861 \$62275 \$62639 NWELL PWELL BULK NOR2_X1
X$75196 \$31861 \$60435 \$60747 NWELL PWELL BULK NOR2_X1
X$75198 \$56140 \$55297 \$31861 \$55862 NWELL PWELL BULK AOI21_X1
X$75201 \$31861 \$55526 \$56140 NWELL PWELL BULK NOR2_X1
X$75204 \$57753 \$58514 \$31861 \$57856 NWELL PWELL BULK AOI21_X1
X$75206 \$31861 \$57352 \$57753 NWELL PWELL BULK NOR2_X1
X$75208 \$56713 \$56709 \$31861 \$57037 NWELL PWELL BULK AOI21_X1
X$75211 \$31861 \$57027 \$56713 NWELL PWELL BULK NOR2_X1
X$75214 \$58951 \$58952 \$31861 \$58122 NWELL PWELL BULK AOI21_X1
X$75218 \$31861 \$59161 \$58951 NWELL PWELL BULK NOR2_X1
X$75221 \$31861 \$47606 \$47943 NWELL PWELL BULK NOR2_X1
X$75223 \$47943 \$47942 \$31861 \$47639 NWELL PWELL BULK AOI21_X1
X$75225 \$45300 \$44127 \$31861 \$45299 NWELL PWELL BULK AOI21_X1
X$75228 \$31861 \$45302 \$45300 NWELL PWELL BULK NOR2_X1
X$75231 \$49943 \$49911 \$31861 \$49910 NWELL PWELL BULK AOI21_X1
X$75233 \$31861 \$50627 \$50984 NWELL PWELL BULK NOR2_X1
X$75235 \$31861 \$49207 \$49943 NWELL PWELL BULK NOR2_X1
X$75237 \$53297 \$52607 \$31861 \$53339 NWELL PWELL BULK AOI21_X1
X$75240 \$31861 \$52968 \$53297 NWELL PWELL BULK NOR2_X1
X$75243 \$50984 \$50941 \$31861 \$50989 NWELL PWELL BULK AOI21_X1
X$75245 \$54587 \$52597 \$31861 \$54706 NWELL PWELL BULK AOI21_X1
X$75247 \$31861 \$53292 \$54587 NWELL PWELL BULK NOR2_X1
X$75249 \$57771 \$57380 \$31861 \$57768 NWELL PWELL BULK AOI21_X1
X$75252 \$31861 \$57773 \$57771 NWELL PWELL BULK NOR2_X1
X$75255 \$31861 \$58980 \$59505 NWELL PWELL BULK NOR2_X1
X$75257 \$56419 \$55885 \$31861 \$56472 NWELL PWELL BULK AOI21_X1
X$75259 \$31861 \$56727 \$56419 NWELL PWELL BULK NOR2_X1
X$75261 \$62954 \$62857 \$31861 \$63166 NWELL PWELL BULK AOI21_X1
X$75263 \$31861 \$63235 \$62954 NWELL PWELL BULK NOR2_X1
X$75265 \$31861 \$63165 \$63685 NWELL PWELL BULK NOR2_X1
X$75267 \$63685 \$61237 \$31861 \$63242 NWELL PWELL BULK AOI21_X1
X$75270 \$62639 \$61891 \$31861 \$62273 NWELL PWELL BULK AOI21_X1
X$75273 \$54188 \$54142 \$31861 \$54140 NWELL PWELL BULK AOI21_X1
X$75276 \$31861 \$54143 \$54188 NWELL PWELL BULK NOR2_X1
X$75278 \$54592 \$54135 \$31861 \$54209 NWELL PWELL BULK AOI21_X1
X$75280 \$31861 \$54138 \$54592 NWELL PWELL BULK NOR2_X1
X$75282 \$63494 \$62475 \$31861 \$63491 NWELL PWELL BULK AOI21_X1
X$75284 \$31861 \$63180 \$63494 NWELL PWELL BULK NOR2_X1
X$75286 \$63220 \$62292 \$31861 \$63223 NWELL PWELL BULK AOI21_X1
X$75288 \$31861 \$63183 \$63220 NWELL PWELL BULK NOR2_X1
X$75290 \$59505 \$59499 \$31861 \$60098 NWELL PWELL BULK AOI21_X1
X$75292 \$31861 \$60771 \$60770 NWELL PWELL BULK NOR2_X1
X$75295 \$60770 \$61351 \$31861 \$61320 NWELL PWELL BULK AOI21_X1
X$75298 \$31861 \$40234 \$40438 NWELL PWELL BULK NOR2_X1
X$75301 \$40438 \$39549 \$31861 \$39874 NWELL PWELL BULK AOI21_X1
X$75304 \$43579 \$43333 \$31861 \$44124 NWELL PWELL BULK AOI21_X1
X$75308 \$31861 \$43805 \$43579 NWELL PWELL BULK NOR2_X1
X$75311 \$31861 \$38949 \$38953 NWELL PWELL BULK NOR2_X1
X$75314 \$38953 \$37247 \$31861 \$38881 NWELL PWELL BULK AOI21_X1
X$75317 \$40293 \$40252 \$31861 \$40787 NWELL PWELL BULK AOI21_X1
X$75320 \$31861 \$40816 \$40293 NWELL PWELL BULK NOR2_X1
X$75323 \$31861 \$36185 \$36181 NWELL PWELL BULK NOR2_X1
X$75325 \$37877 \$31861 \$37876 \$37922 NWELL PWELL BULK MUX2_X1
X$75327 \$36181 \$34838 \$31861 \$36212 NWELL PWELL BULK AOI21_X1
X$75329 \$33570 \$33513 \$31861 \$33142 NWELL PWELL BULK AOI21_X1
X$75331 \$31861 \$33143 \$33570 NWELL PWELL BULK NOR2_X1
X$75333 \$31861 \$34938 \$34953 NWELL PWELL BULK NOR2_X1
X$75339 \$32204 \$33153 \$31861 \$32609 NWELL PWELL BULK AOI21_X1
X$75342 \$31861 \$32629 \$32204 NWELL PWELL BULK NOR2_X1
X$75345 \$32667 \$32200 \$31861 \$32601 NWELL PWELL BULK AOI21_X1
X$75347 \$31861 \$32605 \$32667 NWELL PWELL BULK NOR2_X1
X$75349 \$33498 \$31861 \$33131 \$33628 NWELL PWELL BULK MUX2_X1
X$75352 \$31861 \$35783 \$35843 NWELL PWELL BULK NOR2_X1
X$75355 \$31861 \$32588 \$32759 NWELL PWELL BULK NOR2_X1
X$75357 \$34953 \$33506 \$31861 \$35409 NWELL PWELL BULK AOI21_X1
X$75359 \$35843 \$35780 \$31861 \$35850 NWELL PWELL BULK AOI21_X1
X$75363 \$32759 \$32583 \$31861 \$32584 NWELL PWELL BULK AOI21_X1
X$75486 \$31910 \$40686 NWELL PWELL BULK INV_X1
X$75489 \$31924 \$36524 \$37072 \$31910 \$39238 NWELL PWELL BULK AOI22_X2
X$75525 S0_AXI_WREADY \$31922 NWELL PWELL BULK BUF_X1
X$75540 \$31924 \$33411 \$34721 \$34706 \$35531 NWELL PWELL BULK NOR4_X4
X$75542 \$31924 \$33411 \$34721 \$34706 \$36537 NWELL PWELL BULK OR4_X1
X$75544 \$34934 \$36513 \$31924 \$36514 \$38760 NWELL PWELL BULK AOI22_X1
X$75546 \$34934 \$33845 \$31924 \$33829 \$34624 NWELL PWELL BULK AOI22_X1
X$75564 \$36050 \$36513 \$31949 \$36514 \$37308 NWELL PWELL BULK AOI22_X1
X$75566 \$36050 \$33845 \$31949 \$33829 \$35900 NWELL PWELL BULK AOI22_X1
X$75583 \$31963 \$32571 \$32574 NWELL PWELL BULK XNOR2_X2
X$75607 \$32778 \$31992 \$32339 \$32792 NWELL PWELL BULK AOI21_X1
X$75622 \$31998 \$32112 \$32115 \$32116 \$32366 NWELL PWELL BULK OAI22_X1
X$75624 \$32106 \$32102 \$31998 NWELL PWELL BULK NAND2_X1
X$75632 \$32377 \$32116 \$32498 \$32003 NWELL PWELL BULK OAI21_X1
X$75650 \$35104 \$32025 \$34793 NWELL PWELL BULK XOR2_X1
X$75652 \$34490 \$32553 \$32025 \$34281 NWELL PWELL BULK AND3_X1
X$75684 \$32053 \$39850 \$41527 NWELL PWELL BULK NAND2_X1
X$75686 \$39850 \$32053 \$41182 \$40742 NWELL PWELL BULK AOI21_X1
X$75688 \$32053 \$40211 \$39850 \$32157 NWELL PWELL BULK AND3_X4
X$75690 \$41892 \$32053 \$42150 NWELL PWELL BULK OR2_X1
X$75692 \$32053 \$41183 \$41890 NWELL PWELL BULK NAND2_X1
X$75695 \$41117 \$32053 \$41113 NWELL PWELL BULK AND2_X1
X$75716 \$32056 \$32137 \$32138 \$32438 NWELL PWELL BULK HA_X1
X$75749 M0_AXI_AWID[2] \$32086 NWELL PWELL BULK CLKBUF_X2
X$75777 \$32095 \$32477 \$32479 \$32478 \$33321 NWELL PWELL BULK OR4_X1
X$75788 \$32097 \$35710 \$34735 \$38388 \$38391 NWELL PWELL BULK AOI211_X2
X$75790 \$36540 \$35038 \$36065 \$36392 \$32097 NWELL PWELL BULK NAND4_X4
X$75793 \$33872 \$35034 \$35553 \$34441 \$32097 \$34999 \$33712 NWELL PWELL
+ BULK OAI33_X1
X$75798 \$32097 \$35710 \$39099 NWELL PWELL BULK NOR2_X2
X$75801 \$35710 \$32097 \$38783 \$35725 \$38668 NWELL PWELL BULK OAI22_X2
X$75804 \$32097 \$35710 \$38122 \$39120 \$39109 NWELL PWELL BULK NOR4_X1
X$75819 \$32478 \$32479 \$32477 \$32102 NWELL PWELL BULK NOR3_X2
X$75833 \$33706 \$33712 \$32110 \$33061 \$32111 NWELL PWELL BULK OAI22_X4
X$75835 \$32377 \$32110 \$33429 NWELL PWELL BULK NOR2_X4
X$75840 \$35019 \$34729 \$32110 \$34731 \$34660 NWELL PWELL BULK NAND4_X2
X$75844 \$32495 \$32110 NWELL PWELL BULK INV_X4
X$75847 \$32110 \$32111 \$33059 NWELL PWELL BULK NOR2_X1
X$75865 \$32113 \$32115 NWELL PWELL BULK INV_X1
X$75871 \$32118 \$32116 \$32797 \$32356 NWELL PWELL BULK OAI21_X1
X$75899 \$33078 \$33450 \$32126 \$34311 NWELL PWELL BULK AOI21_X1
X$75903 \$33443 \$32126 \$33870 \$35261 NWELL PWELL BULK AOI21_X2
X$75906 \$32126 \$33879 \$34295 \$34468 NWELL PWELL BULK OR3_X1
X$75915 \$32127 \$32876 NWELL PWELL BULK INV_X1
X$75918 \$32525 \$32127 \$32858 NWELL PWELL BULK NOR2_X1
X$75923 \$32526 \$32129 \$32128 NWELL PWELL BULK NAND2_X1
X$75926 \$32129 \$33087 \$32889 \$32892 NWELL PWELL BULK HA_X1
X$75929 \$32528 \$32129 \$33085 NWELL PWELL BULK NAND2_X1
X$75936 \$32130 \$32893 \$32895 NWELL PWELL BULK XOR2_X1
X$75939 \$32528 \$32130 \$33795 NWELL PWELL BULK NAND2_X1
X$75968 \$50887 \$32157 \$32149 \$51215 NWELL PWELL BULK AOI21_X1
X$75982 \$32157 \$41186 \$42827 NWELL PWELL BULK NAND2_X1
X$75986 \$32157 \$34790 \$35545 NWELL PWELL BULK NAND2_X1
X$75988 \$32157 \$35746 NWELL PWELL BULK INV_X2
X$75990 \$32157 \$34485 \$35276 NWELL PWELL BULK NAND2_X1
X$75993 \$35284 \$32157 \$35750 NWELL PWELL BULK NAND2_X1
X$75996 \$32157 \$34795 \$35283 NWELL PWELL BULK NAND2_X1
X$75998 \$33269 \$32157 \$33014 \$33011 NWELL PWELL BULK OAI21_X1
X$76000 \$33683 \$32157 \$33265 \$33484 NWELL PWELL BULK OAI21_X1
X$76002 \$32157 \$35754 \$35755 NWELL PWELL BULK NAND2_X1
X$76005 \$34793 \$32157 \$35535 NWELL PWELL BULK NAND2_X1
X$76008 \$35080 \$32157 \$37017 NWELL PWELL BULK NAND2_X1
X$76011 \$34606 \$32157 \$32996 \$34263 NWELL PWELL BULK OAI21_X1
X$76013 \$32157 \$52551 \$50887 NWELL PWELL BULK NOR2_X1
X$76018 \$32995 \$32157 \$32158 \$33264 NWELL PWELL BULK OAI21_X1
X$76053 \$32560 \$32363 \$32941 \$32971 \$32159 NWELL PWELL BULK FA_X1
X$76055 \$32160 \$32346 \$32352 NWELL PWELL BULK XNOR2_X1
X$76072 \$33494 \$32174 \$33499 \$34216 NWELL PWELL BULK MUX2_X2
X$76076 \$33501 \$32176 \$35860 \$35768 NWELL PWELL BULK MUX2_X1
X$76079 \$38866 \$32176 \$39566 \$38991 NWELL PWELL BULK MUX2_X1
X$76081 \$40978 \$32176 \$40981 \$40982 NWELL PWELL BULK MUX2_X1
X$76084 \$36611 \$32176 \$37285 \$37293 NWELL PWELL BULK MUX2_X1
X$76086 \$37536 \$32176 \$37150 \$37296 NWELL PWELL BULK MUX2_X1
X$76088 \$37856 \$32176 \$37539 \$37587 NWELL PWELL BULK MUX2_X1
X$76090 \$34505 \$32176 \$34217 \$34219 NWELL PWELL BULK MUX2_X1
X$76095 \$38859 \$32176 \$39588 \$39019 NWELL PWELL BULK MUX2_X1
X$76098 \$42586 \$32176 \$41926 \$42047 NWELL PWELL BULK MUX2_X1
X$76101 \$40235 \$32176 \$40762 \$40412 NWELL PWELL BULK MUX2_X1
X$76103 \$40862 \$32176 \$40338 \$40342 NWELL PWELL BULK MUX2_X1
X$76106 \$42601 \$32176 \$43395 \$43396 NWELL PWELL BULK MUX2_X1
X$76108 \$39365 \$32176 \$39367 \$40363 NWELL PWELL BULK MUX2_X1
X$76111 \$39371 \$32176 \$40247 \$40355 NWELL PWELL BULK MUX2_X1
X$76114 \$42592 \$32176 \$43081 \$43087 NWELL PWELL BULK MUX2_X1
X$76116 \$34523 \$32176 \$35364 \$35314 NWELL PWELL BULK MUX2_X1
X$76119 \$36634 \$32176 \$36705 \$36225 NWELL PWELL BULK MUX2_X1
X$76121 \$37548 \$32176 \$37968 \$37966 NWELL PWELL BULK MUX2_X1
X$76123 \$42232 \$32176 \$42068 \$42071 NWELL PWELL BULK MUX2_X1
X$76125 \$40228 \$32176 \$40505 \$40501 NWELL PWELL BULK MUX2_X1
X$76127 \$41562 \$32176 \$42376 \$42375 NWELL PWELL BULK MUX2_X1
X$76129 \$39896 \$32176 \$39447 \$39452 NWELL PWELL BULK MUX2_X1
X$76132 \$41930 \$32176 \$43064 \$43068 NWELL PWELL BULK MUX2_X1
X$76134 \$40784 \$32176 \$40850 \$40856 NWELL PWELL BULK MUX2_X1
X$76136 \$33517 \$32176 \$35311 \$35386 NWELL PWELL BULK MUX2_X1
X$76139 \$33146 \$32176 \$35377 \$35379 NWELL PWELL BULK MUX2_X1
X$76143 \$35788 \$32176 \$36781 \$36621 NWELL PWELL BULK MUX2_X1
X$76145 \$36720 \$32176 \$36176 \$36229 NWELL PWELL BULK MUX2_X1
X$76147 \$37167 \$32176 \$38031 \$38038 NWELL PWELL BULK MUX2_X1
X$76151 \$32178 \$32176 \$32177 \$32306 NWELL PWELL BULK MUX2_X1
X$76156 \$37862 \$32176 \$37159 \$37261 NWELL PWELL BULK MUX2_X1
X$76158 \$34800 \$32176 \$35877 \$35519 NWELL PWELL BULK MUX2_X1
X$76160 \$37147 \$32176 \$37148 \$37318 NWELL PWELL BULK MUX2_X1
X$76162 \$35462 \$32176 \$34974 \$34976 NWELL PWELL BULK MUX2_X1
X$76164 \$33929 \$32176 \$34968 \$34966 NWELL PWELL BULK MUX2_X1
X$76221 \$32802 \$32575 \$32178 \$32576 NWELL PWELL BULK MUX2_X1
X$76230 \$33918 \$32181 \$33131 \$34209 NWELL PWELL BULK MUX2_X1
X$76232 \$47912 \$32181 NWELL PWELL BULK BUF_X8
X$76235 \$44469 \$44127 \$32181 \$44129 NWELL PWELL BULK AOI21_X1
X$76237 \$32181 \$44304 \$44469 NWELL PWELL BULK NOR2_X1
X$76240 \$43853 \$43333 \$32181 \$43334 NWELL PWELL BULK AOI21_X1
X$76242 \$32181 \$43843 \$43853 NWELL PWELL BULK NOR2_X1
X$76244 \$32182 \$32583 \$32181 \$32580 NWELL PWELL BULK AOI21_X1
X$76248 \$32181 \$32582 \$32182 NWELL PWELL BULK NOR2_X1
X$76251 \$32181 \$38871 \$39356 NWELL PWELL BULK NOR2_X1
X$76254 \$39356 \$39549 \$32181 \$38986 NWELL PWELL BULK AOI21_X1
X$76291 \$32198 \$43769 \$44327 NWELL PWELL BULK NOR2_X1
X$76294 \$43609 \$42756 \$43610 \$43440 \$43349 \$32198 \$41234 NWELL PWELL
+ BULK OAI222_X2
X$76297 \$32198 \$35401 \$42952 NWELL PWELL BULK NOR2_X1
X$76309 \$43399 \$42952 \$32200 NWELL PWELL BULK NOR2_X2
X$76327 \$36166 \$32206 \$36249 \$35792 NWELL PWELL BULK MUX2_X1
X$76330 \$47974 \$32206 \$47607 \$45756 NWELL PWELL BULK MUX2_X1
X$76332 \$57382 \$32206 \$57775 \$54153 NWELL PWELL BULK MUX2_X1
X$76335 \$37867 \$32206 \$38883 \$38884 NWELL PWELL BULK MUX2_X1
X$76339 \$53802 \$32206 \$54195 \$48708 NWELL PWELL BULK MUX2_X1
X$76342 \$60795 \$32206 \$60775 \$57774 NWELL PWELL BULK MUX2_X1
X$76344 \$62291 \$32206 \$62874 \$57431 NWELL PWELL BULK MUX2_X1
X$76347 \$61374 \$32206 \$61376 \$60066 NWELL PWELL BULK MUX2_X1
X$76349 \$33522 \$32206 \$33556 \$33523 NWELL PWELL BULK MUX2_X1
X$76352 \$49574 \$32206 \$49570 \$48305 NWELL PWELL BULK MUX2_X1
X$76354 \$51690 \$32206 \$50947 \$50241 NWELL PWELL BULK MUX2_X1
X$76357 \$33511 \$32206 \$34569 \$33978 NWELL PWELL BULK MUX2_X1
X$76360 \$44026 \$32206 \$44028 \$44008 NWELL PWELL BULK MUX2_X1
X$76363 \$52625 \$32206 \$52608 \$47946 NWELL PWELL BULK MUX2_X1
X$76365 \$59530 \$32206 \$58982 \$56429 NWELL PWELL BULK MUX2_X1
X$76368 \$54150 \$32206 \$54174 \$52186 NWELL PWELL BULK MUX2_X1
X$76370 \$33997 \$32206 \$32621 \$33958 NWELL PWELL BULK MUX2_X1
X$76373 \$40254 \$32206 \$38492 \$41243 NWELL PWELL BULK MUX2_X1
X$76375 \$41582 \$32206 \$40789 \$41591 NWELL PWELL BULK MUX2_X1
X$76377 \$36203 \$32206 \$36187 \$36199 NWELL PWELL BULK MUX2_X1
X$76379 \$34564 \$32206 \$33946 \$34828 NWELL PWELL BULK MUX2_X1
X$76381 \$33222 \$32206 NWELL PWELL BULK BUF_X16
X$76384 \$33602 \$32206 \$33136 \$33169 NWELL PWELL BULK MUX2_X1
X$76422 M0_AXI_WDATA[16] \$36188 NWELL PWELL BULK CLKBUF_X2
X$76427 \$58103 \$58102 \$32214 \$58745 NWELL PWELL BULK MUX2_X1
X$76429 \$32214 \$55498 \$58105 \$58479 NWELL PWELL BULK MUX2_X1
X$76431 \$32214 \$54550 \$57317 \$57601 NWELL PWELL BULK MUX2_X1
X$76433 \$32214 \$56680 \$57318 \$57320 NWELL PWELL BULK MUX2_X1
X$76455 \$50936 \$42756 \$50938 \$43440 \$43349 \$32258 \$52176 NWELL PWELL
+ BULK OAI222_X2
X$76457 \$32258 \$35401 \$50940 NWELL PWELL BULK NOR2_X1
X$76460 \$32258 \$43769 \$51755 NWELL PWELL BULK NOR2_X1
X$76589 \$32378 \$32816 \$32499 NWELL PWELL BULK NOR2_X1
X$76632 \$32528 \$32888 \$32431 NWELL PWELL BULK NAND2_X1
X$76696 \$37493 \$37801 \$32460 \$32500 \$37802 NWELL PWELL BULK OAI22_X1
X$76698 \$32500 \$32460 \$37492 \$37110 \$37490 \$37499 NWELL PWELL BULK
+ OAI221_X2
X$76712 \$33428 \$32460 \$33354 NWELL PWELL BULK NAND2_X1
X$76714 \$32460 \$33063 \$33352 NWELL PWELL BULK XNOR2_X1
X$76717 \$32460 \$34462 \$33428 \$34756 NWELL PWELL BULK AOI21_X1
X$76721 \$32460 \$34195 \$35253 NWELL PWELL BULK NOR2_X1
X$76724 \$32490 \$33427 \$32460 NWELL PWELL BULK OR2_X4
X$76779 \$33856 \$32461 NWELL PWELL BULK BUF_X32
X$76876 M0_AXI_AWADDR[24] \$32465 NWELL PWELL BULK BUF_X1
X$76890 \$32469 \$32470 \$33290 NWELL PWELL BULK NOR2_X1
X$76895 \$33428 \$32470 \$33856 NWELL PWELL BULK AND2_X4
X$76897 \$33829 \$33307 \$32470 \$34273 \$33845 \$34449 NWELL PWELL BULK
+ AOI221_X2
X$76900 \$32490 \$33427 \$32470 NWELL PWELL BULK NOR2_X4
X$76903 \$34419 \$32470 \$34722 NWELL PWELL BULK NOR2_X1
X$76905 \$35900 \$32470 \$35478 NWELL PWELL BULK NOR2_X1
X$76907 \$35486 \$32470 \$34718 NWELL PWELL BULK NOR2_X1
X$76909 \$35690 \$32470 \$35460 NWELL PWELL BULK NOR2_X1
X$76911 \$35218 \$32470 \$34638 NWELL PWELL BULK NOR2_X1
X$76914 \$35894 \$32470 \$35209 NWELL PWELL BULK NOR2_X1
X$76916 \$36774 \$32470 \$35213 NWELL PWELL BULK NOR2_X1
X$76920 \$34145 \$32470 \$33844 NWELL PWELL BULK NOR2_X1
X$76923 \$33418 \$32470 \$33296 NWELL PWELL BULK NOR2_X1
X$76926 \$33838 \$32470 \$33415 NWELL PWELL BULK NOR2_X1
X$76928 \$35677 \$32470 \$37068 NWELL PWELL BULK NOR2_X1
X$76930 \$33830 \$32470 \$34098 NWELL PWELL BULK NOR2_X1
X$76934 \$33828 \$32470 \$33614 NWELL PWELL BULK NOR2_X1
X$76937 \$34600 \$32470 \$33405 NWELL PWELL BULK NOR2_X1
X$76940 \$34624 \$32470 \$34618 NWELL PWELL BULK NOR2_X1
X$76943 \$34411 \$32470 \$33834 NWELL PWELL BULK NOR2_X1
X$76946 \$34920 \$32470 \$34404 NWELL PWELL BULK NOR2_X1
X$76948 \$35415 \$32470 \$34925 NWELL PWELL BULK NOR2_X1
X$76968 \$32748 \$32745 \$35701 \$35531 \$32477 NWELL PWELL BULK NAND4_X4
X$76971 \$36000 \$32477 \$36077 \$35722 \$35710 \$34179 \$36078 NWELL PWELL
+ BULK OAI33_X1
X$76975 \$32495 \$32477 \$32479 \$32478 \$33706 NWELL PWELL BULK OR4_X2
X$77008 \$33064 \$32479 \$33725 NWELL PWELL BULK NOR2_X1
X$77014 \$32479 \$36537 \$36538 \$37096 NWELL PWELL BULK NOR3_X2
X$77030 \$32483 \$33857 \$33057 \$33427 NWELL PWELL BULK AOI21_X2
X$77043 \$32495 \$34995 \$35236 \$35562 NWELL PWELL BULK AOI21_X2
X$77048 \$32495 \$33368 \$32505 NWELL PWELL BULK AND2_X1
X$77050 \$32495 \$33354 \$32500 \$32816 NWELL PWELL BULK AOI21_X1
X$77067 \$35930 \$32500 \$38426 NWELL PWELL BULK OR2_X1
X$77071 \$34452 \$33868 \$34455 \$32500 NWELL PWELL BULK OAI21_X4
X$77095 \$35076 \$34746 \$32511 \$35596 NWELL PWELL BULK AOI21_X1
X$77098 \$32511 \$33072 \$32836 NWELL PWELL BULK NAND2_X1
X$77100 \$32511 \$33764 \$32512 NWELL PWELL BULK NAND2_X1
X$77103 \$34747 \$35247 \$32511 NWELL PWELL BULK AND2_X1
X$77112 \$35624 \$35262 \$34773 \$32516 NWELL PWELL BULK DFF_X1
X$77115 \$I177080 \$33087 \$33800 \$32516 NWELL PWELL BULK DFF_X1
X$77117 \$I175499 \$32525 \$33082 \$32516 NWELL PWELL BULK DFF_X1
X$77119 \$34330 \$32516 \$I245747 \$33452 NWELL PWELL BULK DFF_X2
X$77121 \$33455 \$32516 \$I245569 \$33083 NWELL PWELL BULK DFF_X2
X$77124 \$43532 \$32516 \$I245585 \$43295 NWELL PWELL BULK DFF_X2
X$77127 \$I175894 \$42540 \$43199 \$32516 NWELL PWELL BULK DFF_X1
X$77129 \$I175851 \$43811 \$43808 \$32516 NWELL PWELL BULK DFF_X1
X$77132 \$41874 \$32516 \$I245714 \$41511 NWELL PWELL BULK DFF_X2
X$77135 \$I175826 \$43816 \$43813 \$32516 NWELL PWELL BULK DFF_X1
X$77138 \$I175810 \$41781 \$41165 \$32516 NWELL PWELL BULK DFF_X1
X$77140 \$42537 \$32516 \$I245742 \$41509 NWELL PWELL BULK DFF_X2
X$77142 \$I175811 \$40730 \$40727 \$32516 NWELL PWELL BULK DFF_X1
X$77145 \$I177099 \$41876 \$42458 \$32516 NWELL PWELL BULK DFF_X1
X$77148 \$I175814 \$41168 \$41513 \$32516 NWELL PWELL BULK DFF_X1
X$77150 \$42812 \$42539 \$42887 \$32516 NWELL PWELL BULK DFF_X1
X$77153 \$I175854 \$43289 \$43181 \$32516 NWELL PWELL BULK DFF_X1
X$77156 \$I177095 \$42894 \$42542 \$32516 NWELL PWELL BULK DFF_X1
X$77158 \$I177091 \$43529 \$43800 \$32516 NWELL PWELL BULK DFF_X1
X$77160 \$41165 \$32516 \$I245750 \$41130 NWELL PWELL BULK DFF_X2
X$77162 \$38251 \$38272 \$38266 \$32516 NWELL PWELL BULK DFF_X1
X$77165 \$I177203 \$37023 \$36583 \$32516 NWELL PWELL BULK DFF_X1
X$77168 \$33357 \$32516 \$32857 \$33443 NWELL PWELL BULK DFF_X2
X$77170 \$33074 \$32516 \$33439 \$32517 NWELL PWELL BULK DFF_X2
X$77172 \$I176936 \$35259 \$35938 \$32516 NWELL PWELL BULK DFF_X1
X$77175 \$36985 \$32516 \$36099 \$35250 NWELL PWELL BULK DFF_X2
X$77177 \$36102 \$36103 \$36995 \$32516 NWELL PWELL BULK DFF_X1
X$77180 \$40727 \$32516 \$I245565 \$40656 NWELL PWELL BULK DFF_X2
X$77184 \$I175974 \$38259 \$38831 \$32516 NWELL PWELL BULK DFF_X1
X$77187 \$39839 \$40202 \$39836 \$32516 NWELL PWELL BULK DFF_X1
X$77215 \$32519 \$33443 \$32517 \$33450 NWELL PWELL BULK OAI21_X1
X$77217 \$32519 \$33439 \$32517 \$34284 NWELL PWELL BULK OAI21_X1
X$77220 \$33878 \$32517 \$33080 NWELL PWELL BULK NOR2_X1
X$77222 \$32517 \$33448 NWELL PWELL BULK INV_X1
X$77225 \$32517 \$34273 \$33872 \$33869 \$33870 NWELL PWELL BULK OAI211_X2
X$77230 \$34458 \$34282 \$32519 NWELL PWELL BULK NOR2_X2
X$77235 \$33077 \$32519 \$32858 \$33350 NWELL PWELL BULK AOI21_X1
X$77238 \$33876 \$33878 \$32519 \$33877 NWELL PWELL BULK OAI21_X1
X$77248 \$33444 \$34284 \$33078 \$32520 \$34295 NWELL PWELL BULK AOI22_X1
X$77254 \$33444 \$32522 \$33785 \$33357 NWELL PWELL BULK OAI21_X1
X$77256 \$33448 \$32522 \$33789 \$33074 NWELL PWELL BULK OAI21_X1
X$77258 \$32869 \$33080 \$32879 \$32522 \$33082 NWELL PWELL BULK OAI22_X1
X$77269 \$32525 \$32879 NWELL PWELL BULK INV_X1
X$77272 \$34420 \$35322 \$32526 NWELL PWELL BULK NAND2_X4
X$77274 \$32526 \$33088 \$33462 NWELL PWELL BULK NAND2_X1
X$77276 \$32526 \$35907 \$34782 \$I241552 NWELL PWELL BULK HA_X1
X$77278 \$32526 \$33452 \$33083 \$33344 NWELL PWELL BULK NOR3_X2
X$77282 \$32526 \$33452 \$33461 NWELL PWELL BULK NAND2_X1
X$77284 \$32526 \$33087 \$33458 NWELL PWELL BULK NAND2_X1
X$77288 \$32526 \$33083 \$33454 NWELL PWELL BULK NAND2_X1
X$77291 \$32526 \$32528 NWELL PWELL BULK INV_X4
X$77298 \$32528 \$35267 \$I241036 \$34472 NWELL PWELL BULK HA_X1
X$77305 \$32528 \$33087 \$34334 NWELL PWELL BULK NAND2_X1
X$77309 \$32528 \$32889 \$33803 NWELL PWELL BULK NAND2_X1
X$77312 \$32528 \$32892 \$32893 NWELL PWELL BULK NAND2_X1
X$77340 \$34490 \$32553 \$34790 \$35104 NWELL PWELL BULK HA_X1
X$77371 \$33911 \$32573 \$33487 \$34247 NWELL PWELL BULK HA_X1
X$77378 \$32574 \$32839 \$33246 \$36138 NWELL PWELL BULK NAND3_X4
X$77381 \$34808 \$32575 \$33501 \$35766 NWELL PWELL BULK MUX2_X1
X$77383 \$41405 \$32575 \$40228 \$41408 NWELL PWELL BULK MUX2_X1
X$77386 \$36890 \$32575 \$36611 \$36905 NWELL PWELL BULK MUX2_X1
X$77389 \$39870 \$32575 \$38866 \$40494 NWELL PWELL BULK MUX2_X1
X$77391 \$38169 \$32575 \$37536 \$37591 NWELL PWELL BULK MUX2_X1
X$77393 \$41212 \$32575 \$40978 \$41360 NWELL PWELL BULK MUX2_X1
X$77396 \$34504 \$32575 \$34505 \$34591 NWELL PWELL BULK MUX2_X1
X$77400 \$42238 \$32575 \$42586 \$42364 NWELL PWELL BULK MUX2_X1
X$77403 \$42246 \$32575 \$41930 \$42345 NWELL PWELL BULK MUX2_X1
X$77406 \$42241 \$32575 \$42592 \$42355 NWELL PWELL BULK MUX2_X1
X$77409 \$41919 \$32575 \$41562 \$42062 NWELL PWELL BULK MUX2_X1
X$77411 \$42231 \$32575 \$42232 \$42748 NWELL PWELL BULK MUX2_X1
X$77417 \$36141 \$32575 \$34800 \$36142 NWELL PWELL BULK MUX2_X1
X$77419 \$37844 \$32575 \$37147 \$38203 NWELL PWELL BULK MUX2_X1
X$77421 \$39025 \$32575 \$38859 \$39024 NWELL PWELL BULK MUX2_X1
X$77454 \$32582 \$32589 \$33612 \$33602 NWELL PWELL BULK MUX2_X1
X$77462 \$36311 \$35771 \$32583 NWELL PWELL BULK NOR2_X1
X$77470 \$32588 \$32589 \$32586 \$33136 NWELL PWELL BULK MUX2_X1
X$77481 \$33498 \$32589 \$33621 \$35002 NWELL PWELL BULK MUX2_X1
X$77484 \$56727 \$32589 \$56896 \$56464 NWELL PWELL BULK MUX2_X1
X$77486 \$61226 \$32589 \$61231 \$61541 NWELL PWELL BULK MUX2_X1
X$77488 \$61890 \$32589 \$61888 \$61234 NWELL PWELL BULK MUX2_X1
X$77491 \$63235 \$32589 \$63487 \$62861 NWELL PWELL BULK MUX2_X1
X$77493 \$63165 \$32589 \$63672 \$62854 NWELL PWELL BULK MUX2_X1
X$77495 \$60435 \$32589 \$59674 \$60152 NWELL PWELL BULK MUX2_X1
X$77497 \$61892 \$32589 \$61895 \$62277 NWELL PWELL BULK MUX2_X1
X$77500 \$61487 \$32589 \$62545 \$61480 NWELL PWELL BULK MUX2_X1
X$77502 \$61460 \$32589 \$61243 \$61245 NWELL PWELL BULK MUX2_X1
X$77504 \$62275 \$32589 \$63710 \$62971 NWELL PWELL BULK MUX2_X1
X$77506 \$44304 \$32589 \$44306 \$44455 NWELL PWELL BULK MUX2_X1
X$77508 \$52696 \$32589 \$53023 \$52692 NWELL PWELL BULK MUX2_X1
X$77511 \$51366 \$32589 \$51842 \$51841 NWELL PWELL BULK MUX2_X1
X$77514 \$40234 \$32589 \$39877 \$39358 NWELL PWELL BULK MUX2_X1
X$77516 \$57352 \$32589 \$58127 \$57354 NWELL PWELL BULK MUX2_X1
X$77518 \$54574 \$32589 \$54112 \$54113 NWELL PWELL BULK MUX2_X1
X$77520 \$60430 \$32589 \$60038 \$60039 NWELL PWELL BULK MUX2_X1
X$77522 \$55526 \$32589 \$55527 \$55289 NWELL PWELL BULK MUX2_X1
X$77524 \$55320 \$32589 \$55307 \$55292 NWELL PWELL BULK MUX2_X1
X$77527 \$56408 \$32589 \$56711 \$57019 NWELL PWELL BULK MUX2_X1
X$77530 \$49891 \$32589 \$49893 \$50007 NWELL PWELL BULK MUX2_X1
X$77532 \$51358 \$32589 \$51359 \$51661 NWELL PWELL BULK MUX2_X1
X$77534 \$50605 \$32589 \$50609 \$49895 NWELL PWELL BULK MUX2_X1
X$77537 \$50213 \$32589 \$50599 \$50214 NWELL PWELL BULK MUX2_X1
X$77539 \$55124 \$32589 \$54811 \$54114 NWELL PWELL BULK MUX2_X1
X$77541 \$49886 \$32589 \$49184 \$49545 NWELL PWELL BULK MUX2_X1
X$77543 \$52148 \$32589 \$52149 \$52343 NWELL PWELL BULK MUX2_X1
X$77545 \$60043 \$32589 \$59484 \$59486 NWELL PWELL BULK MUX2_X1
X$77547 \$58957 \$32589 \$58517 \$57353 NWELL PWELL BULK MUX2_X1
X$77549 \$57027 \$32589 \$57350 \$57018 NWELL PWELL BULK MUX2_X1
X$77552 \$59161 \$32589 \$58513 \$59153 NWELL PWELL BULK MUX2_X1
X$77554 \$45302 \$32589 \$44950 \$45303 NWELL PWELL BULK MUX2_X1
X$77556 \$55893 \$32589 \$55131 \$55541 NWELL PWELL BULK MUX2_X1
X$77558 \$38871 \$32589 \$38478 \$38556 NWELL PWELL BULK MUX2_X1
X$77560 \$43805 \$32589 \$43340 \$43803 NWELL PWELL BULK MUX2_X1
X$77563 \$43843 \$32589 \$42937 \$43815 NWELL PWELL BULK MUX2_X1
X$77565 \$33918 \$32589 \$35004 \$34587 NWELL PWELL BULK MUX2_X1
X$77627 \$I178058 \$32600 \$33191 \$32602 NWELL PWELL BULK DFF_X1
X$77632 \$I175477 \$32605 \$32601 \$32602 NWELL PWELL BULK DFF_X1
X$77636 \$I175463 \$34041 \$34053 \$32602 NWELL PWELL BULK DFF_X1
X$77640 \$33558 \$33560 \$33519 \$32602 NWELL PWELL BULK DFF_X1
X$77643 \$38921 \$37968 \$37966 \$32602 NWELL PWELL BULK DFF_X1
X$77646 \$34833 \$35361 \$34884 \$32602 NWELL PWELL BULK DFF_X1
X$77649 \$35369 \$35364 \$35314 \$32602 NWELL PWELL BULK DFF_X1
X$77652 \$36179 \$36692 \$36218 \$32602 NWELL PWELL BULK DFF_X1
X$77655 \$36631 \$37216 \$37174 \$32602 NWELL PWELL BULK DFF_X1
X$77658 \$36633 \$36698 \$36702 \$32602 NWELL PWELL BULK DFF_X1
X$77660 \$I175524 \$33957 \$33528 \$32602 NWELL PWELL BULK DFF_X1
X$77663 \$I178350 \$33551 \$34029 \$32602 NWELL PWELL BULK DFF_X1
X$77665 \$I175527 \$32610 \$33170 \$32602 NWELL PWELL BULK DFF_X1
X$77668 \$I175506 \$32629 \$32609 \$32602 NWELL PWELL BULK DFF_X1
X$77671 \$34525 \$34526 \$34836 \$32602 NWELL PWELL BULK DFF_X1
X$77674 \$I175387 \$34840 \$34541 \$32602 NWELL PWELL BULK DFF_X1
X$77676 \$I178367 \$34850 \$35339 \$32602 NWELL PWELL BULK DFF_X1
X$77679 \$37988 \$38932 \$38524 \$32602 NWELL PWELL BULK DFF_X1
X$77682 \$39927 \$39447 \$39452 \$32602 NWELL PWELL BULK DFF_X1
X$77684 \$40326 \$40327 \$39928 \$32602 NWELL PWELL BULK DFF_X1
X$77686 \$38489 \$39462 \$39459 \$32602 NWELL PWELL BULK DFF_X1
X$77688 \$41240 \$40842 \$40315 \$32602 NWELL PWELL BULK DFF_X1
X$77691 \$40783 \$40850 \$40856 \$32602 NWELL PWELL BULK DFF_X1
X$77694 \$34064 \$33563 \$33566 \$32602 NWELL PWELL BULK DFF_X1
X$77697 \$I178214 \$37878 \$37904 \$32602 NWELL PWELL BULK DFF_X1
X$77700 \$37933 \$37929 \$37935 \$32602 NWELL PWELL BULK DFF_X1
X$77703 \$I178176 \$36639 \$36637 \$32602 NWELL PWELL BULK DFF_X1
X$77705 \$37549 \$37946 \$37943 \$32602 NWELL PWELL BULK DFF_X1
X$77708 \$I178228 \$37877 \$37922 \$32602 NWELL PWELL BULK DFF_X1
X$77711 \$I175788 \$36185 \$36212 \$32602 NWELL PWELL BULK DFF_X1
X$77752 \$32611 S0_AXI_WDATA[10] NWELL PWELL BULK BUF_X1
X$77781 \$33384 \$40122 \$40664 \$32652 \$33386 NWELL PWELL BULK OAI22_X4
X$77812 \$47932 \$42756 \$48286 \$43440 \$43349 \$32687 \$48029 NWELL PWELL
+ BULK OAI222_X2
X$77814 \$32687 \$43769 \$48368 NWELL PWELL BULK NOR2_X1
X$77816 \$32687 \$35401 \$48289 NWELL PWELL BULK NOR2_X1
X$77866 \$32729 \$35401 \$52948 NWELL PWELL BULK NOR2_X1
X$77869 \$53787 \$42756 \$52947 \$43440 \$43349 \$32729 \$55880 NWELL PWELL
+ BULK OAI222_X2
X$77872 \$32729 \$43769 \$54115 NWELL PWELL BULK NOR2_X1
X$77897 \$32745 \$32748 \$33048 NWELL PWELL BULK NAND2_X1
X$77902 \$35701 \$35531 \$32748 \$32745 \$33742 NWELL PWELL BULK AND4_X2
X$77911 \$33664 \$35943 \$32748 NWELL PWELL BULK NOR2_X2
X$77936 \$33860 \$34660 \$34664 \$32768 NWELL PWELL BULK AOI21_X4
X$77951 \$33872 \$35034 \$35718 \$32787 \$37473 \$33852 \$35729 NWELL PWELL
+ BULK OAI33_X1
X$77953 \$37470 \$36843 \$32787 \$36903 NWELL PWELL BULK NOR3_X1
X$77955 \$35717 \$33742 \$32787 \$36550 NWELL PWELL BULK NAND3_X2
X$77958 \$35531 \$35719 \$32787 \$35701 \$35705 NWELL PWELL BULK NAND4_X4
X$77960 \$34430 \$33386 \$33384 \$32787 \$33049 NWELL PWELL BULK OAI22_X2
X$77974 \$32804 \$32788 \$33499 \$33231 NWELL PWELL BULK MUX2_X2
X$78002 \$32827 \$42931 \$43322 NWELL PWELL BULK NOR2_X1
X$78004 \$42569 \$42930 \$32827 \$42221 \$41554 \$36138 \$41913 NWELL PWELL
+ BULK AOI222_X2
X$78006 \$42222 \$32827 \$42931 \$41908 NWELL PWELL BULK NOR3_X1
X$78013 \$34746 \$34752 \$34225 \$32830 NWELL PWELL BULK OAI21_X1
X$78034 \$32848 \$38803 \$35140 \$51328 NWELL PWELL BULK NOR3_X1
X$78037 \$32848 \$38724 \$50871 NWELL PWELL BULK NOR2_X1
X$78040 \$33384 \$32848 \$47807 \$34764 \$47539 NWELL PWELL BULK OAI22_X2
X$78043 \$36426 \$44906 \$39834 \$32848 \$37129 \$45155 NWELL PWELL BULK
+ OAI221_X2
X$78060 \$32857 \$33078 NWELL PWELL BULK INV_X1
X$78067 \$33075 \$32858 \$33076 NWELL PWELL BULK NAND2_X1
X$78231 \$33384 \$33024 \$34016 \$33386 \$33025 NWELL PWELL BULK OAI22_X2
X$78233 \$33024 \$38724 \$40121 NWELL PWELL BULK NOR2_X1
X$78235 \$33024 \$38355 \$35140 \$39784 NWELL PWELL BULK NOR3_X1
X$78247 M0_AXI_AWADDR[17] \$33031 NWELL PWELL BULK BUF_X1
X$78261 M0_AXI_AWADDR[20] \$33034 NWELL PWELL BULK BUF_X1
X$78295 \$35705 \$35708 \$33057 NWELL PWELL BULK OR2_X1
X$78299 \$34204 \$33059 \$35562 \$34741 NWELL PWELL BULK AOI21_X4
X$78305 \$33845 \$33061 \$34673 \$34186 NWELL PWELL BULK AOI21_X4
X$78307 \$33061 \$33063 \$33384 NWELL PWELL BULK NAND2_X4
X$78310 \$33061 \$33860 \$33429 \$33428 NWELL PWELL BULK NOR3_X2
X$78318 \$33860 \$33429 \$33063 NWELL PWELL BULK NOR2_X2
X$78321 \$33063 \$34282 \$34766 NWELL PWELL BULK NOR2_X1
X$78325 \$33070 \$34204 \$34282 \$33063 \$34758 NWELL PWELL BULK OAI22_X1
X$78340 \$38359 \$34195 \$37726 \$34282 \$33070 \$35140 \$40176 NWELL PWELL
+ BULK OAI222_X2
X$78343 \$33070 \$35140 \$38803 \$37062 \$39304 NWELL PWELL BULK NOR4_X4
X$78349 \$33070 \$33742 \$33725 \$33077 NWELL PWELL BULK AOI21_X2
X$78370 \$I176993 \$33072 \$33374 \$33435 NWELL PWELL BULK DFF_X1
X$78372 \$33072 \$33764 \$34226 NWELL PWELL BULK NOR2_X1
X$78375 \$I176876 \$33764 \$33073 \$33435 NWELL PWELL BULK DFF_X1
X$78385 \$33077 \$33870 \$34771 \$34768 NWELL PWELL BULK NAND3_X2
X$78390 \$33444 \$33077 \$34462 \$34464 \$33878 NWELL PWELL BULK AOI22_X1
X$78413 \$33083 \$33880 NWELL PWELL BULK INV_X2
X$78421 \$35183 \$33083 \$34470 NWELL PWELL BULK XOR2_X2
X$78439 \$36112 \$33088 \$34776 NWELL PWELL BULK XOR2_X2
X$78442 M0_AXI_ARLEN[1] \$33090 NWELL PWELL BULK BUF_X2
X$78463 M0_AXI_ARID[0] \$33097 NWELL PWELL BULK BUF_X2
X$78479 \$35136 \$33106 \$34485 \$34490 NWELL PWELL BULK HA_X1
X$78483 \$33106 \$33899 NWELL PWELL BULK INV_X1
X$78493 M0_AXI_ARID[1] \$33111 NWELL PWELL BULK BUF_X2
X$78513 \$33123 \$33663 \$33252 NWELL PWELL BULK XOR2_X1
X$78519 \$I178657 \$33239 \$33125 \$33492 NWELL PWELL BULK DFF_X1
X$78527 \$43565 \$35401 \$42944 \$43327 \$43569 \$40298 \$33131 NWELL PWELL
+ BULK OAI222_X2
X$78562 M1_AXI_WSTRB[2] \$33146 NWELL PWELL BULK BUF_X1
X$78580 \$38938 \$38940 \$33153 NWELL PWELL BULK NOR2_X2
X$78598 S0_AXI_RID[5] \$33538 NWELL PWELL BULK CLKBUF_X3
X$78615 \$33169 S0_AXI_WDATA[6] NWELL PWELL BULK BUF_X1
X$78650 \$38556 \$33222 \$39358 \$38512 NWELL PWELL BULK MUX2_X1
X$78653 \$55541 \$33222 \$56464 \$54148 NWELL PWELL BULK MUX2_X1
X$78655 \$61541 \$33222 \$61234 \$61367 NWELL PWELL BULK MUX2_X1
X$78658 \$61480 \$33222 \$62854 \$59010 NWELL PWELL BULK MUX2_X1
X$78661 \$61245 \$33222 \$62861 \$55890 NWELL PWELL BULK MUX2_X1
X$78664 \$44455 \$33222 \$45303 \$41573 NWELL PWELL BULK MUX2_X1
X$78667 \$52655 \$33222 \$53377 \$53355 NWELL PWELL BULK MUX2_X1
X$78670 \$52692 \$33222 \$51841 \$52594 NWELL PWELL BULK MUX2_X1
X$78672 \$43815 \$33222 \$43803 \$41638 NWELL PWELL BULK MUX2_X1
X$78675 \$57353 \$57354 \$33222 \$45370 NWELL PWELL BULK MUX2_X2
X$78678 \$54113 \$33222 \$54114 \$54149 NWELL PWELL BULK MUX2_X1
X$78680 \$57019 \$57018 \$33222 \$47281 NWELL PWELL BULK MUX2_X2
X$78682 \$55292 \$33222 \$55289 \$54636 NWELL PWELL BULK MUX2_X1
X$78685 \$50007 \$33222 \$49895 \$49596 NWELL PWELL BULK MUX2_X1
X$78688 \$52343 \$33222 \$51661 \$52161 NWELL PWELL BULK MUX2_X1
X$78690 \$49545 \$33222 \$50214 \$45395 NWELL PWELL BULK MUX2_X1
X$78692 \$59486 \$33222 \$60152 \$57798 NWELL PWELL BULK MUX2_X1
X$78695 \$60039 \$33222 \$59153 \$59023 NWELL PWELL BULK MUX2_X1
X$78697 \$62277 \$33222 \$62971 \$62376 NWELL PWELL BULK MUX2_X1
X$78700 \$34587 \$33222 \$35002 \$34519 NWELL PWELL BULK MUX2_X1
X$78735 \$33231 \$43769 \$64183 NWELL PWELL BULK NOR2_X1
X$78737 \$63155 \$42756 \$60427 \$43440 \$43349 \$33231 \$63475 NWELL PWELL
+ BULK OAI222_X2
X$78739 \$33231 \$35401 \$62850 NWELL PWELL BULK NOR2_X1
X$78785 M0_AXI_AWADDR[29] \$33276 NWELL PWELL BULK BUF_X1
X$78813 \$33307 \$36426 \$37796 NWELL PWELL BULK AND2_X1
X$78815 \$38359 \$37726 \$37727 \$33307 \$38817 NWELL PWELL BULK NAND4_X1
X$78821 \$34452 \$33307 \$35127 NWELL PWELL BULK NAND2_X1
X$78828 \$33307 \$38410 \$38192 NWELL PWELL BULK AND2_X1
X$78868 \$33443 \$33350 \$33791 \$33789 NWELL PWELL BULK OAI21_X1
X$78886 \$35253 \$34758 \$34452 \$34455 \$33868 \$33368 NWELL PWELL BULK
+ OAI221_X1
X$78904 \$33384 \$47511 \$49587 \$33386 \$49584 NWELL PWELL BULK OAI22_X2
X$78906 \$33384 \$49850 \$50172 \$34764 \$49842 NWELL PWELL BULK OAI22_X2
X$78911 \$33384 \$47532 \$50427 \$34764 \$49846 NWELL PWELL BULK OAI22_X2
X$78914 \$33384 \$49374 \$50175 \$34764 \$49848 NWELL PWELL BULK OAI22_X2
X$78918 \$33384 \$37721 \$37725 \$33386 \$34693 NWELL PWELL BULK OAI22_X2
X$78920 \$33384 \$47436 \$50181 \$34764 \$49855 NWELL PWELL BULK OAI22_X2
X$78923 \$33384 \$46444 \$46447 \$34764 \$46446 NWELL PWELL BULK OAI22_X2
X$78927 \$33384 \$41142 \$46024 \$33386 \$45644 NWELL PWELL BULK OAI22_X2
X$78929 \$33384 \$47698 \$51291 \$33386 \$51454 NWELL PWELL BULK OAI22_X2
X$78932 \$33384 \$49473 \$51298 \$33386 \$51297 NWELL PWELL BULK OAI22_X2
X$78935 \$33384 \$48325 \$52209 \$33386 \$52066 NWELL PWELL BULK OAI22_X2
X$78937 \$33384 \$49284 \$51549 \$33386 \$51726 NWELL PWELL BULK OAI22_X2
X$78940 \$33384 \$47155 \$50271 \$33386 \$49823 NWELL PWELL BULK OAI22_X2
X$78943 \$33384 \$39954 \$50695 \$33386 \$50696 NWELL PWELL BULK OAI22_X2
X$78947 \$33384 \$50323 \$51561 \$33386 \$51782 NWELL PWELL BULK OAI22_X2
X$78950 \$33384 \$50537 \$52075 \$33386 \$51281 NWELL PWELL BULK OAI22_X2
X$78953 \$33384 \$48206 \$48944 \$34764 \$48934 NWELL PWELL BULK OAI22_X2
X$78956 \$33384 \$49137 \$49135 \$34764 \$48599 NWELL PWELL BULK OAI22_X2
X$78960 \$33384 \$43949 \$45674 \$34764 \$45952 NWELL PWELL BULK OAI22_X2
X$78970 \$33384 \$33385 \$34020 \$33386 \$34025 NWELL PWELL BULK OAI22_X2
X$79015 \$33385 \$38355 \$35140 \$41271 NWELL PWELL BULK NOR3_X1
X$79021 \$33385 \$38724 \$41968 NWELL PWELL BULK NOR2_X1
X$79025 \$34764 \$33386 NWELL PWELL BULK BUF_X16
X$79124 \$35682 \$34403 \$33398 \$36039 \$36538 NWELL PWELL BULK OR4_X2
X$79126 \$34094 \$36513 \$33398 \$36514 \$36752 NWELL PWELL BULK AOI22_X1
X$79129 \$35682 \$34403 \$33398 \$36039 \$35701 NWELL PWELL BULK NOR4_X4
X$79132 \$34094 \$33845 \$33398 \$33829 \$33828 NWELL PWELL BULK AOI22_X1
X$79149 \$35873 \$36513 \$33411 \$36514 \$38619 NWELL PWELL BULK AOI22_X1
X$79151 \$33411 \$36524 \$37072 \$34614 \$38018 NWELL PWELL BULK AOI22_X2
X$79153 \$35873 \$33845 \$33411 \$33829 \$35415 NWELL PWELL BULK AOI22_X1
X$79164 \$I175489 \$33412 \$33644 \$33414 NWELL PWELL BULK DFF_X1
X$79172 \$I178807 \$33835 \$34124 \$33414 NWELL PWELL BULK DFF_X1
X$79174 \$I175965 \$33655 \$33657 \$33414 NWELL PWELL BULK DFF_X1
X$79177 \$I175979 \$34418 \$34960 \$33414 NWELL PWELL BULK DFF_X1
X$79179 \$I178768 \$37733 \$37439 \$33414 NWELL PWELL BULK DFF_X1
X$79182 \$I176050 \$36503 \$36501 \$33414 NWELL PWELL BULK DFF_X1
X$79184 \$I175471 \$36260 \$36506 \$33414 NWELL PWELL BULK DFF_X1
X$79186 \$I177528 \$39231 \$39487 \$33414 NWELL PWELL BULK DFF_X1
X$79188 \$I177459 \$37734 \$38366 \$33414 NWELL PWELL BULK DFF_X1
X$79190 \$I174395 \$38750 \$39501 \$33414 NWELL PWELL BULK DFF_X1
X$79193 \$I176547 \$40692 \$40929 \$33414 NWELL PWELL BULK DFF_X1
X$79195 \$I176543 \$40398 \$40403 \$33414 NWELL PWELL BULK DFF_X1
X$79198 \$I176240 \$40143 \$40418 \$33414 NWELL PWELL BULK DFF_X1
X$79201 \$I176304 \$41156 \$41719 \$33414 NWELL PWELL BULK DFF_X1
X$79203 \$I176501 \$43082 \$43083 \$33414 NWELL PWELL BULK DFF_X1
X$79205 \$I176502 \$43516 \$43740 \$33414 NWELL PWELL BULK DFF_X1
X$79207 \$I176238 \$42717 \$42371 \$33414 NWELL PWELL BULK DFF_X1
X$79210 \$I177013 \$42175 \$42737 \$33414 NWELL PWELL BULK DFF_X1
X$79213 \$I176601 \$42868 \$43102 \$33414 NWELL PWELL BULK DFF_X1
X$79216 \$I177017 \$43277 \$43278 \$33414 NWELL PWELL BULK DFF_X1
X$79218 \$I178867 \$42178 \$42177 \$33414 NWELL PWELL BULK DFF_X1
X$79220 \$I176237 \$41368 \$41498 \$33414 NWELL PWELL BULK DFF_X1
X$79222 \$I176227 \$41151 \$42045 \$33414 NWELL PWELL BULK DFF_X1
X$79224 \$I176950 \$41152 \$41359 \$33414 NWELL PWELL BULK DFF_X1
X$79227 \$I176946 \$42357 \$42515 \$33414 NWELL PWELL BULK DFF_X1
X$79230 \$I176469 \$43728 \$43514 \$33414 NWELL PWELL BULK DFF_X1
X$79232 \$I176730 \$41853 \$42171 \$33414 NWELL PWELL BULK DFF_X1
X$79234 \$I176173 \$41149 \$41494 \$33414 NWELL PWELL BULK DFF_X1
X$79236 \$I178847 \$43519 \$43750 \$33414 NWELL PWELL BULK DFF_X1
X$79238 \$I176366 \$42521 \$43115 \$33414 NWELL PWELL BULK DFF_X1
X$79274 \$36534 \$33845 \$35943 \$33829 \$33418 NWELL PWELL BULK AOI22_X1
X$79283 \$33419 \$39076 NWELL PWELL BULK INV_X1
X$79285 \$33664 \$36524 \$37693 \$37072 \$33419 NWELL PWELL BULK AOI22_X4
X$79307 \$34204 \$33429 \$33860 \$34764 NWELL PWELL BULK OAI21_X4
X$79311 \$33429 \$33860 \$34204 \$33829 NWELL PWELL BULK NOR3_X4
X$79320 \$43790 \$43485 \$43488 \$33435 NWELL PWELL BULK DFF_X1
X$79323 \$I177202 \$35257 \$36948 \$33435 NWELL PWELL BULK DFF_X1
X$79325 \$36093 \$35942 \$35736 \$33435 NWELL PWELL BULK DFF_X1
X$79327 \$35072 \$33435 \$34745 \$34746 NWELL PWELL BULK DFF_X2
X$79329 \$33746 \$33435 \$33749 \$33862 NWELL PWELL BULK DFF_X2
X$79336 \$43775 \$43476 \$43773 \$33435 NWELL PWELL BULK DFF_X1
X$79339 \$43785 \$43481 \$43482 \$33435 NWELL PWELL BULK DFF_X1
X$79342 \$I176388 \$43946 \$43944 \$33435 NWELL PWELL BULK DFF_X1
X$79344 \$I178782 \$43765 \$43761 \$33435 NWELL PWELL BULK DFF_X1
X$79346 \$I175918 \$43129 \$43127 \$33435 NWELL PWELL BULK DFF_X1
X$79348 \$I175899 \$42526 \$42759 \$33435 NWELL PWELL BULK DFF_X1
X$79350 \$41863 \$42402 \$42398 \$33435 NWELL PWELL BULK DFF_X1
X$79352 \$42083 \$41739 \$42082 \$33435 NWELL PWELL BULK DFF_X1
X$79354 \$42875 \$42767 \$42774 \$33435 NWELL PWELL BULK DFF_X1
X$79356 \$41866 \$42418 \$42414 \$33435 NWELL PWELL BULK DFF_X1
X$79358 \$I178888 \$39808 \$40154 \$33435 NWELL PWELL BULK DFF_X1
X$79361 \$I177140 \$39806 \$40972 \$33435 NWELL PWELL BULK DFF_X1
X$79364 \$I176242 \$41716 \$41712 \$33435 NWELL PWELL BULK DFF_X1
X$79366 \$I177142 \$41371 \$41363 \$33435 NWELL PWELL BULK DFF_X1
X$79369 \$40723 \$40542 \$41038 \$33435 NWELL PWELL BULK DFF_X1
X$79371 \$I176349 \$38806 \$39646 \$33435 NWELL PWELL BULK DFF_X1
X$79374 \$I178839 \$42182 \$42391 \$33435 NWELL PWELL BULK DFF_X1
X$79377 \$41398 \$33435 \$40709 \$38122 NWELL PWELL BULK DFF_X2
X$79380 \$40101 \$40502 \$39821 \$33435 NWELL PWELL BULK DFF_X1
X$79383 \$I176836 \$41160 \$41392 \$33435 NWELL PWELL BULK DFF_X1
X$79386 \$40974 \$33435 \$40705 \$39271 NWELL PWELL BULK DFF_X2
X$79388 \$I178781 \$42388 \$42523 \$33435 NWELL PWELL BULK DFF_X1
X$79391 \$41384 \$33435 \$41386 \$38397 NWELL PWELL BULK DFF_X2
X$79426 \$33443 \$33448 \$33876 NWELL PWELL BULK NOR2_X1
X$79430 \$33443 \$33444 NWELL PWELL BULK INV_X1
X$79460 \$36110 \$33452 \$34772 NWELL PWELL BULK XOR2_X2
X$79482 \$33468 \$34475 \$35170 NWELL PWELL BULK XOR2_X1
X$79485 \$33468 \$34354 NWELL PWELL BULK INV_X1
X$79490 \$33751 \$33471 \$33756 \$34366 NWELL PWELL BULK DFF_X1
X$79492 M0_AXI_ARLEN[2] \$33472 NWELL PWELL BULK BUF_X2
X$79521 \$38200 \$37844 \$38203 \$33492 NWELL PWELL BULK DFF_X1
X$79523 \$37317 \$37148 \$37318 \$33492 NWELL PWELL BULK DFF_X1
X$79525 \$38861 \$39000 \$39012 \$33492 NWELL PWELL BULK DFF_X1
X$79528 \$41035 \$40505 \$40501 \$33492 NWELL PWELL BULK DFF_X1
X$79530 \$39966 \$39870 \$40494 \$33492 NWELL PWELL BULK DFF_X1
X$79532 \$39570 \$38994 \$38863 \$33492 NWELL PWELL BULK DFF_X1
X$79535 \$41395 \$41006 \$40495 \$33492 NWELL PWELL BULK DFF_X1
X$79538 \$41373 \$40757 \$41375 \$33492 NWELL PWELL BULK DFF_X1
X$79541 \$I175184 \$35877 \$35519 \$33492 NWELL PWELL BULK DFF_X1
X$79543 \$33639 \$33643 \$33645 \$33492 NWELL PWELL BULK DFF_X1
X$79549 \$38475 \$38561 \$38163 \$33492 NWELL PWELL BULK DFF_X1
X$79552 \$37851 \$37852 \$37590 \$33492 NWELL PWELL BULK DFF_X1
X$79554 \$39567 \$39566 \$38991 \$33492 NWELL PWELL BULK DFF_X1
X$79557 \$I179189 \$36322 \$36328 \$33492 NWELL PWELL BULK DFF_X1
X$79560 \$36920 \$36317 \$36926 \$33492 NWELL PWELL BULK DFF_X1
X$79564 \$I175162 \$36141 \$36142 \$33492 NWELL PWELL BULK DFF_X1
X$79567 \$33914 \$34217 \$34219 \$33492 NWELL PWELL BULK DFF_X1
X$79569 \$I177512 \$33912 \$34499 \$33492 NWELL PWELL BULK DFF_X1
X$79571 \$34499 \$33492 \$I245589 \$33499 NWELL PWELL BULK DFF_X2
X$79573 \$35023 \$34504 \$34591 \$33492 NWELL PWELL BULK DFF_X1
X$79576 \$I178651 \$34802 \$35050 \$33492 NWELL PWELL BULK DFF_X1
X$79578 \$38175 \$37848 \$38184 \$33492 NWELL PWELL BULK DFF_X1
X$79581 \$37533 \$37299 \$37300 \$33492 NWELL PWELL BULK DFF_X1
X$79584 \$38472 \$38169 \$37591 \$33492 NWELL PWELL BULK DFF_X1
X$79587 \$38473 \$37150 \$37296 \$33492 NWELL PWELL BULK DFF_X1
X$79590 \$39579 \$39588 \$39019 \$33492 NWELL PWELL BULK DFF_X1
X$79592 \$39581 \$39025 \$39024 \$33492 NWELL PWELL BULK DFF_X1
X$79595 \$38856 \$33492 \$I245604 \$39959 NWELL PWELL BULK DFF_X2
X$79621 \$39869 \$39969 \$33499 \$40510 NWELL PWELL BULK MUX2_X2
X$79623 \$41402 \$41707 \$33499 \$41725 NWELL PWELL BULK MUX2_X2
X$79625 \$40476 \$40444 \$33499 \$40993 NWELL PWELL BULK MUX2_X2
X$79627 \$38559 \$38476 \$33499 \$38159 NWELL PWELL BULK MUX2_X2
X$79629 \$38205 \$37594 \$33499 \$38198 NWELL PWELL BULK MUX2_X2
X$79635 \$43080 \$42703 \$33499 \$43076 NWELL PWELL BULK MUX2_X2
X$79637 \$41564 \$41693 \$33499 \$41698 NWELL PWELL BULK MUX2_X2
X$79639 \$42732 \$42374 \$33499 \$43116 NWELL PWELL BULK MUX2_X2
X$79642 \$42581 \$33499 \$42582 \$42583 NWELL PWELL BULK MUX2_X1
X$79645 \$42587 \$42588 \$33499 \$43095 NWELL PWELL BULK MUX2_X2
X$79648 \$42695 \$42691 \$33499 \$43069 NWELL PWELL BULK MUX2_X2
X$79674 M1_AXI_WDATA[6] \$33501 NWELL PWELL BULK BUF_X1
X$79694 \$35456 \$35779 \$33506 NWELL PWELL BULK NOR2_X1
X$79708 \$35422 \$35786 \$33513 NWELL PWELL BULK NOR2_X1
X$79721 M1_AXI_WDATA[24] \$33517 NWELL PWELL BULK BUF_X1
X$79743 \$33523 S0_AXI_WDATA[13] NWELL PWELL BULK BUF_X1
X$79759 \$56675 \$55501 \$33538 \$57178 NWELL PWELL BULK MUX2_X1
X$79761 \$33538 \$54550 \$57617 \$57619 NWELL PWELL BULK MUX2_X1
X$79764 \$33538 \$55498 \$56378 \$56532 NWELL PWELL BULK MUX2_X1
X$79766 \$33538 \$56680 \$57605 \$57615 NWELL PWELL BULK MUX2_X1
X$79794 \$34064 \$34520 \$33558 \$34521 NWELL PWELL BULK MUX2_X1
X$79836 \$33596 \$33934 \$34128 \$33935 NWELL PWELL BULK DFF_X1
X$79927 \$34977 \$33845 \$33664 \$33829 \$34145 NWELL PWELL BULK AOI22_X1
X$79931 \$34977 \$36513 \$36514 \$33664 \$37760 NWELL PWELL BULK AOI22_X2
X$79947 \$58475 \$33680 \$57625 \$60712 \$61691 \$60714 NWELL PWELL BULK
+ OAI221_X2
X$79950 \$61194 \$33680 \$60712 \$60008 \$62056 \$61854 NWELL PWELL BULK
+ OAI221_X2
X$79953 \$61189 \$33680 \$60712 \$57301 \$62686 \$62057 NWELL PWELL BULK
+ OAI221_X2
X$79964 \$61194 \$33689 \$62232 \$60008 \$62076 \$61858 NWELL PWELL BULK
+ OAI221_X2
X$79966 \$58475 \$33689 \$57625 \$62232 \$61178 \$62251 NWELL PWELL BULK
+ OAI221_X2
X$79969 \$61189 \$33689 \$62232 \$57301 \$62659 \$62650 NWELL PWELL BULK
+ OAI221_X2
X$80040 M0_AXI_ARID[2] \$33736 NWELL PWELL BULK BUF_X2
X$80076 \$33749 \$35098 NWELL PWELL BULK INV_X1
X$80095 \$33758 \$33759 \$33891 \$34366 NWELL PWELL BULK DFF_X1
X$80119 \$39198 \$38817 \$38818 \$33770 NWELL PWELL BULK AOI21_X1
X$80158 M1_AXI_AWADDR[15] \$33814 NWELL PWELL BULK BUF_X1
X$80185 \$35503 \$33845 \$35915 \$33829 \$34419 NWELL PWELL BULK AOI22_X1
X$80188 \$35219 \$33845 \$34721 \$33829 \$33838 NWELL PWELL BULK AOI22_X1
X$80193 \$35464 \$33845 \$35465 \$33829 \$35218 NWELL PWELL BULK AOI22_X1
X$80196 \$34725 \$33845 \$36039 \$33829 \$35894 NWELL PWELL BULK AOI22_X1
X$80199 \$34724 \$33845 \$36045 \$33829 \$35690 NWELL PWELL BULK AOI22_X1
X$80201 \$36037 \$33845 \$36046 \$33829 \$36774 NWELL PWELL BULK AOI22_X1
X$80210 \$35866 \$33845 \$34403 \$33829 \$34600 NWELL PWELL BULK AOI22_X1
X$80213 \$35865 \$33845 \$35417 \$33829 \$35677 NWELL PWELL BULK AOI22_X1
X$80216 \$34931 \$33845 \$35682 \$33829 \$34411 NWELL PWELL BULK AOI22_X1
X$80219 \$35420 \$33845 \$34706 \$33829 \$34920 NWELL PWELL BULK AOI22_X1
X$80301 \$35719 \$35531 \$35701 \$33852 NWELL PWELL BULK NAND3_X1
X$80315 \$33854 \$34430 \$35041 \$34148 \$35553 NWELL PWELL BULK NAND4_X1
X$80319 \$34148 \$35041 \$34430 \$33854 \$35022 NWELL PWELL BULK AND4_X1
X$80385 \$34238 \$33862 \$34230 \$34446 NWELL PWELL BULK AOI21_X1
X$80387 \$35729 \$33862 \$35733 NWELL PWELL BULK NOR2_X1
X$80390 \$35248 \$33862 \$35249 NWELL PWELL BULK NOR2_X1
X$80393 \$33862 \$34224 \$34747 \$35601 NWELL PWELL BULK AOI21_X1
X$80398 \$34747 \$33862 \$35955 NWELL PWELL BULK NOR2_X1
X$80400 \$37402 \$33862 \$37691 NWELL PWELL BULK NOR2_X1
X$80403 \$36081 \$33862 \$35248 \$37477 NWELL PWELL BULK OAI21_X2
X$80405 \$33862 \$35244 NWELL PWELL BULK INV_X1
X$80418 \$33867 \$40091 \$39308 NWELL PWELL BULK NOR2_X2
X$80421 \$39694 \$33867 NWELL PWELL BULK INV_X1
X$80432 \$34455 \$33868 \$35132 NWELL PWELL BULK NOR2_X1
X$80437 \$34449 \$34756 \$33868 NWELL PWELL BULK OR2_X2
X$80442 \$33869 \$33872 \$34458 NWELL PWELL BULK NOR2_X1
X$80448 \$35239 \$35041 \$35581 \$33869 NWELL PWELL BULK NAND3_X2
X$80466 \$35952 \$36059 \$34997 \$33872 NWELL PWELL BULK NAND3_X4
X$80468 \$35034 \$33872 \$36552 \$35722 \$35710 \$34179 \$36455 NWELL PWELL
+ BULK OAI33_X1
X$80472 \$36080 \$35034 \$33872 \$36004 NWELL PWELL BULK NOR3_X1
X$80494 \$36582 \$33877 \$34771 \$36581 NWELL PWELL BULK MUX2_X2
X$80496 \$36582 \$37012 \$33877 \$33879 \$36583 NWELL PWELL BULK OAI22_X1
X$80524 \$35171 \$34476 \$33887 \$34356 NWELL PWELL BULK MUX2_X1
X$80527 \$35160 \$34475 \$33889 \$34354 \$33887 NWELL PWELL BULK FA_X1
X$80531 \$34476 \$33889 \$34786 NWELL PWELL BULK NOR2_X1
X$80544 \$34612 \$34492 \$33904 \$34619 NWELL PWELL BULK NAND3_X1
X$80567 M1_AXI_WID[0] \$33929 NWELL PWELL BULK BUF_X1
X$80581 \$42244 \$41927 \$42351 \$33935 NWELL PWELL BULK DFF_X1
X$80583 \$I175598 \$41224 \$41567 \$33935 NWELL PWELL BULK DFF_X1
X$80585 \$38481 \$38120 \$38979 \$33935 NWELL PWELL BULK DFF_X1
X$80587 \$I176142 \$40770 \$40925 \$33935 NWELL PWELL BULK DFF_X1
X$80589 \$I177960 \$40948 \$41326 \$33935 NWELL PWELL BULK DFF_X1
X$80592 \$I177917 \$40239 \$40928 \$33935 NWELL PWELL BULK DFF_X1
X$80595 \$40413 \$39878 \$40422 \$33935 NWELL PWELL BULK DFF_X1
X$80597 \$41334 \$41331 \$41345 \$33935 NWELL PWELL BULK DFF_X1
X$80600 \$40960 \$40762 \$40412 \$33935 NWELL PWELL BULK DFF_X1
X$80603 \$38973 \$38482 \$38971 \$33935 NWELL PWELL BULK DFF_X1
X$80606 \$40395 \$40392 \$39956 \$33935 NWELL PWELL BULK DFF_X1
X$80608 \$38957 \$39361 \$39522 \$33935 NWELL PWELL BULK DFF_X1
X$80610 \$38958 \$38544 \$38536 \$33935 NWELL PWELL BULK DFF_X1
X$80613 \$36167 \$36781 \$36621 \$33935 NWELL PWELL BULK DFF_X1
X$80615 \$36776 \$35787 \$36246 \$33935 NWELL PWELL BULK DFF_X1
X$80618 \$I176844 \$33940 \$33937 \$33935 NWELL PWELL BULK DFF_X1
X$80621 \$I175116 \$36163 \$36159 \$33935 NWELL PWELL BULK DFF_X1
X$80623 \$I178834 \$35783 \$35850 \$33935 NWELL PWELL BULK DFF_X1
X$80626 \$38075 \$37863 \$37586 \$33935 NWELL PWELL BULK DFF_X1
X$80629 \$37158 \$37159 \$37261 \$33935 NWELL PWELL BULK DFF_X1
X$80632 \$I178335 \$38871 \$38986 \$33935 NWELL PWELL BULK DFF_X1
X$80635 \$35302 \$34973 \$35300 \$33935 NWELL PWELL BULK DFF_X1
X$80637 \$34582 \$34968 \$34966 \$33935 NWELL PWELL BULK DFF_X1
X$80639 \$I175178 \$34938 \$35409 \$33935 NWELL PWELL BULK DFF_X1
X$80641 \$I176818 \$35306 \$35781 \$33935 NWELL PWELL BULK DFF_X1
X$80644 \$I175559 \$38478 \$38984 \$33935 NWELL PWELL BULK DFF_X1
X$80647 \$38132 \$37855 \$38128 \$33935 NWELL PWELL BULK DFF_X1
X$80649 \$37156 \$37539 \$37587 \$33935 NWELL PWELL BULK DFF_X1
X$80652 \$36155 \$36274 \$36279 \$33935 NWELL PWELL BULK DFF_X1
X$80723 \$33958 S0_AXI_WDATA[29] NWELL PWELL BULK BUF_X1
X$80725 S0_AXI_RLAST \$33980 NWELL PWELL BULK CLKBUF_X3
X$80734 \$34519 S0_AXI_WLAST NWELL PWELL BULK BUF_X1
X$80753 \$33978 S0_AXI_WID[0] NWELL PWELL BULK BUF_X1
X$80756 \$59447 \$55501 \$33980 \$59887 NWELL PWELL BULK MUX2_X1
X$80758 \$33980 \$55498 \$59906 \$59902 NWELL PWELL BULK MUX2_X1
X$80760 \$33980 \$54550 \$59912 \$60015 NWELL PWELL BULK MUX2_X1
X$80763 \$33980 \$56680 \$58924 \$58101 NWELL PWELL BULK MUX2_X1
X$80797 \$42623 \$43254 \$40656 \$34012 NWELL PWELL BULK MUX2_X2
X$80799 \$34012 \$37726 \$37727 \$38948 NWELL PWELL BULK NOR3_X1
X$80801 \$37741 \$39778 \$37755 \$41266 \$34012 NWELL PWELL BULK OAI22_X4
X$80813 \$37741 \$40657 \$37755 \$40830 \$34016 NWELL PWELL BULK OAI22_X4
X$80818 \$40813 \$41477 \$40656 \$34016 NWELL PWELL BULK MUX2_X2
X$80821 \$34016 \$37726 \$37727 \$39936 NWELL PWELL BULK NOR3_X1
X$80826 \$34020 \$37755 \$41621 \$43259 \$37741 NWELL PWELL BULK OAI22_X4
X$80830 \$34020 \$37726 \$37727 \$41625 NWELL PWELL BULK NOR3_X1
X$80833 \$43258 \$42635 \$40656 \$34020 NWELL PWELL BULK MUX2_X2
X$80849 \$34045 \$37726 \$37727 \$50292 NWELL PWELL BULK NOR3_X1
X$80852 \$44884 \$50993 \$37755 \$64948 \$34045 NWELL PWELL BULK OAI22_X4
X$80856 \$58172 \$58827 \$50040 \$34045 NWELL PWELL BULK MUX2_X2
X$80877 \$46561 \$46570 \$40656 \$34061 NWELL PWELL BULK MUX2_X2
X$80880 \$34061 \$37726 \$37727 \$39225 NWELL PWELL BULK NOR3_X1
X$80882 \$37741 \$38742 \$37755 \$40337 \$34061 NWELL PWELL BULK OAI22_X4
X$80900 \$34559 \$34520 \$34078 \$34517 NWELL PWELL BULK MUX2_X1
X$80913 \$41312 \$41144 \$40656 \$34094 NWELL PWELL BULK MUX2_X2
X$80916 \$35865 \$34094 \$34917 \$36050 \$35952 NWELL PWELL BULK NOR4_X4
X$80923 \$34094 \$37441 NWELL PWELL BULK INV_X1
X$80976 \$35238 \$34148 \$35239 NWELL PWELL BULK NAND2_X1
X$80980 \$37780 \$37781 \$34148 \$35248 \$35994 NWELL PWELL BULK NOR4_X1
X$80984 \$35231 \$34148 \$38122 \$35238 \$37775 NWELL PWELL BULK NOR4_X2
X$80991 \$34148 \$35709 NWELL PWELL BULK INV_X2
X$80993 \$34724 \$34725 \$34148 \$34282 \$36380 NWELL PWELL BULK NOR4_X2
X$80995 \$38783 \$37085 \$34148 \$39605 NWELL PWELL BULK NOR3_X1
X$80997 \$35238 \$35231 \$34148 \$39272 \$38388 NWELL PWELL BULK NOR4_X1
X$81011 \$55253 \$55651 \$50040 \$34148 NWELL PWELL BULK MUX2_X2
X$81034 \$36392 \$36065 \$34462 \$36540 \$34179 NWELL PWELL BULK NAND4_X2
X$81061 \$34470 \$34776 \$34772 \$34195 NWELL PWELL BULK NOR3_X4
X$81063 \$38359 \$38803 \$34195 \$38420 NWELL PWELL BULK NOR3_X1
X$81065 \$34195 \$38803 \$38359 \$38824 NWELL PWELL BULK OR3_X2
X$81069 \$39149 \$34195 \$38259 \$38434 NWELL PWELL BULK NOR3_X1
X$81071 \$36451 \$34195 \$36567 NWELL PWELL BULK NOR2_X1
X$81073 \$35710 \$35722 \$34195 \$34456 \$34750 NWELL PWELL BULK NOR4_X2
X$81080 \$34195 \$36451 \$38410 \$36943 \$39672 NWELL PWELL BULK OR4_X1
X$81121 \$50737 \$42756 \$49535 \$43440 \$43349 \$34216 \$50741 NWELL PWELL
+ BULK OAI222_X2
X$81124 \$34216 \$43769 \$50903 NWELL PWELL BULK NOR2_X1
X$81127 \$34216 \$35401 \$41559 NWELL PWELL BULK NOR2_X1
X$81145 \$34226 \$34225 \$34224 NWELL PWELL BULK NAND2_X1
X$81150 \$35249 \$34752 \$34225 \$35735 NWELL PWELL BULK OAI21_X1
X$81152 \$35725 \$36080 \$34225 NWELL PWELL BULK NOR2_X2
X$81156 \$34225 \$34446 \$34747 \$34226 \$34232 NWELL PWELL BULK OAI22_X1
X$81158 \$34225 \$34745 \$34746 \$35609 NWELL PWELL BULK OAI21_X1
X$81178 \$34750 \$34230 NWELL PWELL BULK INV_X1
X$81182 \$35601 \$34230 \$35076 NWELL PWELL BULK NOR2_X1
X$81196 \$34747 \$35248 \$34750 \$34238 NWELL PWELL BULK AOI21_X1
X$81217 \$61189 \$34269 \$60394 \$57301 \$62091 \$62111 NWELL PWELL BULK
+ OAI221_X2
X$81222 \$58475 \$34269 \$57625 \$60394 \$60538 \$59462 NWELL PWELL BULK
+ OAI221_X2
X$81227 \$61194 \$34269 \$60394 \$60008 \$60991 \$62684 NWELL PWELL BULK
+ OAI221_X2
X$81239 \$40731 \$40733 \$40732 \$34273 NWELL PWELL BULK OR3_X4
X$81241 \$34771 \$37498 \$34273 \$38249 NWELL PWELL BULK AOI21_X1
X$81247 \$38359 \$38803 \$34273 \$39311 NWELL PWELL BULK NAND3_X2
X$81249 \$39735 \$34273 \$39835 NWELL PWELL BULK NAND2_X1
X$81251 \$34273 \$38803 \$38359 \$38823 NWELL PWELL BULK AND3_X1
X$81253 \$34273 \$35581 \$35041 \$35994 \$36900 NWELL PWELL BULK AND4_X1
X$81255 \$34273 \$35581 \$35019 NWELL PWELL BULK AND2_X2
X$81259 \$35581 \$34273 \$35034 NWELL PWELL BULK NAND2_X1
X$81262 \$37478 \$37477 \$36566 \$37479 \$34273 \$37681 NWELL PWELL BULK
+ OAI221_X2
X$81290 \$34282 \$36572 \$38827 NWELL PWELL BULK OR2_X1
X$81292 \$40732 \$40733 \$40731 \$34282 NWELL PWELL BULK NOR3_X4
X$81295 \$34282 \$34724 \$34725 \$37463 NWELL PWELL BULK NOR3_X1
X$81378 \$35147 \$35154 \$35157 \$34366 NWELL PWELL BULK DFF_X1
X$81380 \$I176385 \$35160 \$34478 \$34366 NWELL PWELL BULK DFF_X1
X$81385 \$37510 \$34366 \$37392 \$37128 NWELL PWELL BULK DFF_X2
X$81390 \$I175741 \$40632 \$40209 \$34366 NWELL PWELL BULK DFF_X1
X$81393 \$39747 \$34366 \$38448 \$37127 NWELL PWELL BULK DFF_X2
X$81395 \$I177050 \$43300 \$43301 \$34366 NWELL PWELL BULK DFF_X1
X$81397 \$I176052 \$41883 \$42203 \$34366 NWELL PWELL BULK DFF_X1
X$81400 \$I176053 \$41810 \$41885 \$34366 NWELL PWELL BULK DFF_X1
X$81402 \$I177082 \$39842 \$39758 \$34366 NWELL PWELL BULK DFF_X1
X$81407 \$40625 \$34366 \$I245594 \$40091 NWELL PWELL BULK DFF_X2
X$81410 \$39117 \$34366 \$37410 \$37505 NWELL PWELL BULK DFF_X2
X$81412 \$I177081 \$41516 \$41877 \$34366 NWELL PWELL BULK DFF_X1
X$81414 \$I177086 \$42897 \$42543 \$34366 NWELL PWELL BULK DFF_X1
X$81416 \$42838 \$41880 \$42835 \$34366 NWELL PWELL BULK DFF_X1
X$81419 \$40620 \$40206 \$40618 \$34366 NWELL PWELL BULK DFF_X1
X$81422 \$I175930 \$41173 \$41175 \$34366 NWELL PWELL BULK DFF_X1
X$81424 \$41178 \$41806 \$41801 \$34366 NWELL PWELL BULK DFF_X1
X$81426 \$I177071 \$39841 \$40610 \$34366 NWELL PWELL BULK DFF_X1
X$81429 \$41099 \$34366 \$I245581 \$37522 NWELL PWELL BULK DFF_X2
X$81432 \$40646 \$34366 \$I245738 \$39850 NWELL PWELL BULK DFF_X2
X$81435 \$42208 \$34366 \$42819 \$42210 NWELL PWELL BULK DFF_X2
X$81437 \$39723 \$34366 \$I245735 \$37515 NWELL PWELL BULK DFF_X2
X$81440 \$42830 \$34366 \$41889 \$41524 NWELL PWELL BULK DFF_X2
X$81442 \$42146 \$34366 \$41888 \$41887 NWELL PWELL BULK DFF_X2
X$81447 \$43222 \$34366 \$44216 \$43303 NWELL PWELL BULK DFF_X2
X$81496 \$34387 \$34865 \$34863 \$35664 NWELL PWELL BULK DFF_X1
X$81508 \$35866 \$36513 \$34403 \$36514 \$39795 NWELL PWELL BULK AOI22_X1
X$81531 \$35269 \$34420 NWELL PWELL BULK INV_X2
X$81536 \$34420 M1_AXI_AWREADY NWELL PWELL BULK BUF_X1
X$81544 \$34999 \$34426 \$34425 \$34995 NWELL PWELL BULK NOR3_X1
X$81557 \$34429 \$35068 \$34428 \$35710 NWELL PWELL BULK NAND3_X4
X$81559 \$34428 \$34429 \$34441 NWELL PWELL BULK NAND2_X1
X$81574 \$37781 \$37780 \$34430 NWELL PWELL BULK OR2_X2
X$81577 \$34430 \$35041 \$38397 \$38398 NWELL PWELL BULK NAND3_X1
X$81583 \$34430 \$35041 \$38783 NWELL PWELL BULK NAND2_X1
X$81586 \$37480 \$38659 \$37755 \$38661 \$34430 NWELL PWELL BULK OAI22_X4
X$81598 \$34441 \$34456 \$34461 \$34464 NWELL PWELL BULK OR3_X1
X$81601 \$34461 \$34456 \$34441 \$34470 \$34776 \$34772 \$34465 NWELL PWELL
+ BULK OAI33_X1
X$81632 \$40190 \$39304 \$39309 \$34455 NWELL PWELL BULK OAI21_X2
X$81645 \$36540 \$36392 \$36065 \$34456 NWELL PWELL BULK NAND3_X2
X$81664 \$35068 \$35722 \$34461 NWELL PWELL BULK NOR2_X1
X$81672 \$34772 \$34776 \$34470 \$34462 NWELL PWELL BULK OR3_X4
X$81674 \$37796 \$34462 \$36572 \$37494 NWELL PWELL BULK AOI21_X1
X$81676 \$38251 \$34462 \$37499 \$37805 NWELL PWELL BULK AND3_X1
X$81679 \$36108 \$37499 \$34462 \$38268 NWELL PWELL BULK AOI21_X1
X$81682 \$36572 \$34462 \$39173 NWELL PWELL BULK NAND2_X1
X$81685 \$37499 \$34462 \$35267 NWELL PWELL BULK NAND2_X2
X$81687 \$38432 \$38433 \$34462 \$38431 NWELL PWELL BULK AOI21_X1
X$81693 \$36392 \$36065 \$34462 \$37089 \$37706 NWELL PWELL BULK NAND4_X2
X$81722 \$36103 \$34465 \$35636 NWELL PWELL BULK OR2_X1
X$81728 \$36410 \$37012 \$34468 \$34773 NWELL PWELL BULK OAI21_X1
X$81738 \$34472 \$35187 \$34781 NWELL PWELL BULK XOR2_X1
X$81740 \$34472 \$34783 NWELL PWELL BULK INV_X1
X$81743 \$34473 \$35187 \$34785 \$34783 \$35273 NWELL PWELL BULK FA_X1
X$81745 \$34784 \$34473 \$34782 \$34643 NWELL PWELL BULK AOI21_X1
X$81755 \$35170 \$34476 \$35889 NWELL PWELL BULK NOR2_X1
X$81760 \$34786 \$35160 \$34476 \$35570 NWELL PWELL BULK AOI21_X1
X$81773 \$34489 \$35094 NWELL PWELL BULK INV_X1
X$81797 M1_AXI_WID[1] \$34505 NWELL PWELL BULK CLKBUF_X2
X$81821 \$38481 \$34520 \$38973 \$38113 NWELL PWELL BULK MUX2_X1
X$81823 \$38489 \$34520 \$38921 \$38918 NWELL PWELL BULK MUX2_X1
X$81825 \$38958 \$34520 \$38957 \$38955 NWELL PWELL BULK MUX2_X1
X$81827 \$36633 \$34520 \$36179 \$37198 NWELL PWELL BULK MUX2_X1
X$81830 \$34833 \$34520 \$34525 \$34834 NWELL PWELL BULK MUX2_X1
X$81833 \$35367 \$34520 \$35369 \$34890 NWELL PWELL BULK MUX2_X1
X$81836 \$42702 \$34520 \$42945 \$42695 NWELL PWELL BULK MUX2_X1
X$81839 \$42343 \$34520 \$41570 \$42691 NWELL PWELL BULK MUX2_X1
X$81841 \$43369 \$34520 \$43015 \$42957 NWELL PWELL BULK MUX2_X1
X$81844 \$41648 \$34520 \$41574 \$42005 NWELL PWELL BULK MUX2_X1
X$81846 \$36749 \$34520 \$36170 \$36171 NWELL PWELL BULK MUX2_X1
X$81849 \$36776 \$34520 \$36167 \$36760 NWELL PWELL BULK MUX2_X1
X$81852 \$37233 \$34520 \$38023 \$37870 NWELL PWELL BULK MUX2_X1
X$81855 \$43088 \$34520 \$42943 \$43080 NWELL PWELL BULK MUX2_X1
X$81857 \$42594 \$34520 \$42244 \$42703 NWELL PWELL BULK MUX2_X1
X$81861 \$40413 \$34520 \$40960 \$40236 NWELL PWELL BULK MUX2_X1
X$81863 \$41334 \$34520 \$40395 \$40238 NWELL PWELL BULK MUX2_X1
X$81865 \$39495 \$34520 \$39368 \$40245 NWELL PWELL BULK MUX2_X1
X$81867 \$41240 \$34520 \$41939 \$41979 NWELL PWELL BULK MUX2_X1
X$81869 \$40893 \$34520 \$41294 \$40776 NWELL PWELL BULK MUX2_X1
X$81871 \$37987 \$34520 \$37988 \$37982 NWELL PWELL BULK MUX2_X1
X$81873 \$39889 \$34520 \$40248 \$40353 NWELL PWELL BULK MUX2_X1
X$81876 \$39475 \$34520 \$39474 \$39890 NWELL PWELL BULK MUX2_X1
X$81878 \$40326 \$34520 \$39927 \$40320 NWELL PWELL BULK MUX2_X1
X$81880 \$40865 \$34520 \$40781 \$41270 NWELL PWELL BULK MUX2_X1
X$81882 \$38889 \$34520 \$39429 \$39431 NWELL PWELL BULK MUX2_X1
X$81885 \$42955 \$34520 \$43028 \$43019 NWELL PWELL BULK MUX2_X1
X$81887 \$41938 \$34520 \$40783 \$41644 NWELL PWELL BULK MUX2_X1
X$81890 \$36236 \$34520 \$34823 \$34922 NWELL PWELL BULK MUX2_X1
X$81893 \$37549 \$34520 \$37933 \$37950 NWELL PWELL BULK MUX2_X1
X$81895 \$36631 \$34520 \$36704 \$37206 NWELL PWELL BULK MUX2_X1
X$81898 \$36722 \$34520 \$36175 \$36629 NWELL PWELL BULK MUX2_X1
X$81900 \$38011 \$34520 \$38004 \$38007 NWELL PWELL BULK MUX2_X1
X$81903 \$34826 \$34520 \$34827 \$34906 NWELL PWELL BULK MUX2_X1
X$81906 \$38075 \$34520 \$37158 \$38485 NWELL PWELL BULK MUX2_X1
X$81908 \$38132 \$34520 \$37156 \$37859 NWELL PWELL BULK MUX2_X1
X$81951 M1_AXI_WDATA[10] \$34523 NWELL PWELL BULK BUF_X1
X$81973 \$42998 \$34529 \$42959 \$43000 NWELL PWELL BULK MUX2_X1
X$81975 \$34529 \$48303 \$48686 NWELL PWELL BULK NOR2_X1
X$81978 \$34529 \$52170 \$52598 NWELL PWELL BULK NOR2_X1
X$81981 \$52598 \$52597 \$34529 \$52169 NWELL PWELL BULK AOI21_X1
X$81984 \$49242 \$49911 \$34529 \$49938 NWELL PWELL BULK AOI21_X1
X$81986 \$48686 \$47942 \$34529 \$48760 NWELL PWELL BULK AOI21_X1
X$81988 \$34529 \$49238 \$49242 NWELL PWELL BULK NOR2_X1
X$81991 \$52964 \$52607 \$34529 \$52962 NWELL PWELL BULK AOI21_X1
X$81993 \$34529 \$52605 \$52964 NWELL PWELL BULK NOR2_X1
X$81996 \$34529 \$51687 \$51738 NWELL PWELL BULK NOR2_X1
X$81998 \$51738 \$50941 \$34529 \$51740 NWELL PWELL BULK AOI21_X1
X$82001 \$34529 \$56749 \$56785 NWELL PWELL BULK NOR2_X1
X$82003 \$56785 \$57380 \$34529 \$56789 NWELL PWELL BULK AOI21_X1
X$82005 \$54594 \$54135 \$34529 \$55193 NWELL PWELL BULK AOI21_X1
X$82007 \$55148 \$54142 \$34529 \$55176 NWELL PWELL BULK AOI21_X1
X$82010 \$34529 \$54649 \$54594 NWELL PWELL BULK NOR2_X1
X$82012 \$34529 \$55551 \$55148 NWELL PWELL BULK NOR2_X1
X$82015 \$34529 \$61251 \$61250 NWELL PWELL BULK NOR2_X1
X$82017 \$61250 \$62475 \$34529 \$61973 NWELL PWELL BULK AOI21_X1
X$82019 \$62442 \$62292 \$34529 \$61909 NWELL PWELL BULK AOI21_X1
X$82021 \$61355 \$61351 \$34529 \$61366 NWELL PWELL BULK AOI21_X1
X$82023 \$34529 \$61912 \$62442 NWELL PWELL BULK NOR2_X1
X$82026 \$59575 \$59499 \$34529 \$60107 NWELL PWELL BULK AOI21_X1
X$82029 \$34529 \$59503 \$59575 NWELL PWELL BULK NOR2_X1
X$82032 \$34529 \$60804 \$61355 NWELL PWELL BULK NOR2_X1
X$82036 \$35344 \$34838 \$34529 \$34541 NWELL PWELL BULK AOI21_X1
X$82038 \$34529 \$34840 \$35344 NWELL PWELL BULK NOR2_X1
X$82040 \$41624 \$40252 \$34529 \$41940 NWELL PWELL BULK AOI21_X1
X$82042 \$34529 \$41578 \$41624 NWELL PWELL BULK NOR2_X1
X$82045 \$38896 \$34529 \$37876 \$39406 NWELL PWELL BULK MUX2_X1
X$82074 \$34828 S0_AXI_WDATA[22] NWELL PWELL BULK BUF_X1
X$82176 \$34614 \$37994 NWELL PWELL BULK INV_X1
X$82190 \$41117 \$40633 \$41808 \$34619 \$41900 NWELL PWELL BULK AND4_X1
X$82229 \$44808 \$34679 \$44162 \$44501 NWELL PWELL BULK MUX2_X1
X$82232 \$51695 \$34679 \$51270 \$51269 NWELL PWELL BULK MUX2_X1
X$82236 \$53875 \$34679 \$52071 \$53162 NWELL PWELL BULK MUX2_X1
X$82239 \$51112 \$34679 \$50163 \$50768 NWELL PWELL BULK MUX2_X1
X$82241 \$51161 \$34679 \$50178 \$50869 NWELL PWELL BULK MUX2_X1
X$82246 \$51596 \$34679 \$51308 \$51897 NWELL PWELL BULK MUX2_X1
X$82248 \$50099 \$34679 \$49569 \$50103 NWELL PWELL BULK MUX2_X1
X$82250 \$50160 \$34679 \$50755 \$50400 NWELL PWELL BULK MUX2_X1
X$82254 \$53177 \$34679 \$53166 \$53476 NWELL PWELL BULK MUX2_X1
X$82256 \$51826 \$34679 \$50552 \$51825 NWELL PWELL BULK MUX2_X1
X$82258 \$53303 \$34679 \$52849 \$52850 NWELL PWELL BULK MUX2_X1
X$82261 \$49239 \$34679 \$45365 \$49232 NWELL PWELL BULK MUX2_X1
X$82263 \$50246 \$34679 \$49819 \$50630 NWELL PWELL BULK MUX2_X1
X$82266 \$48606 \$34679 \$48219 \$48948 NWELL PWELL BULK MUX2_X1
X$82268 \$53185 \$34679 \$52862 \$53496 NWELL PWELL BULK MUX2_X1
X$82270 \$52461 \$34679 \$51336 \$51625 NWELL PWELL BULK MUX2_X1
X$82272 \$45568 \$34679 \$45262 \$45989 NWELL PWELL BULK MUX2_X1
X$82274 \$42402 \$34679 \$39388 \$42398 NWELL PWELL BULK MUX2_X1
X$82327 \$35328 \$34691 \$35331 \$35664 NWELL PWELL BULK DFF_X1
X$82329 M1_AXI_AWADDR[2] \$34692 NWELL PWELL BULK BUF_X1
X$82363 \$35420 \$36513 \$34706 \$36514 \$37258 NWELL PWELL BULK AOI22_X1
X$82382 \$35219 \$36513 \$36514 \$34721 \$38072 NWELL PWELL BULK AOI22_X2
X$82387 \$34724 \$34725 \$34997 NWELL PWELL BULK NOR2_X2
X$82389 \$47866 \$48064 \$40656 \$34724 NWELL PWELL BULK MUX2_X2
X$82392 \$34724 \$36526 NWELL PWELL BULK INV_X1
X$82397 \$34724 \$36513 \$36045 \$36514 \$36523 NWELL PWELL BULK AOI22_X1
X$82409 \$45664 \$46045 \$40656 \$34725 NWELL PWELL BULK MUX2_X2
X$82414 \$34725 \$36513 \$36514 \$36039 \$38055 NWELL PWELL BULK AOI22_X2
X$82420 \$34725 \$39251 NWELL PWELL BULK INV_X1
X$82438 \$34729 \$36900 \$37096 \$36903 \$36925 NWELL PWELL BULK AOI22_X2
X$82440 \$35019 \$34729 \$35709 \$35028 \$36066 NWELL PWELL BULK NAND4_X2
X$82444 \$35019 \$34729 \$37085 NWELL PWELL BULK NAND2_X1
X$82446 \$36059 \$35952 \$34997 \$34729 NWELL PWELL BULK AND3_X2
X$82461 \$35238 \$35231 \$35709 \$34731 NWELL PWELL BULK NOR3_X2
X$82470 \$36059 \$35952 \$35581 \$37463 \$34735 NWELL PWELL BULK AND4_X2
X$82473 \$34735 \$37775 \$35710 \$37785 \$37706 NWELL PWELL BULK OAI211_X4
X$82476 \$35708 \$35705 \$34735 \$35022 \$34741 NWELL PWELL BULK AOI211_X2
X$82491 \$34746 \$35248 NWELL PWELL BULK INV_X1
X$82494 \$35238 \$35041 \$34746 \$36448 NWELL PWELL BULK NAND3_X1
X$82507 \$34747 \$35965 \$35953 NWELL PWELL BULK OR2_X1
X$82520 \$34750 \$36004 \$35709 \$35247 NWELL PWELL BULK AOI21_X1
X$82523 \$35098 \$35733 \$34750 \$36445 NWELL PWELL BULK OAI21_X1
X$82528 \$35955 \$34750 \$34752 NWELL PWELL BULK NOR2_X1
X$82586 \$34766 \$35930 NWELL PWELL BULK INV_X1
X$82589 \$34768 \$34769 \$34771 \$36426 \$35624 NWELL PWELL BULK OAI22_X4
X$82597 \$37115 \$36581 \$34771 \$36576 NWELL PWELL BULK NAND3_X1
X$82604 \$35636 \$35261 \$35622 \$36572 \$34771 NWELL PWELL BULK OAI22_X4
X$82607 \$36103 \$34771 NWELL PWELL BULK INV_X2
X$82635 \$36109 \$35267 \$36386 \$34780 NWELL PWELL BULK MUX2_X1
X$82643 \$34781 \$34782 \$35268 NWELL PWELL BULK NOR2_X1
X$82646 \$35272 \$34782 \$35273 \$35274 NWELL PWELL BULK MUX2_X1
X$82649 \$34782 \$34785 \$34784 NWELL PWELL BULK NOR2_X1
X$82672 M1_AXI_WLAST \$34800 NWELL PWELL BULK CLKBUF_X2
X$82718 \$37965 \$37547 \$34838 NWELL PWELL BULK NOR2_X2
X$82763 M0_AXI_AWADDR[31] \$34902 NWELL PWELL BULK BUF_X1
X$82777 \$34903 \$35401 \$55198 NWELL PWELL BULK NOR2_X1
X$82780 \$34903 \$43769 \$58976 NWELL PWELL BULK NOR2_X1
X$82783 \$56425 \$42756 \$55904 \$43440 \$43349 \$34903 \$59494 NWELL PWELL
+ BULK OAI222_X2
X$82797 \$55438 \$55773 \$50040 \$34917 NWELL PWELL BULK MUX2_X2
X$82802 \$34917 \$38609 NWELL PWELL BULK INV_X1
X$82830 \$48185 \$48186 \$40656 \$34931 NWELL PWELL BULK MUX2_X2
X$82832 \$36037 \$35420 \$35866 \$34931 \$35581 NWELL PWELL BULK NOR4_X4
X$82835 \$34931 \$36513 \$35682 \$36514 \$37452 NWELL PWELL BULK AOI22_X1
X$82839 \$34931 \$39038 NWELL PWELL BULK INV_X1
X$82850 \$35231 \$35464 \$35873 \$34934 \$35219 NWELL PWELL BULK OR4_X4
X$82852 \$50388 \$50043 \$50040 \$34934 NWELL PWELL BULK MUX2_X2
X$82855 \$34934 \$39994 NWELL PWELL BULK INV_X1
X$82861 \$35219 \$34934 \$35873 \$35464 \$35041 NWELL PWELL BULK NOR4_X4
X$82886 \$37062 \$37452 \$37065 \$34944 \$37650 NWELL PWELL BULK OAI22_X2
X$82925 \$34977 \$52356 NWELL PWELL BULK INV_X1
X$82928 \$73377 \$73660 \$50040 \$34977 NWELL PWELL BULK MUX2_X2
X$82934 \$34977 \$35503 \$36534 \$35695 \$36059 NWELL PWELL BULK NOR4_X4
X$82999 \$35238 \$35231 \$35028 NWELL PWELL BULK NOR2_X1
X$83024 \$36065 \$36392 \$36540 \$35038 \$35236 NWELL PWELL BULK AND4_X1
X$83031 \$35238 \$35041 \$36080 NWELL PWELL BULK NAND2_X2
X$83033 \$35238 \$35041 \$35709 \$36552 NWELL PWELL BULK NAND3_X1
X$83043 \$35994 \$35041 \$35718 NWELL PWELL BULK NAND2_X1
X$83079 \$37062 \$38148 \$37065 \$35068 \$38704 NWELL PWELL BULK OAI22_X2
X$83105 \$35244 \$35609 \$35098 \$35247 \$35965 NWELL PWELL BULK AOI22_X1
X$83112 \$38417 \$35112 \$37426 \$37110 NWELL PWELL BULK AOI21_X2
X$83115 \$38417 \$36081 \$35112 \$37426 \$38220 NWELL PWELL BULK AOI211_X2
X$83117 \$35112 \$37426 \$37106 \$37675 NWELL PWELL BULK AND3_X1
X$83119 \$40088 \$35112 \$40082 \$39704 NWELL PWELL BULK AOI21_X1
X$83144 \$38796 \$39285 \$35140 NWELL PWELL BULK NOR2_X4
X$83146 \$38355 \$35140 \$36514 NWELL PWELL BULK NOR2_X4
X$83149 \$47155 \$38355 \$35140 \$50653 NWELL PWELL BULK NOR3_X1
X$83151 \$47511 \$38355 \$35140 \$49962 NWELL PWELL BULK NOR3_X1
X$83153 \$49850 \$38803 \$35140 \$52103 NWELL PWELL BULK NOR3_X1
X$83156 \$47532 \$38803 \$35140 \$50865 NWELL PWELL BULK NOR3_X1
X$83160 \$49374 \$38803 \$35140 \$52110 NWELL PWELL BULK NOR3_X1
X$83164 \$41142 \$38355 \$35140 \$46422 NWELL PWELL BULK NOR3_X1
X$83168 \$50323 \$38355 \$35140 \$51786 NWELL PWELL BULK NOR3_X1
X$83170 \$49473 \$38355 \$35140 \$52086 NWELL PWELL BULK NOR3_X1
X$83172 \$47698 \$38355 \$35140 \$52288 NWELL PWELL BULK NOR3_X1
X$83175 \$39954 \$38355 \$35140 \$51023 NWELL PWELL BULK NOR3_X1
X$83178 \$50537 \$38355 \$35140 \$52235 NWELL PWELL BULK NOR3_X1
X$83181 \$48325 \$38355 \$35140 \$52628 NWELL PWELL BULK NOR3_X1
X$83183 \$49284 \$38355 \$35140 \$51545 NWELL PWELL BULK NOR3_X1
X$83187 \$37726 \$35140 \$37062 \$37065 NWELL PWELL BULK NAND3_X4
X$83191 \$38420 \$38823 \$35140 \$38818 NWELL PWELL BULK OAI21_X1
X$83197 \$43949 \$38803 \$35140 \$46678 NWELL PWELL BULK NOR3_X1
X$83199 \$47436 \$38803 \$35140 \$52777 NWELL PWELL BULK NOR3_X1
X$83201 \$49137 \$38803 \$35140 \$49774 NWELL PWELL BULK NOR3_X1
X$83208 \$48206 \$38803 \$35140 \$52456 NWELL PWELL BULK NOR3_X1
X$83211 \$46444 \$38803 \$35140 \$46751 NWELL PWELL BULK NOR3_X1
X$83216 \$40122 \$38355 \$35140 \$40847 NWELL PWELL BULK NOR3_X1
X$83219 \$37721 \$38355 \$35140 \$38725 NWELL PWELL BULK NOR3_X1
X$83295 \$40542 \$35151 \$39388 \$41038 NWELL PWELL BULK MUX2_X1
X$83299 \$51119 \$35151 \$50163 \$50770 NWELL PWELL BULK MUX2_X1
X$83301 \$51508 \$35151 \$50755 \$51511 NWELL PWELL BULK MUX2_X1
X$83304 \$50091 \$35151 \$49569 \$50094 NWELL PWELL BULK MUX2_X1
X$83306 \$53950 \$35151 \$52862 \$53188 NWELL PWELL BULK MUX2_X1
X$83309 \$53468 \$35151 \$51308 \$53466 NWELL PWELL BULK MUX2_X1
X$83311 \$45529 \$35151 \$44162 \$45528 NWELL PWELL BULK MUX2_X1
X$83315 \$54472 \$35151 \$53166 \$54024 NWELL PWELL BULK MUX2_X1
X$83317 \$53375 \$35151 \$52071 \$53376 NWELL PWELL BULK MUX2_X1
X$83319 \$52694 \$35151 \$50552 \$52311 NWELL PWELL BULK MUX2_X1
X$83321 \$48983 \$35151 \$48219 \$48615 NWELL PWELL BULK MUX2_X1
X$83323 \$47063 \$35151 \$45262 \$47061 NWELL PWELL BULK MUX2_X1
X$83325 \$52017 \$35151 \$51336 \$52015 NWELL PWELL BULK MUX2_X1
X$83327 \$51173 \$35151 \$50178 \$51168 NWELL PWELL BULK MUX2_X1
X$83390 M1_AXI_AWVALID \$35322 NWELL PWELL BULK BUF_X2
X$83395 M1_AXI_AWADDR[5] \$35194 NWELL PWELL BULK BUF_X1
X$83414 M0_AXI_AWADDR[23] \$35205 NWELL PWELL BULK BUF_X1
X$83445 \$35219 \$38772 NWELL PWELL BULK INV_X1
X$83447 \$42381 \$42065 \$40656 \$35219 NWELL PWELL BULK MUX2_X2
X$83477 \$35236 \$37465 \$38133 NWELL PWELL BULK NAND2_X1
X$83483 \$35719 \$35237 \$35717 NWELL PWELL BULK AND2_X1
X$83485 \$35237 \$35719 \$36000 NWELL PWELL BULK NAND2_X1
X$83491 \$41158 \$41502 \$40656 \$35238 NWELL PWELL BULK MUX2_X2
X$83517 \$36561 \$35244 \$37393 NWELL PWELL BULK NAND2_X1
X$83522 \$36448 \$35725 \$35244 \$36454 NWELL PWELL BULK OAI21_X1
X$83548 \$35249 \$35250 \$36945 NWELL PWELL BULK NOR2_X1
X$83553 \$35250 \$36097 \$36099 \$37415 NWELL PWELL BULK AOI21_X1
X$83555 \$35250 \$35259 \$37402 NWELL PWELL BULK AND2_X1
X$83557 \$35259 \$35250 \$36561 NWELL PWELL BULK NAND2_X1
X$83559 \$35257 \$35250 \$36457 NWELL PWELL BULK NAND2_X1
X$83561 \$35250 \$35257 \$36566 NWELL PWELL BULK AND2_X1
X$83566 \$35250 \$36081 NWELL PWELL BULK INV_X2
X$83569 \$35250 \$36080 \$35725 \$36469 NWELL PWELL BULK OR3_X1
X$83571 \$35725 \$36080 \$35250 \$37479 NWELL PWELL BULK NOR3_X2
X$83580 \$35251 \$35735 \$35258 \$36948 NWELL PWELL BULK OAI21_X1
X$83582 \$35251 \$36445 \$35737 \$35938 NWELL PWELL BULK OAI21_X1
X$83585 \$35953 \$35251 \$35657 \$35736 NWELL PWELL BULK OAI21_X1
X$83593 \$35256 \$35259 \$35737 NWELL PWELL BULK NAND2_X1
X$83595 \$37675 \$37486 \$38221 \$38220 \$35256 NWELL PWELL BULK OR4_X1
X$83598 \$35256 \$35257 \$35258 NWELL PWELL BULK NAND2_X1
X$83600 \$35256 \$35942 \$35657 NWELL PWELL BULK NAND2_X1
X$83630 \$35262 \$36410 NWELL PWELL BULK INV_X1
X$83633 \$35263 \$36400 NWELL PWELL BULK INV_X1
X$83640 \$38281 \$35267 \$38282 \$38280 NWELL PWELL BULK MUX2_X1
X$83642 \$38282 \$35267 \$37124 \$36585 NWELL PWELL BULK MUX2_X1
X$83646 \$35267 \$35907 NWELL PWELL BULK INV_X1
X$83649 \$36588 \$35267 \$37035 \$36113 NWELL PWELL BULK MUX2_X1
X$83660 \$35269 \$35268 \$35739 NWELL PWELL BULK XNOR2_X1
X$83683 \$35746 \$35749 \$35281 NWELL PWELL BULK NAND2_X1
X$83698 \$35297 \$43769 \$47002 NWELL PWELL BULK NOR2_X1
X$83700 \$45726 \$42756 \$45307 \$43440 \$43349 \$35297 \$45882 NWELL PWELL
+ BULK OAI222_X2
X$83704 \$35297 \$35401 \$35771 NWELL PWELL BULK NOR2_X1
X$83727 \$35312 \$35401 \$54584 NWELL PWELL BULK NOR2_X1
X$83730 \$54582 \$42756 \$54125 \$43440 \$43349 \$35312 \$51814 NWELL PWELL
+ BULK OAI222_X2
X$83733 \$35312 \$43769 \$54585 NWELL PWELL BULK NOR2_X1
X$83782 \$35350 \$38363 \$37685 \$38731 NWELL PWELL BULK NOR3_X1
X$83784 \$35350 \$35355 NWELL PWELL BULK INV_X1
X$83787 \$37065 \$35350 \$38541 \$39421 NWELL PWELL BULK OAI21_X1
X$83850 \$42076 \$41042 \$42074 \$35401 NWELL PWELL BULK NAND3_X4
X$83854 \$41220 \$35401 \$50403 NWELL PWELL BULK NOR2_X1
X$83856 \$38104 \$35401 \$55532 NWELL PWELL BULK NOR2_X1
X$83860 \$43116 \$35401 \$51656 NWELL PWELL BULK NOR2_X1
X$83863 \$37274 \$35401 \$51178 NWELL PWELL BULK NOR2_X1
X$83865 \$40510 \$35401 \$60506 NWELL PWELL BULK NOR2_X1
X$83867 \$38198 \$35401 \$62994 NWELL PWELL BULK NOR2_X1
X$83870 \$41725 \$35401 \$56402 NWELL PWELL BULK NOR2_X1
X$83873 \$41698 \$35401 \$60745 NWELL PWELL BULK NOR2_X1
X$83877 \$38159 \$35401 \$63154 NWELL PWELL BULK NOR2_X1
X$83880 \$40993 \$35401 \$57749 NWELL PWELL BULK NOR2_X1
X$83882 \$36746 \$35401 \$50354 NWELL PWELL BULK NOR2_X1
X$83886 \$36319 \$35401 \$44948 NWELL PWELL BULK NOR2_X1
X$83892 \$43012 \$35401 \$58155 NWELL PWELL BULK NOR2_X1
X$83896 \$43069 \$35401 \$57359 NWELL PWELL BULK NOR2_X1
X$83898 \$43076 \$35401 \$62856 NWELL PWELL BULK NOR2_X1
X$83900 \$43095 \$35401 \$63482 NWELL PWELL BULK NOR2_X1
X$83902 \$41646 \$35401 \$55961 NWELL PWELL BULK NOR2_X1
X$83906 \$40318 \$35401 \$55906 NWELL PWELL BULK NOR2_X1
X$83908 \$39941 \$35401 \$63495 NWELL PWELL BULK NOR2_X1
X$83911 \$40883 \$35401 \$64094 NWELL PWELL BULK NOR2_X1
X$83914 \$38917 \$35401 \$60447 NWELL PWELL BULK NOR2_X1
X$83916 \$41576 \$35401 \$61258 NWELL PWELL BULK NOR2_X1
X$83920 \$42583 \$35401 \$43980 NWELL PWELL BULK NOR2_X1
X$83926 \$38879 \$35401 \$39517 NWELL PWELL BULK NOR2_X1
X$83928 \$38488 \$35401 \$38940 NWELL PWELL BULK NOR2_X1
X$83930 \$36689 \$35401 \$42604 NWELL PWELL BULK NOR2_X1
X$83932 \$40298 \$35401 \$37876 NWELL PWELL BULK NAND2_X1
X$83936 \$37546 \$35401 \$37547 NWELL PWELL BULK NOR2_X1
X$83938 \$35793 \$35401 \$36220 NWELL PWELL BULK NOR2_X1
X$83944 \$36157 \$35401 \$36617 NWELL PWELL BULK NOR2_X1
X$83947 \$35442 \$35401 \$35779 NWELL PWELL BULK NOR2_X1
X$84040 \$35417 \$36524 \$39998 \$37072 \$36275 NWELL PWELL BULK AOI22_X4
X$84046 \$35865 \$36513 \$36514 \$35417 \$40372 NWELL PWELL BULK AOI22_X2
X$84060 \$53999 \$54703 \$50040 \$35420 NWELL PWELL BULK MUX2_X2
X$84068 \$35420 \$39001 NWELL PWELL BULK INV_X1
X$84080 \$42944 \$44637 \$44636 \$40298 \$35422 NWELL PWELL BULK OAI22_X2
X$84091 \$35442 \$43769 \$44106 NWELL PWELL BULK NOR2_X1
X$84093 \$43588 \$42756 \$43589 \$43440 \$43349 \$35442 \$40764 NWELL PWELL
+ BULK OAI222_X2
X$84100 \$42944 \$43588 \$43589 \$40298 \$35456 NWELL PWELL BULK OAI22_X2
X$84109 M1_AXI_WDATA[27] \$35462 NWELL PWELL BULK BUF_X1
X$84123 \$53431 \$54006 \$50040 \$35464 NWELL PWELL BULK MUX2_X2
X$84130 \$35464 \$39050 NWELL PWELL BULK INV_X1
X$84133 \$35464 \$36513 \$36514 \$35465 \$39253 NWELL PWELL BULK AOI22_X2
X$84191 \$35503 \$51091 NWELL PWELL BULK INV_X1
X$84194 \$73640 \$73370 \$50040 \$35503 NWELL PWELL BULK MUX2_X2
X$84198 \$35503 \$36513 \$36514 \$35915 \$39568 NWELL PWELL BULK AOI22_X2
X$84243 \$35746 \$35885 \$35549 NWELL PWELL BULK NAND2_X1
X$84252 \$35746 \$36118 \$35558 NWELL PWELL BULK NAND2_X1
X$84274 \$35581 \$36380 \$36059 \$35952 \$35725 NWELL PWELL BULK NAND4_X4
X$84315 \$37110 \$37492 \$38359 \$35656 \$38435 NWELL PWELL BULK OAI22_X1
X$84318 \$37410 \$36581 \$37726 \$35656 \$39735 NWELL PWELL BULK OAI22_X1
X$84320 \$39694 \$38814 \$35656 NWELL PWELL BULK NAND2_X2
X$84347 \$39211 \$39774 \$39913 \$35664 NWELL PWELL BULK DFF_X1
X$84349 \$38722 \$38509 \$38514 \$35664 NWELL PWELL BULK DFF_X1
X$84351 \$38720 \$38899 \$38718 \$35664 NWELL PWELL BULK DFF_X1
X$84354 \$40268 \$40262 \$40118 \$35664 NWELL PWELL BULK DFF_X1
X$84356 \$41131 \$41247 \$41588 \$35664 NWELL PWELL BULK DFF_X1
X$84359 \$39394 \$39393 \$39390 \$35664 NWELL PWELL BULK DFF_X1
X$84361 \$41132 \$41834 \$41949 \$35664 NWELL PWELL BULK DFF_X1
X$84363 \$42501 \$42848 \$42970 \$35664 NWELL PWELL BULK DFF_X1
X$84366 \$42500 \$42845 \$42968 \$35664 NWELL PWELL BULK DFF_X1
X$84368 \$40270 \$40654 \$40653 \$35664 NWELL PWELL BULK DFF_X1
X$84371 \$41475 \$41595 \$41472 \$35664 NWELL PWELL BULK DFF_X1
X$84373 \$41476 \$41962 \$41952 \$35664 NWELL PWELL BULK DFF_X1
X$84375 \$42626 \$42988 \$42974 \$35664 NWELL PWELL BULK DFF_X1
X$84378 \$36230 \$35825 \$35829 \$35664 NWELL PWELL BULK DFF_X1
X$84380 \$36489 \$36488 \$36678 \$35664 NWELL PWELL BULK DFF_X1
X$84384 \$37209 \$37937 \$37581 \$35664 NWELL PWELL BULK DFF_X1
X$84387 \$37717 \$37430 \$37429 \$35664 NWELL PWELL BULK DFF_X1
X$84389 \$36021 \$36670 \$36661 \$35664 NWELL PWELL BULK DFF_X1
X$84391 \$36481 \$36652 \$36651 \$35664 NWELL PWELL BULK DFF_X1
X$84394 \$36206 \$36020 \$36202 \$35664 NWELL PWELL BULK DFF_X1
X$84396 \$37058 \$37191 \$37194 \$35664 NWELL PWELL BULK DFF_X1
X$84399 \$I176857 \$37219 \$37434 \$35664 NWELL PWELL BULK DFF_X1
X$84401 \$38737 \$38549 \$38361 \$35664 NWELL PWELL BULK DFF_X1
X$84403 \$39220 \$40321 \$39948 \$35664 NWELL PWELL BULK DFF_X1
X$84406 \$43644 \$44024 \$44014 \$35664 NWELL PWELL BULK DFF_X1
X$84409 \$44030 \$43651 \$43645 \$35664 NWELL PWELL BULK DFF_X1
X$84412 \$I174499 \$37437 \$37951 \$35664 NWELL PWELL BULK DFF_X1
X$84415 \$42634 \$42630 \$42627 \$35664 NWELL PWELL BULK DFF_X1
X$84472 \$51867 \$51862 \$50040 \$35695 NWELL PWELL BULK MUX2_X2
X$84477 \$35695 \$39257 NWELL PWELL BULK INV_X1
X$84486 \$37062 \$37457 \$37065 \$38385 \$35698 NWELL PWELL BULK OAI22_X4
X$84500 \$37473 \$39271 \$38397 \$35705 \$38797 NWELL PWELL BULK NOR4_X2
X$84502 \$35705 \$37473 \$39817 NWELL PWELL BULK NOR2_X1
X$84525 \$37480 \$37701 \$37755 \$38658 \$35709 NWELL PWELL BULK OAI22_X4
X$84590 \$37062 \$37476 \$37065 \$35722 \$38172 NWELL PWELL BULK OAI22_X2
X$84608 \$38398 \$35725 \$39120 \$38794 NWELL PWELL BULK OAI21_X1
X$84619 \$37691 \$35729 \$37404 \$37688 \$36561 NWELL PWELL BULK AOI22_X4
X$84642 \$35743 \$37813 NWELL PWELL BULK INV_X2
X$84644 \$35743 \$35889 \$36374 NWELL PWELL BULK XNOR2_X1
X$84658 \$35746 \$36594 \$37053 NWELL PWELL BULK NAND2_X1
X$84662 \$35746 \$36125 \$35881 NWELL PWELL BULK NAND2_X1
X$84665 \$35746 \$37020 \$37015 NWELL PWELL BULK NAND2_X1
X$84668 \$35746 \$36126 \$35753 NWELL PWELL BULK NAND2_X1
X$84671 \$35746 \$35752 \$35751 NWELL PWELL BULK NAND2_X1
X$84674 \$35746 \$36600 \$36364 NWELL PWELL BULK NAND2_X1
X$84683 \$35749 \$35885 \$36597 \$36599 NWELL PWELL BULK AND3_X1
X$84686 \$35749 \$37047 \$38309 NWELL PWELL BULK XNOR2_X1
X$84688 \$35749 \$37830 \$38449 NWELL PWELL BULK XNOR2_X1
X$84697 \$35752 \$38456 \$39068 NWELL PWELL BULK XNOR2_X1
X$84699 \$35752 \$36600 \$36599 \$37137 NWELL PWELL BULK AND3_X1
X$84701 \$35752 \$37523 \$38277 NWELL PWELL BULK XNOR2_X1
X$84725 \$36831 \$36617 \$35780 NWELL PWELL BULK NOR2_X1
X$84747 M1_AXI_WDATA[5] \$35788 NWELL PWELL BULK BUF_X1
X$84762 \$35792 S0_AXI_WDATA[27] NWELL PWELL BULK BUF_X1
X$84766 \$43613 \$42756 \$43674 \$43440 \$43349 \$35793 \$43600 NWELL PWELL
+ BULK OAI222_X2
X$84769 \$35793 \$43769 \$44043 NWELL PWELL BULK NOR2_X1
X$84815 \$75296 \$75533 \$50040 \$35865 NWELL PWELL BULK MUX2_X2
X$84819 \$35865 \$49476 NWELL PWELL BULK INV_X1
X$84840 \$72734 \$72533 \$50040 \$35866 NWELL PWELL BULK MUX2_X2
X$84842 \$35866 \$50363 NWELL PWELL BULK INV_X1
X$84866 \$44445 \$45109 \$40656 \$35873 NWELL PWELL BULK MUX2_X2
X$84869 \$35873 \$38029 NWELL PWELL BULK INV_X1
X$84900 \$35885 \$36597 \$37368 \$37047 NWELL PWELL BULK HA_X1
X$84903 \$35885 \$37522 \$37133 NWELL PWELL BULK XOR2_X1
X$84939 \$36400 \$37012 \$36404 \$35921 NWELL PWELL BULK OAI21_X1
X$84964 \$36534 \$36513 \$36514 \$35943 \$40432 NWELL PWELL BULK AOI22_X2
X$85039 \$52327 \$51847 \$50040 \$36037 NWELL PWELL BULK MUX2_X2
X$85046 \$36037 \$39799 NWELL PWELL BULK INV_X1
X$85049 \$36037 \$36513 \$36046 \$36514 \$40935 NWELL PWELL BULK AOI22_X1
X$85109 \$36050 \$39254 NWELL PWELL BULK INV_X1
X$85113 \$42348 \$42038 \$40656 \$36050 NWELL PWELL BULK MUX2_X2
X$85135 \$37369 \$36065 \$36392 \$36540 \$36553 NWELL PWELL BULK AND4_X2
X$85152 \$36066 \$39808 \$39806 \$39811 NWELL PWELL BULK NOR3_X1
X$85154 \$40066 \$40070 \$36066 \$40072 NWELL PWELL BULK OAI21_X1
X$85156 \$36066 \$38397 \$39815 NWELL PWELL BULK NAND2_X1
X$85158 \$40709 \$36066 \$40706 \$40163 NWELL PWELL BULK AND3_X1
X$85171 \$36077 \$37470 \$36843 \$37380 NWELL PWELL BULK NOR3_X2
X$85177 \$36078 \$36945 \$37480 \$36469 \$36457 NWELL PWELL BULK AOI22_X4
X$85193 \$36081 \$36093 \$38410 NWELL PWELL BULK NOR2_X4
X$85198 \$36081 \$37465 \$36553 \$36558 NWELL PWELL BULK AND3_X1
X$85200 \$36553 \$37465 \$36081 \$37688 NWELL PWELL BULK NAND3_X2
X$85218 \$37107 \$37110 \$36097 NWELL PWELL BULK OR2_X1
X$85229 \$37110 \$36568 \$36099 \$37112 NWELL PWELL BULK NOR3_X1
X$85231 \$36103 \$36104 \$36102 \$36101 NWELL PWELL BULK OAI21_X1
X$85233 \$36102 \$36575 \$36101 \$37000 NWELL PWELL BULK OAI21_X1
X$85238 \$37114 \$36102 \$36574 NWELL PWELL BULK NAND2_X1
X$85249 \$37114 \$36581 \$37115 \$36104 NWELL PWELL BULK AOI21_X1
X$85257 \$38272 \$36108 NWELL PWELL BULK INV_X1
X$85275 \$36594 \$36118 \$36593 \$36597 NWELL PWELL BULK HA_X1
X$85277 \$36118 \$37515 \$37367 NWELL PWELL BULK XOR2_X1
X$85287 \$36125 \$38254 \$39667 \$39336 NWELL PWELL BULK HA_X1
X$85290 \$36125 \$38847 \$39332 NWELL PWELL BULK XNOR2_X1
X$85298 \$36126 \$38457 \$38845 NWELL PWELL BULK XNOR2_X1
X$85302 \$36126 \$37137 \$38265 \$37612 NWELL PWELL BULK HA_X1
X$85304 \$37020 \$36126 \$37137 \$38254 NWELL PWELL BULK AND3_X1
X$85313 \$36131 \$36129 NWELL PWELL BULK INV_X2
X$85315 \$36129 \$36961 \$36959 NWELL PWELL BULK NAND2_X1
X$85317 \$36129 \$36132 \$37143 NWELL PWELL BULK NAND2_X1
X$85319 \$36129 \$36604 \$37529 NWELL PWELL BULK NAND2_X1
X$85321 \$36129 \$36341 \$36608 NWELL PWELL BULK NAND2_X1
X$85323 \$36129 \$36986 \$36987 NWELL PWELL BULK NAND2_X1
X$85325 \$38223 \$36129 \$37837 \$I241564 NWELL PWELL BULK HA_X1
X$85327 \$36129 \$36605 \$36984 NWELL PWELL BULK NAND2_X1
X$85339 \$38851 \$36131 \$I241130 \$38572 NWELL PWELL BULK HA_X1
X$85342 \$36131 \$37528 \$37334 NWELL PWELL BULK NAND2_X1
X$85344 \$36131 \$37145 \$37324 NWELL PWELL BULK NAND2_X1
X$85346 \$36131 \$36604 \$36983 NWELL PWELL BULK NAND2_X1
X$85348 \$36131 \$36132 \$36979 NWELL PWELL BULK NAND2_X1
X$85350 \$36131 \$38469 \$39041 NWELL PWELL BULK NAND2_X1
X$85362 \$36604 \$36132 \$36605 \$36961 NWELL PWELL BULK HA_X1
X$85370 \$43966 \$42569 \$44157 \$43898 \$42221 \$43314 \$36138 NWELL PWELL
+ BULK AOI222_X2
X$85372 \$41546 \$42569 \$42423 \$41905 \$42221 \$41746 \$36138 NWELL PWELL
+ BULK AOI222_X2
X$85374 \$36138 \$43975 \$44148 \$43561 \$42569 \$43564 \$42221 NWELL PWELL
+ BULK AOI222_X2
X$85378 \$41412 \$42569 \$42220 \$41552 \$42221 \$41042 \$36138 NWELL PWELL
+ BULK AOI222_X2
X$85380 \$42569 \$43184 \$42088 \$42221 \$43171 \$36138 \$42928 NWELL PWELL
+ BULK AOI222_X2
X$85383 \$36138 \$42798 \$42439 \$44183 NWELL PWELL BULK NAND3_X1
X$85386 \$36138 \$42914 NWELL PWELL BULK INV_X1
X$85417 \$47584 \$42756 \$47586 \$43440 \$43349 \$36157 \$47926 NWELL PWELL
+ BULK OAI222_X2
X$85419 \$36157 \$43769 \$48271 NWELL PWELL BULK NOR2_X1
X$85435 \$I175092 \$36165 \$36164 \$36169 NWELL PWELL BULK DFF_X1
X$85447 \$42945 \$43064 \$43068 \$36169 NWELL PWELL BULK DFF_X1
X$85450 \$I176821 \$41228 \$41299 \$36169 NWELL PWELL BULK DFF_X1
X$85453 \$I176260 \$38949 \$38881 \$36169 NWELL PWELL BULK DFF_X1
X$85455 \$39495 \$38944 \$39502 \$36169 NWELL PWELL BULK DFF_X1
X$85457 \$39368 \$39367 \$40363 \$36169 NWELL PWELL BULK DFF_X1
X$85459 \$I177914 \$39883 \$39881 \$36169 NWELL PWELL BULK DFF_X1
X$85462 \$41294 \$41571 \$41292 \$36169 NWELL PWELL BULK DFF_X1
X$85466 \$I174450 \$42024 \$42333 \$36169 NWELL PWELL BULK DFF_X1
X$85468 \$40893 \$40896 \$40370 \$36169 NWELL PWELL BULK DFF_X1
X$85471 \$I176826 \$39506 \$39509 \$36169 NWELL PWELL BULK DFF_X1
X$85474 \$I176145 \$40772 \$40771 \$36169 NWELL PWELL BULK DFF_X1
X$85477 \$I177897 \$39882 \$40242 \$36169 NWELL PWELL BULK DFF_X1
X$85479 \$38004 \$37993 \$37576 \$36169 NWELL PWELL BULK DFF_X1
X$85482 \$39889 \$39372 \$39482 \$36169 NWELL PWELL BULK DFF_X1
X$85484 \$39475 \$39480 \$38887 \$36169 NWELL PWELL BULK DFF_X1
X$85486 \$I174669 \$43359 \$43403 \$36169 NWELL PWELL BULK DFF_X1
X$85488 \$I176781 \$43744 \$43746 \$36169 NWELL PWELL BULK DFF_X1
X$85490 \$I174506 \$43355 \$43057 \$36169 NWELL PWELL BULK DFF_X1
X$85493 \$I177888 \$42250 \$42680 \$36169 NWELL PWELL BULK DFF_X1
X$85496 \$42343 \$42029 \$42031 \$36169 NWELL PWELL BULK DFF_X1
X$85498 \$41570 \$41673 \$41674 \$36169 NWELL PWELL BULK DFF_X1
X$85500 \$I177791 \$43357 \$43411 \$36169 NWELL PWELL BULK DFF_X1
X$85502 \$I178314 \$38049 \$38062 \$36169 NWELL PWELL BULK DFF_X1
X$85505 \$38011 \$37226 \$37227 \$36169 NWELL PWELL BULK DFF_X1
X$85507 \$37233 \$37166 \$37234 \$36169 NWELL PWELL BULK DFF_X1
X$85509 \$36749 \$36751 \$36767 \$36169 NWELL PWELL BULK DFF_X1
X$85511 \$36170 \$36172 \$36240 \$36169 NWELL PWELL BULK DFF_X1
X$85513 \$38023 \$38031 \$38038 \$36169 NWELL PWELL BULK DFF_X1
X$85517 \$I176802 \$37244 \$37160 \$36169 NWELL PWELL BULK DFF_X1
X$85574 \$36188 \$46090 \$46815 \$46907 NWELL PWELL BULK MUX2_X1
X$85576 \$47598 \$46082 \$36188 \$47258 NWELL PWELL BULK MUX2_X1
X$85578 \$36188 \$46512 \$46102 \$46233 NWELL PWELL BULK MUX2_X1
X$85580 \$36188 \$46524 \$47330 \$47333 NWELL PWELL BULK MUX2_X1
X$85593 \$36199 S0_AXI_WDATA[3] NWELL PWELL BULK BUF_X1
X$85617 \$42944 \$43613 \$43674 \$40298 \$36216 NWELL PWELL BULK OAI22_X2
X$85688 \$36275 \$40376 NWELL PWELL BULK INV_X1
X$85710 \$42944 \$45726 \$45307 \$40298 \$36311 NWELL PWELL BULK OAI22_X2
X$85723 \$36319 \$43769 \$49181 NWELL PWELL BULK NOR2_X1
X$85726 \$48258 \$42756 \$48654 \$43440 \$43349 \$36319 \$53056 NWELL PWELL
+ BULK OAI222_X2
X$85746 \$36341 \$36959 \$36960 NWELL PWELL BULK XNOR2_X1
X$85793 \$36426 \$50089 \$39834 \$47532 \$37129 \$50176 NWELL PWELL BULK
+ OAI221_X2
X$85795 \$36426 \$49739 \$39834 \$49850 \$37129 \$49806 NWELL PWELL BULK
+ OAI221_X2
X$85797 \$36426 \$49500 \$39834 \$49374 \$37129 \$49376 NWELL PWELL BULK
+ OAI221_X2
X$85801 \$36426 \$37812 \$37815 \$37503 NWELL PWELL BULK OR3_X2
X$85804 \$36426 \$37812 \$37811 \$37819 \$37504 \$38313 NWELL PWELL BULK
+ OAI221_X1
X$85807 \$37811 \$36426 \$37812 \$38614 NWELL PWELL BULK OAI21_X2
X$85810 \$36572 \$36426 \$37115 NWELL PWELL BULK NOR2_X1
X$85812 \$36581 \$36426 \$37801 \$39834 NWELL PWELL BULK NAND3_X4
X$85816 \$36426 \$36581 \$38828 NWELL PWELL BULK XNOR2_X1
X$85821 \$49137 \$39834 \$37129 \$36426 \$48218 \$49415 NWELL PWELL BULK
+ OAI221_X1
X$85823 \$48206 \$39834 \$37129 \$36426 \$48524 \$47556 NWELL PWELL BULK
+ OAI221_X1
X$85825 \$47436 \$39834 \$37129 \$36426 \$50105 \$50087 NWELL PWELL BULK
+ OAI221_X1
X$85829 \$36426 \$45565 \$39834 \$43949 \$37129 \$44271 NWELL PWELL BULK
+ OAI221_X2
X$85832 \$46444 \$39834 \$37129 \$36426 \$46454 \$46697 NWELL PWELL BULK
+ OAI221_X1
X$85867 \$50261 \$36433 \$50260 \$49463 NWELL PWELL BULK MUX2_X1
X$85869 \$51716 \$36433 \$51274 \$51280 NWELL PWELL BULK MUX2_X1
X$85871 \$50863 \$36433 \$50861 \$51517 NWELL PWELL BULK MUX2_X1
X$85873 \$50849 \$36433 \$50848 \$51305 NWELL PWELL BULK MUX2_X1
X$85875 \$46019 \$36433 \$45639 \$46418 NWELL PWELL BULK MUX2_X1
X$85878 \$52758 \$36433 \$52875 \$52878 NWELL PWELL BULK MUX2_X1
X$85880 \$48608 \$36433 \$48534 \$49509 NWELL PWELL BULK MUX2_X1
X$85883 \$45258 \$36433 \$45678 \$46367 NWELL PWELL BULK MUX2_X1
X$85886 \$50567 \$36433 \$50873 \$50874 NWELL PWELL BULK MUX2_X1
X$85888 \$50189 \$36433 \$50780 \$51337 NWELL PWELL BULK MUX2_X1
X$85891 \$52536 \$36433 \$53187 \$52885 NWELL PWELL BULK MUX2_X1
X$85893 \$50850 \$36433 \$50849 \$49839 NWELL PWELL BULK OAI21_X2
X$85895 \$50779 \$36433 \$50864 NWELL PWELL BULK NAND2_X1
X$85898 \$50864 \$36433 \$50863 \$49847 NWELL PWELL BULK OAI21_X2
X$85901 \$51111 \$36433 \$50850 NWELL PWELL BULK NAND2_X1
X$85903 \$48735 \$36433 \$48742 \$48556 NWELL PWELL BULK MUX2_X1
X$85905 \$51915 \$36433 \$52099 \$49845 NWELL PWELL BULK OAI21_X2
X$85907 \$52873 \$36433 \$52529 NWELL PWELL BULK NAND2_X1
X$85909 \$52529 \$36433 \$52758 \$49497 NWELL PWELL BULK OAI21_X2
X$85911 \$51600 \$36433 \$51915 NWELL PWELL BULK NAND2_X1
X$85914 \$52099 \$36433 \$52736 \$52523 NWELL PWELL BULK MUX2_X1
X$85916 \$53861 \$36433 \$53385 \$51576 NWELL PWELL BULK MUX2_X1
X$85918 \$51578 \$36433 \$52316 \$51564 NWELL PWELL BULK MUX2_X1
X$85920 \$53327 \$36433 \$53326 \$50814 NWELL PWELL BULK MUX2_X1
X$85922 \$41506 \$36433 \$42091 \$41162 NWELL PWELL BULK OAI21_X2
X$85924 \$42090 \$36433 \$41506 NWELL PWELL BULK NAND2_X1
X$85926 \$50789 \$36433 \$50189 \$48602 NWELL PWELL BULK OAI21_X2
X$85928 \$51203 \$36433 \$50789 NWELL PWELL BULK NAND2_X1
X$85930 \$48613 \$36433 \$49421 NWELL PWELL BULK NAND2_X1
X$85933 \$49421 \$36433 \$48608 \$48604 NWELL PWELL BULK OAI21_X2
X$85936 \$52884 \$36433 \$52534 NWELL PWELL BULK NAND2_X1
X$85938 \$52534 \$36433 \$52536 \$49857 NWELL PWELL BULK OAI21_X2
X$85941 \$50879 \$36433 \$50881 NWELL PWELL BULK NAND2_X1
X$85944 \$50881 \$36433 \$51335 \$49512 NWELL PWELL BULK OAI21_X2
X$85947 \$51335 \$36433 \$51209 \$51624 NWELL PWELL BULK MUX2_X1
X$85950 \$50565 \$36433 \$50185 NWELL PWELL BULK NAND2_X1
X$85952 \$50185 \$36433 \$50567 \$47874 NWELL PWELL BULK OAI21_X2
X$85954 \$46058 \$36433 \$46059 \$46450 NWELL PWELL BULK MUX2_X1
X$85956 \$45993 \$36433 \$46058 \$45260 NWELL PWELL BULK OAI21_X2
X$85959 \$45681 \$36433 \$45993 NWELL PWELL BULK NAND2_X1
X$85962 \$45978 \$36433 \$46053 NWELL PWELL BULK NAND2_X1
X$85966 \$46053 \$36433 \$45258 \$46055 NWELL PWELL BULK OAI21_X2
X$85969 \$42091 \$36433 \$41750 \$41869 NWELL PWELL BULK MUX2_X1
X$86023 \$49134 \$36451 \$49385 \$49379 NWELL PWELL BULK AOI21_X2
X$86025 \$37685 \$36451 NWELL PWELL BULK BUF_X16
X$86027 \$51305 \$38363 \$36451 \$51890 NWELL PWELL BULK NOR3_X1
X$86029 \$51890 \$36451 \$51594 \$52094 NWELL PWELL BULK AOI21_X2
X$86031 \$51624 \$38363 \$36451 \$51613 NWELL PWELL BULK NOR3_X1
X$86033 \$51517 \$38363 \$36451 \$51315 NWELL PWELL BULK NOR3_X1
X$86035 \$51315 \$36451 \$50867 \$51150 NWELL PWELL BULK AOI21_X2
X$86037 \$51613 \$36451 \$51320 \$51953 NWELL PWELL BULK AOI21_X1
X$86039 \$52878 \$38363 \$36451 \$53484 NWELL PWELL BULK NOR3_X1
X$86041 \$52101 \$36451 \$52102 \$52743 NWELL PWELL BULK AOI21_X2
X$86044 \$53484 \$36451 \$53487 \$53100 NWELL PWELL BULK AOI21_X2
X$86046 \$52523 \$38363 \$36451 \$52101 NWELL PWELL BULK NOR3_X1
X$86048 \$36565 \$36451 \$46307 NWELL PWELL BULK XNOR2_X1
X$86051 \$42788 \$36451 \$42531 \$42880 NWELL PWELL BULK AOI21_X2
X$86053 \$41869 \$38363 \$36451 \$42788 NWELL PWELL BULK NOR3_X1
X$86055 \$52883 \$36451 \$52532 \$53124 NWELL PWELL BULK AOI21_X2
X$86057 \$53181 \$36451 \$52530 \$52427 NWELL PWELL BULK AOI21_X2
X$86059 \$52885 \$38363 \$36451 \$53181 NWELL PWELL BULK NOR3_X1
X$86061 \$51615 \$36451 \$50871 \$51966 NWELL PWELL BULK AOI21_X2
X$86064 \$51337 \$38363 \$36451 \$52883 NWELL PWELL BULK NOR3_X1
X$86066 \$49509 \$38363 \$36451 \$49134 NWELL PWELL BULK NOR3_X1
X$86068 \$50874 \$38363 \$36451 \$51615 NWELL PWELL BULK NOR3_X1
X$86071 \$46450 \$38363 \$36451 \$46452 NWELL PWELL BULK NOR3_X1
X$86073 \$47021 \$36451 \$47027 \$46745 NWELL PWELL BULK AOI21_X2
X$86076 \$46367 \$38363 \$36451 \$47021 NWELL PWELL BULK NOR3_X1
X$86079 \$46452 \$36451 \$47037 \$47034 NWELL PWELL BULK AOI21_X1
X$86083 \$40538 \$36451 \$40536 \$39829 NWELL PWELL BULK AOI21_X1
X$86086 \$36565 \$36451 \$38192 \$36943 \$39670 NWELL PWELL BULK OAI211_X2
X$86120 \$36943 \$36929 \$36455 \$36454 NWELL PWELL BULK AOI21_X4
X$86151 M0_AXI_AWADDR[2] \$36480 NWELL PWELL BULK BUF_X1
X$86179 M1_AXI_AWADDR[16] \$36494 NWELL PWELL BULK BUF_X1
X$86198 M0_AXI_AWADDR[19] \$36497 NWELL PWELL BULK BUF_X1
X$86256 \$37726 \$37727 \$36513 NWELL PWELL BULK NOR2_X4
X$86258 \$36513 \$40509 NWELL PWELL BULK INV_X1
X$86324 \$36514 \$40168 NWELL PWELL BULK INV_X1
X$86350 \$37062 \$36523 \$37065 \$37266 \$37664 NWELL PWELL BULK OAI22_X2
X$86378 \$38724 \$37404 \$36524 NWELL PWELL BULK NOR2_X4
X$86403 \$37480 \$37456 \$37755 \$37667 \$36526 NWELL PWELL BULK OAI22_X4
X$86408 \$53906 \$54274 \$50040 \$36534 NWELL PWELL BULK MUX2_X2
X$86414 \$36534 \$40147 NWELL PWELL BULK INV_X1
X$86448 \$36550 \$38122 \$38668 \$38794 \$38796 NWELL PWELL BULK AOI211_X2
X$86451 \$36550 \$39808 \$40458 NWELL PWELL BULK NAND2_X1
X$86453 \$36550 \$40157 \$39271 \$39099 \$40703 NWELL PWELL BULK AOI22_X1
X$86469 \$37380 \$37096 \$37478 \$36553 \$37465 NWELL PWELL BULK AOI22_X4
X$86474 \$37393 \$36925 \$36558 \$37685 \$37402 NWELL PWELL BULK OAI22_X4
X$86481 \$36964 \$36563 \$36565 \$37107 NWELL PWELL BULK AOI21_X1
X$86483 \$36563 \$37481 \$37482 NWELL PWELL BULK NAND2_X4
X$86486 \$36943 \$38410 \$37404 \$36563 NWELL PWELL BULK NOR3_X2
X$86489 \$37478 \$37477 \$37479 \$36565 \$36566 NWELL PWELL BULK OAI22_X4
X$86493 \$36565 \$38724 \$44791 NWELL PWELL BULK XNOR2_X1
X$86516 \$37103 \$36567 \$36964 \$36568 NWELL PWELL BULK OAI21_X1
X$86530 \$36572 \$36581 \$41436 NWELL PWELL BULK NOR2_X4
X$86533 \$37505 \$36572 \$37062 \$39308 \$37490 NWELL PWELL BULK AOI22_X1
X$86537 \$36572 \$36581 \$40200 NWELL PWELL BULK AND2_X4
X$86540 \$36572 \$37801 NWELL PWELL BULK INV_X2
X$86548 \$36574 \$36575 \$36576 \$36580 NWELL PWELL BULK NAND3_X1
X$86551 \$37493 \$37494 \$38249 \$36575 NWELL PWELL BULK OAI21_X1
X$86564 \$38827 \$36581 \$39173 \$37812 NWELL PWELL BULK MUX2_X1
X$86568 \$37493 \$37115 \$37410 \$36581 \$37114 NWELL PWELL BULK OAI22_X1
X$86576 \$36581 \$37796 \$37801 \$37811 NWELL PWELL BULK NAND3_X4
X$86589 \$37023 \$36582 NWELL PWELL BULK INV_X1
X$86592 \$37410 \$36582 \$37498 NWELL PWELL BULK NOR2_X1
X$86610 \$36589 \$37129 \$37503 \$37632 NWELL PWELL BULK OAI21_X1
X$86615 \$36593 \$37629 NWELL PWELL BULK INV_X1
X$86622 \$37825 \$36595 \$38347 \$37827 NWELL PWELL BULK HA_X1
X$86631 \$36600 \$36599 \$37134 \$37523 NWELL PWELL BULK HA_X1
X$86638 \$36600 \$38289 \$37362 NWELL PWELL BULK XOR2_X1
X$86661 M1_AXI_WDATA[11] \$36611 NWELL PWELL BULK BUF_X1
X$86686 M1_AXI_WDATA[30] \$36634 NWELL PWELL BULK BUF_X1
X$86746 \$36689 \$43769 \$47605 NWELL PWELL BULK NOR2_X1
X$86748 \$47603 \$42756 \$47264 \$43440 \$43349 \$36689 \$47668 NWELL PWELL
+ BULK OAI222_X2
X$86764 \$52250 \$37065 \$36694 \$52496 NWELL PWELL BULK OAI21_X2
X$86766 \$36694 \$38363 \$38978 \$51767 NWELL PWELL BULK NOR3_X1
X$86768 \$36694 \$51285 NWELL PWELL BULK INV_X1
X$86798 M1_AXI_WDATA[3] \$36720 NWELL PWELL BULK BUF_X1
X$86816 \$36746 \$43769 \$51056 NWELL PWELL BULK NOR2_X1
X$86819 \$50230 \$42756 \$50231 \$43440 \$43349 \$36746 \$51372 NWELL PWELL
+ BULK OAI222_X2
X$86837 \$37062 \$36752 \$37065 \$37270 \$37448 NWELL PWELL BULK OAI22_X2
X$86868 \$42944 \$47584 \$47586 \$40298 \$36831 NWELL PWELL BULK OAI22_X2
X$86877 \$36843 \$37470 \$37473 NWELL PWELL BULK OR2_X1
X$86882 \$37470 \$36843 \$37469 NWELL PWELL BULK NOR2_X1
X$86903 \$38122 \$36867 \$37469 \$38672 NWELL PWELL BULK AOI21_X1
X$86905 \$36867 \$37469 \$38389 NWELL PWELL BULK NAND2_X1
X$86950 \$36943 \$38410 \$38724 NWELL PWELL BULK NOR2_X4
X$86955 \$38192 \$36943 \$38697 NWELL PWELL BULK NOR2_X1
X$86963 \$36943 \$38410 \$38363 NWELL PWELL BULK OR2_X4
X$86966 \$37481 \$36943 \$39296 NWELL PWELL BULK OR2_X1
X$86969 \$38410 \$36943 \$37681 \$38810 NWELL PWELL BULK OR3_X1
X$87001 \$40548 \$39694 \$36964 NWELL PWELL BULK AND2_X1
X$87008 \$37404 \$36964 \$37492 NWELL PWELL BULK NAND2_X1
X$87014 \$41863 \$36976 \$42083 \$42091 NWELL PWELL BULK MUX2_X1
X$87016 \$50248 \$36976 \$50533 \$50261 NWELL PWELL BULK MUX2_X1
X$87019 \$48554 \$36976 \$48730 \$48735 NWELL PWELL BULK MUX2_X1
X$87021 \$51828 \$36976 \$51067 \$51578 NWELL PWELL BULK MUX2_X1
X$87024 \$51160 \$36976 \$50797 \$50567 NWELL PWELL BULK MUX2_X1
X$87027 \$52370 \$36976 \$52378 \$52099 NWELL PWELL BULK MUX2_X1
X$87029 \$51885 \$36976 \$51593 \$50848 NWELL PWELL BULK MUX2_X1
X$87032 \$54023 \$36976 \$54325 \$52875 NWELL PWELL BULK MUX2_X1
X$87035 \$53481 \$36976 \$54316 \$52758 NWELL PWELL BULK MUX2_X1
X$87038 \$48960 \$36976 \$48961 \$48608 NWELL PWELL BULK MUX2_X1
X$87041 \$47059 \$36976 \$47058 \$46059 NWELL PWELL BULK MUX2_X1
X$87043 \$44506 \$36976 \$44179 \$45258 NWELL PWELL BULK MUX2_X1
X$87046 \$53513 \$36976 \$53516 \$52536 NWELL PWELL BULK MUX2_X1
X$87049 \$50161 \$36976 \$50560 \$50849 NWELL PWELL BULK MUX2_X1
X$87051 \$45638 \$36976 \$46177 \$45639 NWELL PWELL BULK MUX2_X1
X$87053 \$48748 \$36976 \$48171 \$48742 NWELL PWELL BULK MUX2_X1
X$87055 \$51133 \$36976 \$50777 \$50863 NWELL PWELL BULK MUX2_X1
X$87057 \$51124 \$36976 \$50859 \$50861 NWELL PWELL BULK MUX2_X1
X$87059 \$52872 \$36976 \$53473 \$52736 NWELL PWELL BULK MUX2_X1
X$87061 \$46191 \$36976 \$45223 \$46019 NWELL PWELL BULK MUX2_X1
X$87063 \$52313 \$36976 \$51579 \$52316 NWELL PWELL BULK MUX2_X1
X$87065 \$53862 \$36976 \$53160 \$53385 NWELL PWELL BULK MUX2_X1
X$87067 \$54232 \$36976 \$52861 \$53861 NWELL PWELL BULK MUX2_X1
X$87070 \$51718 \$36976 \$52207 \$51274 NWELL PWELL BULK MUX2_X1
X$87073 \$49095 \$36976 \$49461 \$50260 NWELL PWELL BULK MUX2_X1
X$87075 \$51699 \$36976 \$52064 \$51716 NWELL PWELL BULK MUX2_X1
X$87079 \$53318 \$36976 \$53321 \$53327 NWELL PWELL BULK MUX2_X1
X$87081 \$54170 \$36976 \$54177 \$53326 NWELL PWELL BULK MUX2_X1
X$87085 \$48989 \$36976 \$49155 \$48534 NWELL PWELL BULK MUX2_X1
X$87088 \$50090 \$36976 \$50572 \$50780 NWELL PWELL BULK MUX2_X1
X$87090 \$49860 \$36976 \$50787 \$50189 NWELL PWELL BULK MUX2_X1
X$87092 \$53522 \$36976 \$54027 \$53187 NWELL PWELL BULK MUX2_X1
X$87094 \$52018 \$36976 \$50885 \$51209 NWELL PWELL BULK MUX2_X1
X$87096 \$52464 \$36976 \$51626 \$51335 NWELL PWELL BULK MUX2_X1
X$87099 \$51184 \$36976 \$50570 \$50873 NWELL PWELL BULK MUX2_X1
X$87102 \$45685 \$36976 \$46380 \$46058 NWELL PWELL BULK MUX2_X1
X$87104 \$45976 \$36976 \$45259 \$45678 NWELL PWELL BULK MUX2_X1
X$87106 \$40723 \$36976 \$41866 \$41750 NWELL PWELL BULK MUX2_X1
X$87204 \$37020 \$37613 \$37361 NWELL PWELL BULK XOR2_X1
X$87209 \$37020 \$37612 \$38585 NWELL PWELL BULK XNOR2_X1
X$87237 \$39109 \$39110 \$38791 \$37062 NWELL PWELL BULK OR3_X4
X$87239 \$37062 \$37760 \$37065 \$39071 \$39076 NWELL PWELL BULK OAI22_X4
X$87241 \$37062 \$39253 \$37065 \$39564 \$39054 NWELL PWELL BULK OAI22_X4
X$87244 \$37062 \$38587 \$37065 \$37995 \$41671 NWELL PWELL BULK OAI22_X2
X$87254 \$37062 \$38055 \$37065 \$38635 \$38632 NWELL PWELL BULK OAI22_X4
X$87260 \$37062 \$37258 \$37065 \$37064 \$38589 NWELL PWELL BULK OAI22_X2
X$87262 \$37062 \$38619 \$37065 \$37994 \$38766 NWELL PWELL BULK OAI22_X2
X$87265 \$37062 \$39795 \$37065 \$40137 \$40379 NWELL PWELL BULK OAI22_X2
X$87268 \$37062 \$38760 \$37065 \$40686 \$43055 NWELL PWELL BULK OAI22_X2
X$87270 \$37062 \$40372 \$37065 \$40378 \$40376 NWELL PWELL BULK OAI22_X4
X$87272 \$37062 \$40935 \$37065 \$39800 \$43275 NWELL PWELL BULK OAI22_X2
X$87275 \$37062 \$39568 \$37065 \$39258 \$39259 NWELL PWELL BULK OAI22_X4
X$87278 \$37062 \$37308 \$37065 \$37079 \$37686 NWELL PWELL BULK OAI22_X2
X$87280 \$37062 \$38072 \$37065 \$38653 \$38083 NWELL PWELL BULK OAI22_X4
X$87283 \$37062 \$40432 \$37065 \$40434 \$39804 NWELL PWELL BULK OAI22_X4
X$87286 \$37062 \$40168 \$40509 \$40110 NWELL PWELL BULK AOI21_X2
X$87288 \$37062 \$38803 \$37727 \$40716 NWELL PWELL BULK NOR3_X1
X$87339 \$37065 \$51305 \$51522 \$52520 NWELL PWELL BULK OAI21_X1
X$87341 \$37065 \$48556 \$49967 \$50536 NWELL PWELL BULK OAI21_X1
X$87343 \$50658 \$37065 \$49463 \$50667 NWELL PWELL BULK OAI21_X2
X$87345 \$37065 \$51517 \$51607 \$52749 NWELL PWELL BULK OAI21_X1
X$87347 \$52761 \$37065 \$52878 \$52877 NWELL PWELL BULK OAI21_X2
X$87350 \$37065 \$52523 \$52105 \$52540 NWELL PWELL BULK OAI21_X1
X$87354 \$37065 \$51564 \$52501 \$53021 NWELL PWELL BULK OAI21_X1
X$87357 \$52679 \$37065 \$51576 \$53704 NWELL PWELL BULK OAI21_X2
X$87361 \$51806 \$37065 \$46418 \$52084 NWELL PWELL BULK OAI21_X2
X$87364 \$37065 \$50814 \$52995 \$56304 NWELL PWELL BULK OAI21_X1
X$87368 \$52222 \$37065 \$51280 \$52232 NWELL PWELL BULK OAI21_X2
X$87371 \$37065 \$41869 \$42534 \$43290 NWELL PWELL BULK OAI21_X1
X$87374 \$37065 \$46367 \$47466 \$47542 NWELL PWELL BULK OAI21_X1
X$87376 \$37065 \$52885 \$52886 \$53134 NWELL PWELL BULK OAI21_X1
X$87379 \$37065 \$51337 \$52790 \$53958 NWELL PWELL BULK OAI21_X1
X$87381 \$49779 \$37065 \$49509 \$49510 NWELL PWELL BULK OAI21_X2
X$87384 \$37065 \$50874 \$51501 \$52533 NWELL PWELL BULK OAI21_X1
X$87386 \$37065 \$51624 \$51333 \$51628 NWELL PWELL BULK OAI21_X1
X$87389 \$37065 \$46450 \$46690 \$46389 NWELL PWELL BULK OAI21_X1
X$87494 \$38363 \$37685 \$37072 NWELL PWELL BULK NOR2_X4
X$87556 \$38697 \$37681 \$37103 NWELL PWELL BULK NAND2_X1
X$87559 \$38414 \$37107 \$37106 NWELL PWELL BULK NOR2_X1
X$87566 \$38414 \$38415 \$37107 \$38221 NWELL PWELL BULK NOR3_X1
X$87601 \$37126 \$37646 NWELL PWELL BULK INV_X1
X$87607 \$37392 \$37127 \$I241078 \$37396 NWELL PWELL BULK HA_X1
X$87610 \$37128 \$37127 \$37819 \$38333 NWELL PWELL BULK NOR3_X1
X$87614 \$37127 \$37508 \$38447 \$39094 NWELL PWELL BULK MUX2_X1
X$87620 \$38325 \$37128 \$37508 \$38323 \$37644 NWELL PWELL BULK AND4_X1
X$87622 \$37508 \$37128 \$37511 NWELL PWELL BULK NOR2_X1
X$87625 \$37128 \$38448 \$I241072 \$37504 NWELL PWELL BULK HA_X1
X$87633 \$37503 \$37811 \$37815 \$37129 NWELL PWELL BULK OAI21_X4
X$87641 \$37646 \$37129 \$38292 NWELL PWELL BULK OR2_X1
X$87644 \$40632 \$37129 \$40634 NWELL PWELL BULK OR2_X1
X$87648 \$41810 \$37129 \$41812 NWELL PWELL BULK OR2_X1
X$87651 \$38828 \$37129 \$37801 \$38430 NWELL PWELL BULK NAND3_X1
X$87655 \$50192 \$37129 \$50494 NWELL PWELL BULK OR2_X1
X$87657 \$49517 \$37129 \$50075 NWELL PWELL BULK OR2_X1
X$87660 \$49157 \$37129 \$49444 NWELL PWELL BULK OR2_X1
X$87662 \$47885 \$37129 \$49013 NWELL PWELL BULK OR2_X1
X$87664 \$48997 \$37129 \$49430 NWELL PWELL BULK OR2_X1
X$87667 \$49003 \$37129 \$48617 NWELL PWELL BULK OR2_X1
X$87678 \$46695 \$37129 \$47093 NWELL PWELL BULK OR2_X1
X$87680 \$48144 \$37129 \$47840 NWELL PWELL BULK OR2_X1
X$87682 \$45203 \$37129 \$45202 NWELL PWELL BULK OR2_X1
X$87689 \$45283 \$37129 \$45281 NWELL PWELL BULK OR2_X1
X$87733 \$37367 \$37361 \$37133 \$37362 \$37521 NWELL PWELL BULK NOR4_X1
X$87737 \$37134 \$38291 NWELL PWELL BULK INV_X1
X$87754 \$37527 \$37145 \$38211 NWELL PWELL BULK XNOR2_X2
X$87758 M1_AXI_WDATA[12] \$37147 NWELL PWELL BULK CLKBUF_X2
X$87791 M1_AXI_WDATA[29] \$37167 NWELL PWELL BULK BUF_X1
X$87883 \$38878 \$39517 \$37247 NWELL PWELL BULK NOR2_X1
X$87920 \$53777 \$42756 \$53778 \$43440 \$43349 \$37274 \$52345 NWELL PWELL
+ BULK OAI222_X2
X$87922 \$37274 \$43769 \$54107 NWELL PWELL BULK NOR2_X1
X$87953 \$43975 \$37306 \$43973 \$43561 \$42908 \$43316 \$43564 NWELL PWELL
+ BULK AOI222_X2
X$87955 \$37306 \$43565 NWELL PWELL BULK INV_X1
X$87957 \$42928 \$37306 \$42222 \$42908 \$43184 \$43316 \$43171 NWELL PWELL
+ BULK AOI222_X2
X$87959 \$41913 \$37306 \$42931 \$42908 \$42930 \$43316 \$41554 NWELL PWELL
+ BULK AOI222_X2
X$87961 \$37306 \$42798 \$43541 \$44199 NWELL PWELL BULK NAND3_X2
X$88010 \$37368 \$37627 NWELL PWELL BULK INV_X1
X$88020 \$37392 \$38448 \$38447 \$37819 NWELL PWELL BULK HA_X1
X$88034 \$37396 \$37506 NWELL PWELL BULK INV_X1
X$88044 \$44791 \$37404 \$44789 NWELL PWELL BULK NOR2_X2
X$88049 \$38810 \$37404 \$39296 \$39672 \$39670 \$38415 NWELL PWELL BULK
+ OAI221_X2
X$88076 \$38814 \$39309 \$39304 \$37426 NWELL PWELL BULK OAI21_X2
X$88116 \$37741 \$37623 \$37755 \$37617 \$37441 NWELL PWELL BULK OAI22_X4
X$88119 \$37448 \$42849 \$46429 \$46430 NWELL PWELL BULK MUX2_X1
X$88121 \$46027 \$42511 \$37448 \$46428 NWELL PWELL BULK MUX2_X1
X$88123 \$37448 \$41977 \$45236 \$45873 NWELL PWELL BULK MUX2_X1
X$88126 \$45438 \$42506 \$37448 \$45442 NWELL PWELL BULK MUX2_X1
X$88187 \$37480 \$37669 \$37755 \$38642 \$39257 NWELL PWELL BULK OAI22_X4
X$88189 \$37480 \$37481 NWELL PWELL BULK BUF_X16
X$88191 \$37480 \$39056 \$37755 \$38631 \$39254 NWELL PWELL BULK OAI22_X4
X$88194 \$37480 \$39060 \$37755 \$38636 \$38772 NWELL PWELL BULK OAI22_X4
X$88196 \$37480 \$38626 \$37755 \$38625 \$39050 NWELL PWELL BULK OAI22_X4
X$88199 \$37480 \$37748 \$37755 \$39545 \$39251 NWELL PWELL BULK OAI22_X4
X$88201 \$37480 \$39798 \$37755 \$40391 \$39799 NWELL PWELL BULK OAI22_X4
X$88204 \$37741 \$37480 NWELL PWELL BULK BUF_X8
X$88206 \$37480 \$40047 \$37755 \$39571 \$40147 NWELL PWELL BULK OAI22_X4
X$88218 \$37481 \$49379 \$37482 \$49755 \$49135 NWELL PWELL BULK OAI22_X4
X$88221 \$37481 \$53100 \$37482 \$53092 \$50175 NWELL PWELL BULK OAI22_X4
X$88223 \$37481 \$37693 \$37482 \$52356 \$52352 NWELL PWELL BULK OAI22_X2
X$88225 \$37481 \$39576 \$37482 \$52519 \$51091 NWELL PWELL BULK OAI22_X4
X$88227 \$37481 \$53124 \$37482 \$53110 \$48944 NWELL PWELL BULK OAI22_X4
X$88229 \$37481 \$51150 \$37482 \$51526 \$50427 NWELL PWELL BULK OAI22_X4
X$88232 \$37481 \$46745 \$37482 \$47441 \$46447 NWELL PWELL BULK OAI22_X4
X$88234 \$37481 \$51953 \$37482 \$49793 \$54026 NWELL PWELL BULK OAI22_X2
X$88237 \$37481 \$51966 \$37482 \$52113 \$47807 NWELL PWELL BULK OAI22_X4
X$88240 \$37481 \$52427 \$37482 \$53495 \$50181 NWELL PWELL BULK OAI22_X4
X$88242 \$37481 \$47034 \$37482 \$45674 \$52879 NWELL PWELL BULK OAI22_X2
X$88244 \$37481 \$52743 \$37482 \$54467 \$50172 NWELL PWELL BULK OAI22_X4
X$88246 \$37481 \$52094 \$37482 \$52364 \$49489 NWELL PWELL BULK OAI22_X4
X$88249 \$37481 \$42880 \$37482 \$43152 \$40188 NWELL PWELL BULK OAI22_X4
X$88271 \$44884 \$39515 \$37482 \$50728 \$50363 NWELL PWELL BULK OAI22_X4
X$88273 \$44884 \$39998 \$37482 \$50365 \$49476 NWELL PWELL BULK OAI22_X4
X$88293 \$37482 \$37755 NWELL PWELL BULK BUF_X32
X$88323 \$37505 \$37493 NWELL PWELL BULK INV_X1
X$88326 \$37504 \$37493 \$38321 NWELL PWELL BULK NAND2_X1
X$88356 \$37504 \$37505 \$37815 NWELL PWELL BULK NAND2_X1
X$88365 \$37504 \$39087 \$39320 NWELL PWELL BULK NAND2_X1
X$88368 \$38444 \$37504 \$38836 NWELL PWELL BULK NAND2_X1
X$88376 \$39320 \$37505 \$38614 \$38840 NWELL PWELL BULK AOI21_X1
X$88378 \$37796 \$37505 \$38234 NWELL PWELL BULK NAND2_X1
X$88411 \$38843 \$37515 \$39851 \$40214 NWELL PWELL BULK HA_X1
X$88414 \$38842 \$37515 \$39327 NWELL PWELL BULK NAND2_X1
X$88418 \$37515 \$37629 \$37516 \$37518 NWELL PWELL BULK HA_X1
X$88424 \$37516 \$38339 NWELL PWELL BULK INV_X1
X$88427 \$37519 \$37518 \$38342 \$37520 NWELL PWELL BULK OAI21_X1
X$88429 \$38339 \$37827 \$37826 \$37519 NWELL PWELL BULK AOI21_X1
X$88432 \$38311 \$37520 \$37829 \$38296 NWELL PWELL BULK AOI21_X1
X$88439 \$37521 \$38449 \$37826 \$41531 NWELL PWELL BULK NAND3_X1
X$88443 \$38842 \$37522 \$41192 NWELL PWELL BULK NAND2_X1
X$88446 \$37522 \$40214 \$39852 \$39855 NWELL PWELL BULK HA_X1
X$88449 \$37522 \$37830 \$40214 \$40604 NWELL PWELL BULK AND3_X1
X$88451 \$37522 \$37627 \$38342 \$38330 NWELL PWELL BULK HA_X1
X$88459 \$38223 \$37527 \$38216 NWELL PWELL BULK NAND2_X1
X$88467 \$39865 \$37528 \$37602 NWELL PWELL BULK XNOR2_X2
X$88475 M1_AXI_WSTRB[0] \$37536 NWELL PWELL BULK BUF_X1
X$88491 \$45817 \$42756 \$45384 \$43440 \$43349 \$37546 \$46559 NWELL PWELL
+ BULK OAI222_X2
X$88494 \$37546 \$43769 \$46114 NWELL PWELL BULK NOR2_X1
X$88505 M1_AXI_WDATA[1] \$37548 NWELL PWELL BULK BUF_X1
X$88573 \$38457 \$37613 \$40599 \$41079 NWELL PWELL BULK AND3_X1
X$88576 \$37613 \$41768 NWELL PWELL BULK INV_X1
X$88578 \$37613 \$38585 \$38253 \$38461 NWELL PWELL BULK HA_X1
X$88586 \$70916 \$63530 \$37617 \$70786 NWELL PWELL BULK MUX2_X1
X$88588 \$70579 \$62181 \$37617 \$70582 NWELL PWELL BULK MUX2_X1
X$88591 \$71621 \$63057 \$37617 \$71993 NWELL PWELL BULK MUX2_X1
X$88593 \$71078 \$61075 \$37617 \$71476 NWELL PWELL BULK MUX2_X1
X$88608 \$57116 \$37621 \$56661 NWELL PWELL BULK NAND2_X1
X$88611 \$40633 \$39335 \$39852 \$37621 \$40745 NWELL PWELL BULK NAND4_X1
X$88613 \$40633 \$39335 \$41434 \$37621 \$41535 NWELL PWELL BULK NAND4_X1
X$88615 \$37621 \$39335 \$40215 NWELL PWELL BULK AND2_X2
X$88617 \$37621 \$41186 NWELL PWELL BULK INV_X1
X$88619 \$40633 \$40211 \$37621 \$38842 NWELL PWELL BULK OAI21_X4
X$88621 \$41889 \$41887 \$I241012 \$37621 NWELL PWELL BULK HA_X1
X$88624 \$39335 \$37621 \$39853 NWELL PWELL BULK NAND2_X2
X$88626 \$40633 \$39335 \$41429 \$37621 \$41536 NWELL PWELL BULK NAND4_X1
X$88674 \$46039 \$42511 \$37650 \$46622 NWELL PWELL BULK MUX2_X1
X$88677 \$46035 \$42506 \$37650 \$46432 NWELL PWELL BULK MUX2_X1
X$88680 \$37650 \$41977 \$45889 \$46033 NWELL PWELL BULK MUX2_X1
X$88684 \$37650 \$42849 \$45898 \$45895 NWELL PWELL BULK MUX2_X1
X$88691 \$44464 \$42511 \$37664 \$44248 NWELL PWELL BULK MUX2_X1
X$88693 \$43938 \$42506 \$37664 \$44136 NWELL PWELL BULK MUX2_X1
X$88695 \$37664 \$42849 \$44251 \$44249 NWELL PWELL BULK MUX2_X1
X$88699 \$37664 \$41977 \$43519 \$43750 NWELL PWELL BULK MUX2_X1
X$88707 \$63595 \$62784 \$37667 \$63067 NWELL PWELL BULK MUX2_X1
X$88710 \$63356 \$63355 \$37667 \$64089 NWELL PWELL BULK MUX2_X1
X$88712 \$60638 \$61102 \$37667 \$61368 NWELL PWELL BULK MUX2_X1
X$88715 \$61793 \$61799 \$37667 \$62396 NWELL PWELL BULK MUX2_X1
X$88738 \$37681 \$38363 \$40536 NWELL PWELL BULK NOR2_X1
X$88740 \$39298 \$37681 \$39299 NWELL PWELL BULK OR2_X1
X$88751 \$41139 \$37685 \$40663 \$41484 NWELL PWELL BULK AOI21_X2
X$88754 \$40276 \$37685 \$40121 \$40657 NWELL PWELL BULK AOI21_X2
X$88757 \$39405 \$37685 \$38723 \$39778 NWELL PWELL BULK AOI21_X2
X$88763 \$38731 \$37685 \$39214 \$39779 NWELL PWELL BULK AOI21_X2
X$88766 \$38978 \$37685 NWELL PWELL BULK BUF_X8
X$88769 \$41616 \$37685 \$41968 \$41621 NWELL PWELL BULK AOI21_X2
X$88796 \$47175 \$42511 \$37686 \$47172 NWELL PWELL BULK MUX2_X1
X$88798 \$37686 \$42849 \$46733 \$47527 NWELL PWELL BULK MUX2_X1
X$88801 \$37686 \$41977 \$46283 \$46435 NWELL PWELL BULK MUX2_X1
X$88803 \$45906 \$42506 \$37686 \$45908 NWELL PWELL BULK MUX2_X1
X$88855 \$37721 \$38724 \$39214 NWELL PWELL BULK NOR2_X1
X$88860 \$44367 \$44683 \$40656 \$37725 NWELL PWELL BULK MUX2_X2
X$88863 \$37725 \$37726 \$37727 \$38358 NWELL PWELL BULK NOR3_X1
X$88868 \$37741 \$39779 \$37755 \$40297 \$37725 NWELL PWELL BULK OAI22_X4
X$88876 \$37726 \$38404 \$38122 \$38806 NWELL PWELL BULK AOI21_X4
X$88880 \$50271 \$37726 \$37727 \$50981 NWELL PWELL BULK NOR3_X1
X$88883 \$50427 \$37726 \$37727 \$51939 NWELL PWELL BULK NOR3_X1
X$88886 \$50175 \$37726 \$37727 \$52422 NWELL PWELL BULK NOR3_X1
X$88888 \$50172 \$37726 \$37727 \$52104 NWELL PWELL BULK NOR3_X1
X$88890 \$49489 \$37726 \$37727 \$50851 NWELL PWELL BULK NOR3_X1
X$88892 \$46024 \$37726 \$37727 \$46213 NWELL PWELL BULK NOR3_X1
X$88896 \$51561 \$37726 \$37727 \$52079 NWELL PWELL BULK NOR3_X1
X$88898 \$50695 \$37726 \$37727 \$50833 NWELL PWELL BULK NOR3_X1
X$88900 \$51291 \$37726 \$37727 \$52083 NWELL PWELL BULK NOR3_X1
X$88902 \$51298 \$37726 \$37727 \$52508 NWELL PWELL BULK NOR3_X1
X$88906 \$49587 \$37726 \$37727 \$49829 NWELL PWELL BULK NOR3_X1
X$88909 \$52075 \$37726 \$37727 \$52243 NWELL PWELL BULK NOR3_X1
X$88911 \$51549 \$37726 \$37727 \$51546 NWELL PWELL BULK NOR3_X1
X$88913 \$52209 \$37726 \$37727 \$52855 NWELL PWELL BULK NOR3_X1
X$88918 \$40188 \$37726 \$37727 \$42797 NWELL PWELL BULK NOR3_X1
X$88922 \$48944 \$37726 \$37727 \$52454 NWELL PWELL BULK NOR3_X1
X$88925 \$50181 \$37726 \$37727 \$52784 NWELL PWELL BULK NOR3_X1
X$88927 \$49135 \$37726 \$37727 \$49773 NWELL PWELL BULK NOR3_X1
X$88931 \$47807 \$37726 \$37727 \$51621 NWELL PWELL BULK NOR3_X1
X$88933 \$49793 \$37726 \$37727 \$51332 NWELL PWELL BULK NOR3_X1
X$88935 \$45674 \$37726 \$37727 \$46455 NWELL PWELL BULK NOR3_X1
X$88939 \$46447 \$37726 \$37727 \$47457 NWELL PWELL BULK NOR3_X1
X$88941 \$40664 \$37726 \$37727 \$40666 NWELL PWELL BULK NOR3_X1
X$89036 \$37727 \$40091 \$40079 NWELL PWELL BULK NOR2_X1
X$89038 \$39309 \$37727 \$38824 \$39311 NWELL PWELL BULK AOI21_X4
X$89040 \$52778 \$37727 \$56610 NWELL PWELL BULK NOR2_X1
X$89069 \$38796 \$39285 \$37727 NWELL PWELL BULK OR2_X4
X$89131 M0_AXI_AWADDR[11] \$37728 NWELL PWELL BULK BUF_X1
X$89153 \$37741 \$38582 \$37755 \$38584 \$39001 NWELL PWELL BULK OAI22_X4
X$89156 \$37741 \$38380 \$37755 \$39797 \$39038 NWELL PWELL BULK OAI22_X4
X$89159 \$37741 \$38002 \$37755 \$38595 \$38609 NWELL PWELL BULK OAI22_X4
X$89162 \$37741 \$38018 \$37755 \$38622 \$38029 NWELL PWELL BULK OAI22_X4
X$89167 \$37741 \$41484 \$37755 \$41991 \$40664 NWELL PWELL BULK OAI22_X4
X$89173 \$37741 \$44884 NWELL PWELL BULK BUF_X16
X$89176 \$37741 \$39238 \$37755 \$40362 \$39994 NWELL PWELL BULK OAI22_X4
X$89212 \$44884 \$50281 \$37755 \$50662 \$49587 NWELL PWELL BULK OAI22_X4
X$89214 \$44884 \$51010 \$37755 \$56474 \$50695 NWELL PWELL BULK OAI22_X4
X$89216 \$44884 \$52656 \$37755 \$53014 \$51561 NWELL PWELL BULK OAI22_X4
X$89219 \$44884 \$52668 \$37755 \$58207 \$51291 NWELL PWELL BULK OAI22_X4
X$89222 \$44884 \$52291 \$37755 \$52290 \$51298 NWELL PWELL BULK OAI22_X4
X$89224 \$44884 \$52487 \$37755 \$55185 \$52209 NWELL PWELL BULK OAI22_X4
X$89226 \$44884 \$52076 \$37755 \$52075 \$53013 NWELL PWELL BULK OAI22_X2
X$89229 \$44884 \$51548 \$37755 \$50271 \$53000 NWELL PWELL BULK OAI22_X2
X$89233 \$44884 \$46571 \$37755 \$46572 \$46024 NWELL PWELL BULK OAI22_X4
X$89245 \$44884 \$52639 \$37755 \$53004 \$51549 NWELL PWELL BULK OAI22_X4
X$89296 \$41502 \$41862 \$37780 NWELL PWELL BULK NOR2_X1
X$89303 \$41158 \$40656 \$37781 NWELL PWELL BULK NOR2_X1
X$89311 \$38797 \$37785 \$38404 NWELL PWELL BULK NOR2_X1
X$89313 \$38797 \$37785 \$38802 \$38803 \$38801 NWELL PWELL BULK OAI22_X4
X$89338 \$38431 \$38434 \$37802 \$38645 NWELL PWELL BULK AOI21_X1
X$89341 \$38435 \$37802 \$38432 \$38644 NWELL PWELL BULK OR3_X1
X$89368 \$37813 M0_AXI_ARREADY NWELL PWELL BULK BUF_X1
X$89382 \$37819 \$38325 NWELL PWELL BULK INV_X1
X$89396 \$38347 \$37826 NWELL PWELL BULK INV_X1
X$89402 \$38330 \$37829 NWELL PWELL BULK INV_X1
X$89406 \$37830 \$39329 NWELL PWELL BULK INV_X1
X$89412 \$37830 \$38309 \$38314 \$38608 NWELL PWELL BULK HA_X1
X$89418 \$37835 \$38464 \$38576 \$39057 \$38578 NWELL PWELL BULK FA_X1
X$89421 \$37838 \$37835 \$37837 \$37836 NWELL PWELL BULK AOI21_X1
X$89425 \$38463 \$37837 \$38578 \$38245 NWELL PWELL BULK MUX2_X1
X$89428 \$37837 \$38576 \$37838 NWELL PWELL BULK NOR2_X1
X$89435 \$39643 \$37837 \$41416 NWELL PWELL BULK NOR2_X1
X$89440 \$38851 \$38852 \$37841 NWELL PWELL BULK NAND2_X1
X$89456 M1_AXI_WDATA[18] \$37856 NWELL PWELL BULK BUF_X1
X$89469 M1_AXI_WDATA[7] \$37862 NWELL PWELL BULK BUF_X1
X$89553 \$42944 \$45817 \$45384 \$40298 \$37965 NWELL PWELL BULK OAI22_X2
X$89658 \$55531 \$42756 \$55870 \$43440 \$43349 \$38104 \$53272 NWELL PWELL
+ BULK OAI222_X2
X$89660 \$38104 \$43769 \$55873 NWELL PWELL BULK NOR2_X1
X$89669 \$39271 \$39272 \$38109 NWELL PWELL BULK NOR2_X1
X$89688 \$40717 \$38122 \$40719 NWELL PWELL BULK NOR2_X1
X$89697 \$38122 \$39271 \$38397 \$40162 NWELL PWELL BULK NOR3_X1
X$89699 \$38122 \$38801 NWELL PWELL BULK INV_X1
X$89701 \$39815 \$39817 \$38122 \$39271 \$40164 NWELL PWELL BULK NOR4_X1
X$89729 \$38133 \$39811 \$39815 \$40157 NWELL PWELL BULK OAI21_X1
X$89732 \$38133 \$40712 \$40483 \$40997 NWELL PWELL BULK OR3_X1
X$89739 \$38159 \$43769 \$67644 NWELL PWELL BULK NOR2_X1
X$89741 \$67054 \$42756 \$66747 \$43440 \$43349 \$38159 \$66745 NWELL PWELL
+ BULK OAI222_X2
X$89760 \$38172 \$41977 \$43289 \$43181 NWELL PWELL BULK MUX2_X1
X$89763 \$43529 \$42506 \$38172 \$43800 NWELL PWELL BULK MUX2_X1
X$89765 \$44512 \$42511 \$38172 \$44824 NWELL PWELL BULK MUX2_X1
X$89767 \$38172 \$42849 \$44261 \$43951 NWELL PWELL BULK MUX2_X1
X$89785 \$38802 \$40170 \$38178 \$39646 NWELL PWELL BULK OAI21_X1
X$89801 \$65631 \$42756 \$64767 \$43440 \$43349 \$38198 \$67038 NWELL PWELL
+ BULK OAI222_X2
X$89804 \$38198 \$43769 \$65633 NWELL PWELL BULK NOR2_X1
X$89838 \$41908 \$42088 \$41545 \$38223 NWELL PWELL BULK OR3_X4
X$89844 \$38223 \$40221 \$38570 \$40504 NWELL PWELL BULK OR3_X4
X$89846 \$38223 \$40551 \$40559 NWELL PWELL BULK NAND2_X1
X$89848 \$38223 \$38851 NWELL PWELL BULK INV_X4
X$89851 \$38223 \$39865 \$40547 NWELL PWELL BULK NAND2_X1
X$89854 \$38223 \$39347 \$38853 NWELL PWELL BULK NAND2_X1
X$89857 \$38570 \$39865 \$38223 \$39972 NWELL PWELL BULK NOR3_X4
X$89859 \$38223 \$38570 \$39349 NWELL PWELL BULK NAND2_X1
X$89887 \$38459 \$38255 \$38253 \$39065 NWELL PWELL BULK OAI21_X1
X$89896 \$38457 \$38260 \$38255 \$38459 NWELL PWELL BULK HA_X1
X$89913 \$38265 \$38260 NWELL PWELL BULK INV_X1
X$89929 \$38272 \$38437 \$38278 \$38433 NWELL PWELL BULK HA_X1
X$89933 \$38456 \$38277 \$38283 \$38458 NWELL PWELL BULK HA_X1
X$89952 \$38454 \$38296 \$38283 \$38602 \$38288 \$39062 NWELL PWELL BULK
+ OAI221_X1
X$89955 \$38289 \$38291 \$38288 \$38602 NWELL PWELL BULK HA_X1
X$89963 \$38842 \$38289 \$41440 NWELL PWELL BULK NAND2_X1
X$89965 \$38289 \$40604 \$41434 \$40592 NWELL PWELL BULK HA_X1
X$89967 \$38289 \$38456 \$40604 \$40599 NWELL PWELL BULK AND3_X1
X$89987 \$38314 \$38311 NWELL PWELL BULK INV_X1
X$90055 \$38355 \$38803 NWELL PWELL BULK BUF_X8
X$90103 \$38725 \$38358 \$38359 \$38541 NWELL PWELL BULK OAI21_X1
X$90107 \$38803 \$38359 \$52778 NWELL PWELL BULK XOR2_X1
X$90110 \$50653 \$50981 \$38359 \$50658 NWELL PWELL BULK OAI21_X1
X$90112 \$50865 \$51939 \$38359 \$51607 NWELL PWELL BULK OAI21_X1
X$90114 \$52110 \$52422 \$38359 \$52761 NWELL PWELL BULK OAI21_X1
X$90117 \$52103 \$52104 \$38359 \$52105 NWELL PWELL BULK OAI21_X1
X$90120 \$51595 \$50851 \$38359 \$51522 NWELL PWELL BULK OAI21_X1
X$90122 \$46422 \$46213 \$38359 \$46423 NWELL PWELL BULK OAI21_X1
X$90125 \$51023 \$50833 \$38359 \$50545 NWELL PWELL BULK OAI21_X1
X$90127 \$51786 \$52079 \$38359 \$52501 NWELL PWELL BULK OAI21_X1
X$90129 \$52288 \$52083 \$38359 \$51806 NWELL PWELL BULK OAI21_X1
X$90132 \$52086 \$52508 \$38359 \$52679 NWELL PWELL BULK OAI21_X1
X$90135 \$49962 \$49829 \$38359 \$49967 NWELL PWELL BULK OAI21_X1
X$90137 \$50301 \$50292 \$38359 \$50540 NWELL PWELL BULK OAI21_X1
X$90140 \$52235 \$52243 \$38359 \$52250 NWELL PWELL BULK OAI21_X1
X$90142 \$52628 \$52855 \$38359 \$52995 NWELL PWELL BULK OAI21_X1
X$90144 \$51545 \$51546 \$38359 \$52222 NWELL PWELL BULK OAI21_X1
X$90146 \$42532 \$42797 \$38359 \$42534 NWELL PWELL BULK OAI21_X1
X$90159 \$46751 \$47457 \$38359 \$47466 NWELL PWELL BULK OAI21_X1
X$90162 \$52777 \$52784 \$38359 \$52886 NWELL PWELL BULK OAI21_X1
X$90164 \$52456 \$52454 \$38359 \$52790 NWELL PWELL BULK OAI21_X1
X$90166 \$49774 \$49773 \$38359 \$49779 NWELL PWELL BULK OAI21_X1
X$90168 \$51328 \$51621 \$38359 \$51501 NWELL PWELL BULK OAI21_X1
X$90171 \$51997 \$51332 \$38359 \$51333 NWELL PWELL BULK OAI21_X1
X$90174 \$46678 \$46455 \$38359 \$46690 NWELL PWELL BULK OAI21_X1
X$90178 \$41271 \$41625 \$38359 \$41280 NWELL PWELL BULK OAI21_X1
X$90180 \$40847 \$40666 \$38359 \$41140 NWELL PWELL BULK OAI21_X1
X$90182 \$39784 \$39936 \$38359 \$40301 NWELL PWELL BULK OAI21_X1
X$90184 \$38531 \$38948 \$38359 \$38734 NWELL PWELL BULK OAI21_X1
X$90189 \$38968 \$39225 \$38359 \$38743 NWELL PWELL BULK OAI21_X1
X$90256 \$38672 \$38391 \$39109 \$38791 \$38359 NWELL PWELL BULK AOI211_X4
X$90267 \$46307 \$38363 \$49844 NWELL PWELL BULK NOR2_X2
X$90270 \$48556 \$38363 \$38978 \$49955 NWELL PWELL BULK NOR3_X1
X$90272 \$49463 \$38363 \$38978 \$50817 NWELL PWELL BULK NOR3_X1
X$90282 \$51576 \$38363 \$38978 \$52681 NWELL PWELL BULK NOR3_X1
X$90284 \$51564 \$38363 \$38978 \$51446 NWELL PWELL BULK NOR3_X1
X$90286 \$46418 \$38363 \$38978 \$51793 NWELL PWELL BULK NOR3_X1
X$90292 \$50814 \$38363 \$38978 \$52488 NWELL PWELL BULK NOR3_X1
X$90294 \$51280 \$38363 \$38978 \$52216 NWELL PWELL BULK NOR3_X1
X$90392 \$38385 \$42849 \$57246 \$57852 NWELL PWELL BULK MUX2_X1
X$90394 \$38385 \$41977 \$57243 \$57840 NWELL PWELL BULK MUX2_X1
X$90396 \$58037 \$53989 \$38385 \$58635 NWELL PWELL BULK MUX2_X1
X$90399 \$58645 \$47751 \$38385 \$58646 NWELL PWELL BULK MUX2_X1
X$90412 \$39806 \$39605 \$38389 \$40448 NWELL PWELL BULK OAI21_X1
X$90414 \$38389 \$39272 \$39099 \$40066 NWELL PWELL BULK AOI21_X1
X$90420 \$38391 \$38672 \$39110 NWELL PWELL BULK AND2_X1
X$90428 \$40153 \$38397 \$39605 \$40446 NWELL PWELL BULK AOI21_X1
X$90431 \$38397 \$39272 NWELL PWELL BULK INV_X1
X$90437 \$38397 \$39817 \$40705 \$40710 NWELL PWELL BULK OAI21_X1
X$90491 \$38426 \$39704 \$39835 \$39752 NWELL PWELL BULK AND3_X1
X$90512 \$38434 \$38435 \$39140 NWELL PWELL BULK NAND2_X1
X$90532 \$38837 \$38446 \$38444 \$38445 NWELL PWELL BULK OAI21_X1
X$90538 \$38445 \$39116 \$39750 \$39117 NWELL PWELL BULK NAND3_X1
X$90549 \$38447 \$38837 NWELL PWELL BULK INV_X1
X$90557 \$38602 \$38608 \$38454 NWELL PWELL BULK OR2_X1
X$90560 \$38456 \$39331 NWELL PWELL BULK INV_X1
X$90567 \$38457 \$40599 \$41429 \$41773 NWELL PWELL BULK HA_X1
X$90569 \$38842 \$38457 \$41784 NWELL PWELL BULK NAND2_X1
X$90580 \$38458 \$38459 \$38588 NWELL PWELL BULK NOR2_X1
X$90586 \$39334 \$38461 \$39337 NWELL PWELL BULK OR2_X1
X$90589 \$38463 \$38578 \$38462 \$39339 NWELL PWELL BULK DFF_X1
X$90594 \$38572 \$38464 \$39643 NWELL PWELL BULK XOR2_X1
X$90598 \$38570 \$38469 \$38569 NWELL PWELL BULK XNOR2_X2
X$90624 \$38488 \$43769 \$44414 NWELL PWELL BULK NOR2_X1
X$90629 \$43595 \$42756 \$43596 \$43440 \$43349 \$38488 \$42248 NWELL PWELL
+ BULK OAI222_X2
X$90644 \$38512 S0_AXI_WSTRB[3] NWELL PWELL BULK BUF_X1
X$90708 \$40221 \$38570 \$38851 \$40496 NWELL PWELL BULK NAND3_X4
X$90713 \$39865 \$38570 \$38851 \$40231 NWELL PWELL BULK NAND3_X4
X$90728 \$38572 \$39057 NWELL PWELL BULK INV_X1
X$90745 \$63351 \$63355 \$38584 \$63590 NWELL PWELL BULK MUX2_X1
X$90747 \$62781 \$62784 \$38584 \$62934 NWELL PWELL BULK MUX2_X1
X$90750 \$62780 \$61799 \$38584 \$62779 NWELL PWELL BULK MUX2_X1
X$90753 \$62165 \$61102 \$38584 \$62388 NWELL PWELL BULK MUX2_X1
X$90764 \$38847 \$38586 \$39669 \$39334 NWELL PWELL BULK HA_X1
X$90767 \$39667 \$38586 NWELL PWELL BULK INV_X1
X$90776 \$39065 \$39062 \$38588 \$39061 NWELL PWELL BULK AOI21_X1
X$90780 \$43513 \$42511 \$38589 \$43512 NWELL PWELL BULK MUX2_X1
X$90782 \$38589 \$41977 \$42513 \$42694 NWELL PWELL BULK MUX2_X1
X$90784 \$38589 \$42849 \$42859 \$43270 NWELL PWELL BULK MUX2_X1
X$90788 \$43506 \$42506 \$38589 \$43702 NWELL PWELL BULK MUX2_X1
X$90799 \$66254 \$61075 \$38595 \$66077 NWELL PWELL BULK MUX2_X1
X$90802 \$65553 \$63355 \$38595 \$65720 NWELL PWELL BULK MUX2_X1
X$90804 \$66256 \$62350 \$38595 \$66832 NWELL PWELL BULK MUX2_X1
X$90806 \$66087 \$62784 \$38595 \$66257 NWELL PWELL BULK MUX2_X1
X$90832 \$38614 \$38836 \$39116 NWELL PWELL BULK OR2_X1
X$90835 \$39100 \$38614 \$39750 NWELL PWELL BULK NAND2_X1
X$90849 \$64845 \$61799 \$38622 \$64847 NWELL PWELL BULK MUX2_X1
X$90852 \$64852 \$63355 \$38622 \$64693 NWELL PWELL BULK MUX2_X1
X$90855 \$65185 \$61102 \$38622 \$65734 NWELL PWELL BULK MUX2_X1
X$90858 \$65735 \$62784 \$38622 \$65559 NWELL PWELL BULK MUX2_X1
X$90866 \$69592 \$61102 \$38625 \$70070 NWELL PWELL BULK MUX2_X1
X$90868 \$68778 \$63530 \$38625 \$68968 NWELL PWELL BULK MUX2_X1
X$90870 \$69590 \$62350 \$38625 \$69827 NWELL PWELL BULK MUX2_X1
X$90872 \$68055 \$63210 \$38625 \$68583 NWELL PWELL BULK MUX2_X1
X$90884 \$70068 \$63210 \$38631 \$70065 NWELL PWELL BULK MUX2_X1
X$90887 \$71482 \$62350 \$38631 \$72004 NWELL PWELL BULK MUX2_X1
X$90890 \$72006 \$61075 \$38631 \$72374 NWELL PWELL BULK MUX2_X1
X$90902 \$70424 \$63530 \$38631 \$70928 NWELL PWELL BULK MUX2_X1
X$90912 \$38635 \$41977 \$48192 \$48425 NWELL PWELL BULK MUX2_X1
X$90915 \$38635 \$42849 \$49117 \$49325 NWELL PWELL BULK MUX2_X1
X$90917 \$48581 \$42511 \$38635 \$48849 NWELL PWELL BULK MUX2_X1
X$90920 \$47863 \$42506 \$38635 \$48053 NWELL PWELL BULK MUX2_X1
X$90928 \$70426 \$62350 \$38636 \$70606 NWELL PWELL BULK MUX2_X1
X$90931 \$70933 \$69838 \$38636 \$71084 NWELL PWELL BULK MUX2_X1
X$90933 \$72220 \$63530 \$38636 \$72386 NWELL PWELL BULK MUX2_X1
X$90936 \$71833 \$62181 \$38636 \$72382 NWELL PWELL BULK MUX2_X1
X$90949 \$66964 \$62350 \$38642 \$68063 NWELL PWELL BULK MUX2_X1
X$90951 \$67843 \$63355 \$38642 \$68060 NWELL PWELL BULK MUX2_X1
X$90953 \$67578 \$62784 \$38642 \$68077 NWELL PWELL BULK MUX2_X1
X$90956 \$66689 \$61102 \$38642 \$67203 NWELL PWELL BULK MUX2_X1
X$90967 \$38645 \$38644 \$39140 \$38831 NWELL PWELL BULK NAND3_X1
X$90979 \$38653 \$41977 \$62177 \$62435 NWELL PWELL BULK MUX2_X1
X$90981 \$62433 \$53989 \$38653 \$61992 NWELL PWELL BULK MUX2_X1
X$90983 \$59958 \$47751 \$38653 \$60145 NWELL PWELL BULK MUX2_X1
X$90985 \$38653 \$42849 \$60889 \$60647 NWELL PWELL BULK MUX2_X1
X$90994 \$69835 \$63210 \$38658 \$70085 NWELL PWELL BULK MUX2_X1
X$90996 \$69760 \$62784 \$38658 \$69598 NWELL PWELL BULK MUX2_X1
X$90999 \$71086 \$62350 \$38658 \$71268 NWELL PWELL BULK MUX2_X1
X$91002 \$71089 \$69838 \$38658 \$71651 NWELL PWELL BULK MUX2_X1
X$91018 \$65759 \$63355 \$38661 \$65226 NWELL PWELL BULK MUX2_X1
X$91021 \$67225 \$61102 \$38661 \$67582 NWELL PWELL BULK MUX2_X1
X$91023 \$66265 \$61799 \$38661 \$66263 NWELL PWELL BULK MUX2_X1
X$91025 \$65565 \$62784 \$38661 \$66127 NWELL PWELL BULK MUX2_X1
X$91033 \$39298 \$38697 \$38667 NWELL PWELL BULK OR2_X1
X$91059 \$44577 \$42506 \$38704 \$44896 NWELL PWELL BULK MUX2_X1
X$91062 \$46046 \$42511 \$38704 \$45927 NWELL PWELL BULK MUX2_X1
X$91065 \$38704 \$41977 \$45250 \$45248 NWELL PWELL BULK MUX2_X1
X$91069 \$38704 \$42849 \$45936 \$45932 NWELL PWELL BULK MUX2_X1
X$91082 M0_AXI_AWSIZE[2] \$38719 NWELL PWELL BULK BUF_X1
X$91103 \$47532 \$38724 \$50867 NWELL PWELL BULK NOR2_X1
X$91107 \$47155 \$38724 \$50674 NWELL PWELL BULK NOR2_X1
X$91109 \$47511 \$38724 \$49960 NWELL PWELL BULK NOR2_X1
X$91111 \$49850 \$38724 \$52102 NWELL PWELL BULK NOR2_X1
X$91114 \$49374 \$38724 \$53487 NWELL PWELL BULK NOR2_X1
X$91118 \$41142 \$38724 \$46021 NWELL PWELL BULK NOR2_X1
X$91121 \$47698 \$38724 \$52280 NWELL PWELL BULK NOR2_X1
X$91123 \$39954 \$38724 \$51013 NWELL PWELL BULK NOR2_X1
X$91126 \$49473 \$38724 \$52292 NWELL PWELL BULK NOR2_X1
X$91132 \$50323 \$38724 \$52262 NWELL PWELL BULK NOR2_X1
X$91134 \$50537 \$38724 \$52247 NWELL PWELL BULK NOR2_X1
X$91136 \$48325 \$38724 \$52626 NWELL PWELL BULK NOR2_X1
X$91138 \$49284 \$38724 \$52228 NWELL PWELL BULK NOR2_X1
X$91141 \$47436 \$38724 \$52530 NWELL PWELL BULK NOR2_X1
X$91143 \$49137 \$38724 \$49385 NWELL PWELL BULK NOR2_X1
X$91146 \$48206 \$38724 \$52532 NWELL PWELL BULK NOR2_X1
X$91149 \$43949 \$38724 \$47037 NWELL PWELL BULK NOR2_X1
X$91151 \$46444 \$38724 \$47027 NWELL PWELL BULK NOR2_X1
X$91153 \$40122 \$38724 \$40663 NWELL PWELL BULK NOR2_X1
X$91242 \$38741 \$38978 \$39463 \$38742 NWELL PWELL BULK AOI21_X2
X$91250 M0_AXI_AWADDR[21] \$38749 NWELL PWELL BULK BUF_X1
X$91276 \$47519 \$42506 \$38766 \$47710 NWELL PWELL BULK MUX2_X1
X$91278 \$38766 \$42849 \$47524 \$47724 NWELL PWELL BULK MUX2_X1
X$91280 \$47169 \$42511 \$38766 \$47374 NWELL PWELL BULK MUX2_X1
X$91282 \$38766 \$41977 \$47167 \$47356 NWELL PWELL BULK MUX2_X1
X$91301 \$40711 \$38801 \$38791 NWELL PWELL BULK NOR2_X1
X$91327 \$38801 \$40101 \$39285 NWELL PWELL BULK NOR2_X2
X$91331 \$38806 \$38802 NWELL PWELL BULK INV_X1
X$91394 \$40091 \$38814 NWELL PWELL BULK INV_X1
X$91399 \$39303 \$40079 \$39299 \$39304 \$38814 \$40082 NWELL PWELL BULK
+ AOI221_X1
X$91415 \$38824 \$39311 \$39303 NWELL PWELL BULK NAND2_X1
X$91437 \$38842 \$40644 \$40031 NWELL PWELL BULK OR2_X1
X$91440 \$38842 \$40215 \$43303 \$42548 NWELL PWELL BULK OAI21_X1
X$91445 \$38842 \$40215 \$41086 \$41081 NWELL PWELL BULK AOI21_X1
X$91448 \$38842 \$40615 \$40215 \$39693 NWELL PWELL BULK AOI21_X1
X$91450 \$38842 \$40601 \$40215 \$39996 NWELL PWELL BULK AOI21_X1
X$91452 \$39702 \$38842 \$38843 \$39083 NWELL PWELL BULK MUX2_X1
X$91457 \$38842 \$41901 \$40215 \$41199 NWELL PWELL BULK AOI21_X1
X$91483 \$39853 \$38843 \$39702 NWELL PWELL BULK NOR2_X1
X$91487 \$39332 \$38845 \$39068 \$39683 NWELL PWELL BULK NAND3_X1
X$91493 \$38847 \$40216 NWELL PWELL BULK INV_X1
X$91500 \$38851 \$40551 \$40219 NWELL PWELL BULK NAND2_X1
X$91503 \$38851 \$39347 \$39350 NWELL PWELL BULK NAND2_X1
X$91506 \$38851 \$40218 \$39633 NWELL PWELL BULK NAND2_X1
X$91510 \$38851 \$40554 \$39987 NWELL PWELL BULK NAND2_X1
X$91515 \$38851 \$38855 \$39047 NWELL PWELL BULK NAND2_X1
X$91524 \$38852 \$39633 \$39640 NWELL PWELL BULK XNOR2_X1
X$91527 \$I179184 \$38852 \$39988 \$39339 NWELL PWELL BULK DFF_X1
X$91551 M1_AXI_WSTRB[1] \$38859 NWELL PWELL BULK CLKBUF_X2
X$91560 M1_AXI_WDATA[21] \$38866 NWELL PWELL BULK BUF_X1
X$91580 \$42944 \$43350 \$40298 \$43352 \$38878 NWELL PWELL BULK OAI22_X1
X$91584 \$43350 \$42756 \$43352 \$43440 \$43349 \$38879 \$40383 NWELL PWELL
+ BULK OAI222_X2
X$91586 \$38879 \$43769 \$43587 NWELL PWELL BULK NOR2_X1
X$91598 \$38884 S0_AXI_WDATA[7] NWELL PWELL BULK BUF_X1
X$91607 \$38889 \$39434 \$39445 \$38891 NWELL PWELL BULK DFF_X1
X$91609 M0_AXI_WDATA[7] \$39427 NWELL PWELL BULK CLKBUF_X2
X$91614 \$I178676 \$43615 \$43666 \$38891 NWELL PWELL BULK DFF_X1
X$91616 \$40865 \$41236 \$40867 \$38891 NWELL PWELL BULK DFF_X1
X$91619 \$I177564 \$41651 \$41656 \$38891 NWELL PWELL BULK DFF_X1
X$91621 \$I175915 \$43647 \$43617 \$38891 NWELL PWELL BULK DFF_X1
X$91623 \$I178779 \$42998 \$43000 \$38891 NWELL PWELL BULK DFF_X1
X$91626 \$I178777 \$41578 \$41940 \$38891 NWELL PWELL BULK DFF_X1
X$91629 \$41939 \$42256 \$42255 \$38891 NWELL PWELL BULK DFF_X1
X$91632 \$39474 \$39935 \$39891 \$38891 NWELL PWELL BULK DFF_X1
X$91634 \$40248 \$40247 \$40355 \$38891 NWELL PWELL BULK DFF_X1
X$91636 \$I179173 \$39901 \$39915 \$38891 NWELL PWELL BULK DFF_X1
X$91640 \$40781 \$40338 \$40342 \$38891 NWELL PWELL BULK DFF_X1
X$91642 \$I179086 \$43606 \$43361 \$38891 NWELL PWELL BULK DFF_X1
X$91644 \$I175333 \$40816 \$40787 \$38891 NWELL PWELL BULK DFF_X1
X$91647 \$I175319 \$38896 \$39406 \$38891 NWELL PWELL BULK DFF_X1
X$91649 \$I175306 \$41241 \$41263 \$38891 NWELL PWELL BULK DFF_X1
X$91652 \$39429 \$39920 \$39921 \$38891 NWELL PWELL BULK DFF_X1
X$91655 \$43612 \$44003 \$43682 \$38891 NWELL PWELL BULK DFF_X1
X$91657 \$43369 \$43368 \$43391 \$38891 NWELL PWELL BULK DFF_X1
X$91659 \$43028 \$43395 \$43396 \$38891 NWELL PWELL BULK DFF_X1
X$91662 \$42955 \$42649 \$43035 \$38891 NWELL PWELL BULK DFF_X1
X$91665 \$I178876 \$41581 \$41967 \$38891 NWELL PWELL BULK DFF_X1
X$91668 \$I178778 \$42977 \$42606 \$38891 NWELL PWELL BULK DFF_X1
X$91673 \$41938 \$41992 \$42000 \$38891 NWELL PWELL BULK DFF_X1
X$91676 \$I174357 \$41661 \$41664 \$38891 NWELL PWELL BULK DFF_X1
X$91679 \$I179084 \$42663 \$42679 \$38891 NWELL PWELL BULK DFF_X1
X$91681 \$I174432 \$41934 \$42319 \$38891 NWELL PWELL BULK DFF_X1
X$91684 \$41648 \$41238 \$41649 \$38891 NWELL PWELL BULK DFF_X1
X$91686 \$43015 \$42254 \$42641 \$38891 NWELL PWELL BULK DFF_X1
X$91689 \$41574 \$41935 \$42310 \$38891 NWELL PWELL BULK DFF_X1
X$91736 \$67193 \$42756 \$67095 \$43440 \$43349 \$38917 \$67952 NWELL PWELL
+ BULK OAI222_X2
X$91739 \$38917 \$43769 \$67660 NWELL PWELL BULK NOR2_X1
X$91760 \$42944 \$43595 \$43596 \$40298 \$38938 NWELL PWELL BULK OAI22_X2
X$91808 \$51793 \$38978 \$52280 \$52668 NWELL PWELL BULK AOI21_X2
X$91812 \$49955 \$38978 \$49960 \$50281 NWELL PWELL BULK AOI21_X2
X$91818 \$46576 \$38978 \$46021 \$46571 NWELL PWELL BULK AOI21_X2
X$91823 \$52681 \$38978 \$52292 \$52291 NWELL PWELL BULK AOI21_X2
X$91827 \$50538 \$38978 \$50539 \$50993 NWELL PWELL BULK AOI21_X2
X$91829 \$50817 \$38978 \$50674 \$51548 NWELL PWELL BULK AOI21_X1
X$91831 \$51767 \$38978 \$52247 \$52076 NWELL PWELL BULK AOI21_X1
X$91834 \$50825 \$38978 \$51013 \$51010 NWELL PWELL BULK AOI21_X2
X$91836 \$51446 \$38978 \$52262 \$52656 NWELL PWELL BULK AOI21_X2
X$91839 \$52488 \$38978 \$52626 \$52487 NWELL PWELL BULK AOI21_X2
X$91842 \$52216 \$38978 \$52228 \$52639 NWELL PWELL BULK AOI21_X2
X$91947 \$39669 \$39334 \$39061 \$39337 \$39648 \$39335 NWELL PWELL BULK
+ OAI221_X2
X$91960 \$57248 \$53989 \$39071 \$56873 NWELL PWELL BULK MUX2_X1
X$91963 \$56886 \$47751 \$39071 \$56888 NWELL PWELL BULK MUX2_X1
X$91966 \$39071 \$42849 \$56600 \$57252 NWELL PWELL BULK MUX2_X1
X$91969 \$39071 \$41977 \$57250 \$57484 NWELL PWELL BULK MUX2_X1
X$91987 \$41763 \$39339 \$42448 \$39087 NWELL PWELL BULK DFF_X2
X$91990 \$42555 \$39087 \$42212 NWELL PWELL BULK AND2_X1
X$92002 \$39099 \$40451 \$40448 \$40153 NWELL PWELL BULK AOI21_X1
X$92005 \$39099 \$39120 \$40070 NWELL PWELL BULK NOR2_X1
X$92011 \$40705 \$39099 \$39271 \$41386 \$40706 NWELL PWELL BULK OAI22_X1
X$92039 \$39271 \$39120 NWELL PWELL BULK INV_X1
X$92057 \$40202 \$39838 \$39839 \$39162 NWELL PWELL BULK MUX2_X1
X$92076 M1_AXI_AWID[1] \$39388 NWELL PWELL BULK CLKBUF_X2
X$92101 \$I177423 \$39237 \$40351 \$40671 NWELL PWELL BULK DFF_X1
X$92120 \$59951 \$53989 \$39258 \$60505 NWELL PWELL BULK MUX2_X1
X$92122 \$59374 \$47751 \$39258 \$59602 NWELL PWELL BULK MUX2_X1
X$92125 \$39258 \$42849 \$59378 \$59615 NWELL PWELL BULK MUX2_X1
X$92127 \$39258 \$41977 \$60329 \$60641 NWELL PWELL BULK MUX2_X1
X$92136 \$39605 \$39271 \$40451 NWELL PWELL BULK NAND2_X1
X$92170 \$39672 \$39296 \$39670 \$40538 NWELL PWELL BULK OAI21_X1
X$92172 \$39694 \$40548 \$39298 NWELL PWELL BULK NAND2_X1
X$92177 \$40183 \$39829 \$39298 \$40543 NWELL PWELL BULK OR3_X4
X$92192 \$39308 \$39304 \$39309 \$40198 NWELL PWELL BULK OAI21_X4
X$92204 \$40177 \$39308 \$40176 \$40720 NWELL PWELL BULK AOI21_X1
X$92206 \$40716 \$39308 \$40717 NWELL PWELL BULK NOR2_X1
X$92225 \$39316 \$39317 \$40612 NWELL PWELL BULK XOR2_X1
X$92227 \$39316 \$40050 NWELL PWELL BULK INV_X1
X$92230 \$41107 \$39752 \$I241086 \$39316 NWELL PWELL BULK HA_X1
X$92234 \$39842 \$39317 \$39318 \$40050 \$40206 NWELL PWELL BULK FA_X1
X$92237 \$39766 \$39318 \$39319 NWELL PWELL BULK NOR2_X1
X$92243 \$39319 \$39842 \$39766 \$39843 NWELL PWELL BULK AOI21_X1
X$92275 \$41186 \$39335 \$39851 \$40644 NWELL PWELL BULK AOI21_X1
X$92277 \$39335 \$41186 \$41461 \$41529 NWELL PWELL BULK MUX2_X1
X$92290 \$39336 \$39648 NWELL PWELL BULK INV_X1
X$92294 \$47216 \$47218 \$47805 \$39339 NWELL PWELL BULK DFF_X1
X$92296 \$I174878 \$46069 \$46470 \$39339 NWELL PWELL BULK DFF_X1
X$92299 \$44277 \$44597 \$44859 \$39339 NWELL PWELL BULK DFF_X1
X$92302 \$I176800 \$45286 \$45603 \$39339 NWELL PWELL BULK DFF_X1
X$92305 \$I178644 \$45699 \$45696 \$39339 NWELL PWELL BULK DFF_X1
X$92307 \$I178640 \$46469 \$46681 \$39339 NWELL PWELL BULK DFF_X1
X$92309 \$44176 \$39339 \$I245697 \$43966 NWELL PWELL BULK DFF_X2
X$92312 \$I174870 \$44601 \$44278 \$39339 NWELL PWELL BULK DFF_X1
X$92315 \$I175212 \$45700 \$45287 \$39339 NWELL PWELL BULK DFF_X1
X$92317 \$44279 \$39339 \$I245646 \$44493 NWELL PWELL BULK DFF_X2
X$92320 \$I175289 \$44604 \$44279 \$39339 NWELL PWELL BULK DFF_X1
X$92322 \$44533 \$39339 \$I245560 \$43314 NWELL PWELL BULK DFF_X2
X$92324 \$45287 \$39339 \$I245525 \$43978 NWELL PWELL BULK DFF_X2
X$92326 \$46473 \$39339 \$I245643 \$46475 NWELL PWELL BULK DFF_X2
X$92328 \$I174936 \$45710 \$45928 \$39339 NWELL PWELL BULK DFF_X1
X$92330 \$45145 \$39339 \$44814 \$44822 NWELL PWELL BULK DFF_X2
X$92332 \$45573 \$39339 \$I245705 \$43898 NWELL PWELL BULK DFF_X2
X$92335 \$41543 \$39339 \$I245552 \$41545 NWELL PWELL BULK DFF_X2
X$92337 \$42815 \$39339 \$42552 \$42555 NWELL PWELL BULK DFF_X2
X$92339 \$41548 \$39339 \$I245687 \$41746 NWELL PWELL BULK DFF_X2
X$92341 \$41749 \$39339 \$I245548 \$41546 NWELL PWELL BULK DFF_X2
X$92346 \$42096 \$39339 \$I245725 \$41905 NWELL PWELL BULK DFF_X2
X$92348 \$I178588 \$42437 \$42557 \$39339 NWELL PWELL BULK DFF_X1
X$92351 \$41735 \$39339 \$41730 \$41916 NWELL PWELL BULK DFF_X2
X$92356 \$41906 \$39339 \$I245524 \$41907 NWELL PWELL BULK DFF_X2
X$92360 \$43861 \$39339 \$I245573 \$43310 NWELL PWELL BULK DFF_X2
X$92362 \$43461 \$39339 \$I245566 \$42798 NWELL PWELL BULK DFF_X2
X$92388 \$39347 \$40551 \$40554 \$40218 NWELL PWELL BULK HA_X1
X$92399 \$39873 \$39556 \$39354 \$39355 NWELL PWELL BULK DFF_X1
X$92401 \$43585 \$43584 \$44119 \$39355 NWELL PWELL BULK DFF_X1
X$92403 \$43343 \$43345 \$43346 \$39355 NWELL PWELL BULK DFF_X1
X$92406 \$44115 \$43586 \$44440 \$39355 NWELL PWELL BULK DFF_X1
X$92408 \$43099 \$43103 \$43096 \$39355 NWELL PWELL BULK DFF_X1
X$92410 \$42943 \$43081 \$43087 \$39355 NWELL PWELL BULK DFF_X1
X$92413 \$42365 \$42238 \$42364 \$39355 NWELL PWELL BULK DFF_X1
X$92416 \$41685 \$41346 \$41689 \$39355 NWELL PWELL BULK DFF_X1
X$92418 \$42358 \$41926 \$42047 \$39355 NWELL PWELL BULK DFF_X1
X$92420 \$42594 \$42245 \$42596 \$39355 NWELL PWELL BULK DFF_X1
X$92423 \$42702 \$42246 \$42345 \$39355 NWELL PWELL BULK DFF_X1
X$92425 \$42739 \$41919 \$42062 \$39355 NWELL PWELL BULK DFF_X1
X$92428 \$42383 \$42231 \$42748 \$39355 NWELL PWELL BULK DFF_X1
X$92431 \$42373 \$42722 \$42585 \$39355 NWELL PWELL BULK DFF_X1
X$92435 \$I176276 \$43843 \$43334 \$39355 NWELL PWELL BULK DFF_X1
X$92438 \$43332 \$43438 \$42745 \$39355 NWELL PWELL BULK DFF_X1
X$92440 \$42933 \$42743 \$42577 \$39355 NWELL PWELL BULK DFF_X1
X$92443 \$41364 \$41212 \$41360 \$39355 NWELL PWELL BULK DFF_X1
X$92445 \$41367 \$40981 \$40982 \$39355 NWELL PWELL BULK DFF_X1
X$92448 \$41692 \$41353 \$41690 \$39355 NWELL PWELL BULK DFF_X1
X$92451 \$42234 \$42068 \$42071 \$39355 NWELL PWELL BULK DFF_X1
X$92453 \$41040 \$41405 \$41408 \$39355 NWELL PWELL BULK DFF_X1
X$92455 \$43088 \$42241 \$42355 \$39355 NWELL PWELL BULK DFF_X1
X$92457 \$I178303 \$39877 \$39547 \$39355 NWELL PWELL BULK DFF_X1
X$92459 \$I177790 \$43340 \$43338 \$39355 NWELL PWELL BULK DFF_X1
X$92461 \$41922 \$42053 \$42059 \$39355 NWELL PWELL BULK DFF_X1
X$92463 \$42736 \$42376 \$42375 \$39355 NWELL PWELL BULK DFF_X1
X$92465 \$I176346 \$42937 \$43118 \$39355 NWELL PWELL BULK DFF_X1
X$92468 \$40454 \$39961 \$39871 \$39355 NWELL PWELL BULK DFF_X1
X$92471 \$I175611 \$40234 \$39874 \$39355 NWELL PWELL BULK DFF_X1
X$92505 M1_AXI_WID[3] \$39365 NWELL PWELL BULK BUF_X1
X$92522 M1_AXI_WID[2] \$39371 NWELL PWELL BULK BUF_X1
X$92567 \$39421 \$42849 \$42850 \$43016 NWELL PWELL BULK MUX2_X1
X$92569 \$43003 \$42511 \$39421 \$43410 NWELL PWELL BULK MUX2_X1
X$92571 \$39421 \$41977 \$41987 \$41986 NWELL PWELL BULK MUX2_X1
X$92574 \$42508 \$42506 \$39421 \$42290 NWELL PWELL BULK MUX2_X1
X$92583 \$46624 \$46082 \$39427 \$46628 NWELL PWELL BULK MUX2_X1
X$92585 \$39427 \$46512 \$46963 \$47242 NWELL PWELL BULK MUX2_X1
X$92587 \$39427 \$46090 \$46270 \$46263 NWELL PWELL BULK MUX2_X1
X$92589 \$39427 \$46524 \$46620 \$46621 NWELL PWELL BULK MUX2_X1
X$92610 \$56308 \$47751 \$39433 \$55597 NWELL PWELL BULK MUX2_X1
X$92613 \$39433 \$42849 \$55604 \$55601 NWELL PWELL BULK MUX2_X1
X$92616 \$39433 \$41977 \$57426 \$57425 NWELL PWELL BULK MUX2_X1
X$92619 \$57233 \$53989 \$39433 \$57672 NWELL PWELL BULK MUX2_X1
X$92675 \$40341 \$39485 \$39970 \$40671 NWELL PWELL BULK DFF_X1
X$92718 \$62171 \$61799 \$39545 \$62405 NWELL PWELL BULK MUX2_X1
X$92720 \$62173 \$61102 \$39545 \$62418 NWELL PWELL BULK MUX2_X1
X$92723 \$63070 \$63355 \$39545 \$62785 NWELL PWELL BULK MUX2_X1
X$92725 \$63610 \$62784 \$39545 \$63605 NWELL PWELL BULK MUX2_X1
X$92746 \$41708 \$41559 \$39549 NWELL PWELL BULK NOR2_X2
X$92762 \$39564 \$41977 \$55442 \$56870 NWELL PWELL BULK MUX2_X1
X$92764 \$55778 \$47751 \$39564 \$56514 NWELL PWELL BULK MUX2_X1
X$92766 \$39564 \$42849 \$55779 \$55445 NWELL PWELL BULK MUX2_X1
X$92768 \$55625 \$53989 \$39564 \$56007 NWELL PWELL BULK MUX2_X1
X$92791 \$64964 \$61102 \$39571 \$64965 NWELL PWELL BULK MUX2_X1
X$92794 \$66690 \$63355 \$39571 \$67215 NWELL PWELL BULK MUX2_X1
X$92796 \$65562 \$61799 \$39571 \$65750 NWELL PWELL BULK MUX2_X1
X$92798 \$66262 \$62784 \$39571 \$66692 NWELL PWELL BULK MUX2_X1
X$92860 \$42137 \$41826 \$40215 \$41531 \$39683 \$41808 NWELL PWELL BULK
+ OAI221_X1
X$92879 \$43558 \$43323 \$39694 NWELL PWELL BULK AND2_X2
X$92922 \$39752 \$39838 NWELL PWELL BULK INV_X2
X$92931 \$41110 \$39838 \$39766 \$I241585 NWELL PWELL BULK HA_X1
X$92937 \$40620 \$39766 \$40206 \$40207 NWELL PWELL BULK MUX2_X1
X$92940 \$40612 \$39766 \$40613 NWELL PWELL BULK NOR2_X1
X$92962 M0_AXI_AWADDR[10] \$39788 NWELL PWELL BULK BUF_X1
X$92977 \$69823 \$62350 \$39797 \$70589 NWELL PWELL BULK MUX2_X1
X$92979 \$69193 \$63210 \$39797 \$68962 NWELL PWELL BULK MUX2_X1
X$92981 \$68399 \$63530 \$39797 \$68574 NWELL PWELL BULK MUX2_X1
X$92984 \$69589 \$61075 \$39797 \$70040 NWELL PWELL BULK MUX2_X1
X$93002 \$39806 \$39808 \$39817 \$40156 NWELL PWELL BULK OAI21_X1
X$93031 \$40162 \$40163 \$39817 \$40487 NWELL PWELL BULK OAI21_X1
X$93034 \$40487 \$40712 \$40996 \$40170 \$39821 NWELL PWELL BULK OAI22_X1
X$93087 \$41781 \$39838 \$41168 \$41779 NWELL PWELL BULK MUX2_X1
X$93089 \$41168 \$39838 \$41108 \$41171 NWELL PWELL BULK MUX2_X1
X$93091 \$41516 \$39838 \$41173 \$41518 NWELL PWELL BULK MUX2_X1
X$93095 \$40730 \$39838 \$40202 \$40600 NWELL PWELL BULK MUX2_X1
X$93097 \$39838 \$41453 \$41456 NWELL PWELL BULK NAND2_X1
X$93109 \$39841 \$41865 NWELL PWELL BULK INV_X2
X$93112 \$39841 \$40613 \$40203 NWELL PWELL BULK XNOR2_X1
X$93148 \$39853 \$41829 \$42139 NWELL PWELL BULK OR2_X1
X$93170 \$39855 \$40615 NWELL PWELL BULK INV_X1
X$93183 \$39865 \$40221 NWELL PWELL BULK INV_X1
X$93204 \$40383 \$40231 \$39883 \$39881 NWELL PWELL BULK MUX2_X1
X$93207 \$40383 \$40496 \$39882 \$40242 NWELL PWELL BULK MUX2_X1
X$93210 \$39882 \$39971 \$39883 \$40244 NWELL PWELL BULK MUX2_X1
X$93232 M1_AXI_WDATA[19] \$39896 NWELL PWELL BULK BUF_X1
X$93249 S0_AXI_RID[6] \$40289 NWELL PWELL BULK CLKBUF_X3
X$93292 \$66816 \$42756 \$66042 \$43440 \$43349 \$39941 \$67074 NWELL PWELL
+ BULK OAI222_X2
X$93294 \$39941 \$43769 \$67229 NWELL PWELL BULK NOR2_X1
X$93317 \$68946 \$39959 \$69383 \$63553 NWELL PWELL BULK MUX2_X1
X$93320 \$48838 \$39959 \$49281 \$48719 NWELL PWELL BULK MUX2_X1
X$93322 \$44081 \$39959 \$44320 \$44064 NWELL PWELL BULK MUX2_X1
X$93325 \$69390 \$39959 \$69678 \$69310 NWELL PWELL BULK MUX2_X1
X$93328 \$59104 \$39959 \$58228 \$58174 NWELL PWELL BULK MUX2_X1
X$93330 \$64088 \$39959 \$64442 \$60800 NWELL PWELL BULK MUX2_X1
X$93332 \$65266 \$39959 \$65081 \$65208 NWELL PWELL BULK MUX2_X1
X$93334 \$62286 \$39959 \$62481 \$62353 NWELL PWELL BULK MUX2_X1
X$93336 \$52595 \$39959 \$52959 \$52640 NWELL PWELL BULK MUX2_X1
X$93338 \$66820 \$39959 \$66041 \$66409 NWELL PWELL BULK MUX2_X1
X$93340 \$48277 \$39959 \$48671 \$48751 NWELL PWELL BULK MUX2_X1
X$93342 \$52164 \$39959 \$51675 \$52241 NWELL PWELL BULK MUX2_X1
X$93345 \$42252 \$39959 \$42666 \$42632 NWELL PWELL BULK MUX2_X1
X$93348 \$44326 \$39959 \$43608 \$44354 NWELL PWELL BULK MUX2_X1
X$93350 \$56729 \$39959 \$56459 \$55938 NWELL PWELL BULK MUX2_X1
X$93352 \$59074 \$39959 \$58539 \$58189 NWELL PWELL BULK MUX2_X1
X$93355 \$60829 \$39959 \$60759 \$60784 NWELL PWELL BULK MUX2_X1
X$93358 \$63173 \$39959 \$62283 \$63537 NWELL PWELL BULK MUX2_X1
X$93361 \$60845 \$39959 \$60756 \$60807 NWELL PWELL BULK MUX2_X1
X$93366 \$39959 \$41352 NWELL PWELL BULK BUF_X16
X$93374 \$42251 \$39959 \$43405 \$43008 NWELL PWELL BULK MUX2_X1
X$93429 \$68658 \$39971 \$68479 \$68866 NWELL PWELL BULK MUX2_X1
X$93432 \$67933 \$39971 \$67545 \$67932 NWELL PWELL BULK MUX2_X1
X$93435 \$68860 \$39971 \$68473 \$69663 NWELL PWELL BULK MUX2_X1
X$93437 \$69933 \$39971 \$70211 \$70213 NWELL PWELL BULK MUX2_X1
X$93439 \$67037 \$39971 \$67635 \$68265 NWELL PWELL BULK MUX2_X1
X$93441 \$63461 \$39971 \$64409 \$65433 NWELL PWELL BULK MUX2_X1
X$93444 \$65055 \$39971 \$64764 \$65918 NWELL PWELL BULK MUX2_X1
X$93447 \$61879 \$39971 \$61216 \$63151 NWELL PWELL BULK MUX2_X1
X$93450 \$56703 \$39971 \$57085 \$56704 NWELL PWELL BULK MUX2_X1
X$93453 \$47578 \$39971 \$47580 \$47744 NWELL PWELL BULK MUX2_X1
X$93456 \$40948 \$39971 \$41224 \$41225 NWELL PWELL BULK MUX2_X1
X$93459 \$40770 \$39971 \$40239 \$40385 NWELL PWELL BULK MUX2_X1
X$93461 \$41661 \$39971 \$41651 \$42252 NWELL PWELL BULK MUX2_X1
X$93465 \$41228 \$39971 \$40772 \$41230 NWELL PWELL BULK MUX2_X1
X$93467 \$53786 \$39971 \$54261 \$52941 NWELL PWELL BULK MUX2_X1
X$93469 \$42024 \$39971 \$42250 \$42251 NWELL PWELL BULK MUX2_X1
X$93472 \$53784 \$39971 \$54108 \$53872 NWELL PWELL BULK MUX2_X1
X$93474 \$67639 \$39971 \$67519 \$68227 NWELL PWELL BULK MUX2_X1
X$93477 \$68869 \$39971 \$67938 \$69290 NWELL PWELL BULK MUX2_X1
X$93479 \$52716 \$39971 \$52586 \$52940 NWELL PWELL BULK MUX2_X1
X$93481 \$52938 \$39971 \$52152 \$53533 NWELL PWELL BULK MUX2_X1
X$93483 \$50906 \$39971 \$50208 \$50729 NWELL PWELL BULK MUX2_X1
X$93486 \$46325 \$39971 \$46081 \$47745 NWELL PWELL BULK MUX2_X1
X$93488 \$51912 \$39971 \$49885 \$51193 NWELL PWELL BULK MUX2_X1
X$93490 \$39971 \$48275 NWELL PWELL BULK BUF_X16
X$93492 \$55655 \$39971 \$56406 \$56407 NWELL PWELL BULK MUX2_X1
X$93494 \$56707 \$39971 \$57343 \$57880 NWELL PWELL BULK MUX2_X1
X$93496 \$44083 \$39971 \$44319 \$44320 NWELL PWELL BULK MUX2_X1
X$93498 \$44323 \$39971 \$44406 \$44326 NWELL PWELL BULK MUX2_X1
X$93500 \$67636 \$39971 \$67042 \$67742 NWELL PWELL BULK MUX2_X1
X$93502 \$63455 \$39971 \$62762 \$63459 NWELL PWELL BULK MUX2_X1
X$93505 \$56697 \$39971 \$56698 \$57140 NWELL PWELL BULK MUX2_X1
X$93507 \$57339 \$39971 \$57895 \$57549 NWELL PWELL BULK MUX2_X1
X$93509 \$55103 \$39971 \$55104 \$56396 NWELL PWELL BULK MUX2_X1
X$93511 \$54094 \$39971 \$52929 \$54557 NWELL PWELL BULK MUX2_X1
X$93513 \$54092 \$39971 \$53257 \$54093 NWELL PWELL BULK MUX2_X1
X$93515 \$43606 \$39971 \$43607 \$43608 NWELL PWELL BULK MUX2_X1
X$93517 \$43744 \$39971 \$43355 \$44081 NWELL PWELL BULK MUX2_X1
X$93519 \$42663 \$39971 \$41934 \$42666 NWELL PWELL BULK MUX2_X1
X$93521 \$43357 \$39971 \$43359 \$43405 NWELL PWELL BULK MUX2_X1
X$93579 \$44323 \$39972 \$43600 \$44402 NWELL PWELL BULK MUX2_X1
X$93581 \$40948 \$39972 \$40764 \$41326 NWELL PWELL BULK MUX2_X1
X$93583 \$41228 \$39972 \$40383 \$41299 NWELL PWELL BULK MUX2_X1
X$93585 \$43744 \$39972 \$43593 \$43746 NWELL PWELL BULK MUX2_X1
X$93587 \$42024 \$39972 \$42248 \$42333 NWELL PWELL BULK MUX2_X1
X$93589 \$41661 \$39972 \$41234 \$41664 NWELL PWELL BULK MUX2_X1
X$93592 \$42346 \$39972 NWELL PWELL BULK BUF_X8
X$93595 \$42378 \$39972 NWELL PWELL BULK BUF_X8
X$93695 \$40091 \$40208 \$41120 NWELL PWELL BULK XNOR2_X1
X$93715 \$46457 \$43956 \$40110 \$46701 NWELL PWELL BULK MUX2_X1
X$93718 \$40110 \$41977 \$46388 \$46708 NWELL PWELL BULK MUX2_X1
X$93721 \$40110 \$42849 \$45268 \$45269 NWELL PWELL BULK MUX2_X1
X$93723 \$45584 \$44584 \$40110 \$45578 NWELL PWELL BULK MUX2_X1
X$93731 M0_AXI_AWID[3] \$41254 NWELL PWELL BULK CLKBUF_X2
X$93757 \$40672 \$40323 \$40131 \$40671 NWELL PWELL BULK DFF_X1
X$93761 M0_AXI_AWADDR[16] \$40142 NWELL PWELL BULK BUF_X1
X$93796 \$40164 \$40709 \$40710 \$40483 NWELL PWELL BULK AOI21_X1
X$93803 \$40711 \$40170 \$40997 \$41392 NWELL PWELL BULK OAI21_X1
X$93810 \$40720 \$40172 \$41398 NWELL PWELL BULK OR2_X1
X$93823 \$40188 \$41755 NWELL PWELL BULK INV_X1
X$93826 \$56931 \$56607 \$50040 \$40188 NWELL PWELL BULK MUX2_X2
X$93844 \$40198 \$43295 \$43533 NWELL PWELL BULK NAND2_X1
X$93846 \$40198 \$42897 \$42896 NWELL PWELL BULK NAND2_X1
X$93848 \$40198 \$43839 \$43835 NWELL PWELL BULK NAND2_X1
X$93851 \$40198 \$41880 \$42468 NWELL PWELL BULK NAND2_X1
X$93854 \$40198 \$43216 \$41519 \$I241581 NWELL PWELL BULK HA_X1
X$93857 \$40198 \$42200 NWELL PWELL BULK INV_X4
X$93860 \$40198 \$43959 \$43960 NWELL PWELL BULK NAND2_X1
X$93863 \$43959 \$43295 \$40198 \$43956 NWELL PWELL BULK NOR3_X4
X$93866 \$43535 \$43295 \$40198 \$44584 NWELL PWELL BULK NOR3_X4
X$93877 \$49847 \$40200 \$49849 \$41436 \$50089 NWELL PWELL BULK AOI22_X1
X$93879 \$49845 \$40200 \$49737 \$41436 \$49739 NWELL PWELL BULK AOI22_X1
X$93882 \$49497 \$40200 \$49498 \$41436 \$49500 NWELL PWELL BULK AOI22_X1
X$93885 \$49839 \$40200 \$41436 \$49492 \$46329 NWELL PWELL BULK AOI22_X2
X$93889 \$41162 \$40200 \$41755 \$41436 \$41424 NWELL PWELL BULK AOI22_X1
X$93892 \$48604 \$40200 \$48605 \$41436 \$48218 NWELL PWELL BULK AOI22_X1
X$93894 \$49512 \$40200 \$49513 \$41436 \$49514 NWELL PWELL BULK AOI22_X1
X$93896 \$49857 \$40200 \$50117 \$41436 \$50105 NWELL PWELL BULK AOI22_X1
X$93898 \$46055 \$40200 \$46057 \$41436 \$46454 NWELL PWELL BULK AOI22_X1
X$93902 \$45260 \$40200 \$45261 \$41436 \$45565 NWELL PWELL BULK AOI22_X1
X$93904 \$47874 \$40200 \$41436 \$47876 \$44906 NWELL PWELL BULK AOI22_X2
X$93906 \$48602 \$40200 \$48213 \$41436 \$48524 NWELL PWELL BULK AOI22_X1
X$93921 \$40202 \$41168 \$41108 \$41453 NWELL PWELL BULK HA_X1
X$93938 \$41803 \$41519 \$40208 NWELL PWELL BULK NOR2_X1
X$93943 \$41524 \$41888 \$I241025 \$40211 NWELL PWELL BULK HA_X1
X$93946 \$41183 \$41526 \$40211 \$41461 NWELL PWELL BULK NOR3_X1
X$93951 \$40211 \$41527 \$40633 \$41893 \$41829 NWELL PWELL BULK AOI22_X4
X$94000 M1_AXI_WDATA[8] \$40228 NWELL PWELL BULK CLKBUF_X2
X$94011 \$43593 \$40231 \$44319 \$44725 NWELL PWELL BULK MUX2_X1
X$94013 \$48029 \$40231 \$48678 \$49277 NWELL PWELL BULK MUX2_X1
X$94016 \$67647 \$40231 \$67944 \$68173 NWELL PWELL BULK MUX2_X1
X$94019 \$67065 \$40231 \$68189 \$67725 NWELL PWELL BULK MUX2_X1
X$94022 \$67550 \$40231 \$68473 \$68861 NWELL PWELL BULK MUX2_X1
X$94025 \$66745 \$40231 \$68479 \$68650 NWELL PWELL BULK MUX2_X1
X$94028 \$67038 \$40231 \$67042 \$67740 NWELL PWELL BULK MUX2_X1
X$94033 \$55880 \$40231 \$60754 \$61450 NWELL PWELL BULK MUX2_X1
X$94035 \$61904 \$40231 \$62868 \$62935 NWELL PWELL BULK MUX2_X1
X$94038 \$52176 \$40231 \$60440 \$60823 NWELL PWELL BULK MUX2_X1
X$94040 \$58535 \$40231 \$58538 \$58972 NWELL PWELL BULK MUX2_X1
X$94043 \$46559 \$40231 \$61903 \$61429 NWELL PWELL BULK MUX2_X1
X$94045 \$53056 \$40231 \$55104 \$56235 NWELL PWELL BULK MUX2_X1
X$94047 \$45882 \$40231 \$47580 \$47747 NWELL PWELL BULK MUX2_X1
X$94049 \$43600 \$40231 \$43607 \$43605 NWELL PWELL BULK MUX2_X1
X$94051 \$53272 \$40231 \$54261 \$55269 NWELL PWELL BULK MUX2_X1
X$94054 \$50741 \$40231 \$57085 \$57091 NWELL PWELL BULK MUX2_X1
X$94057 \$46492 \$40231 \$56406 \$57056 NWELL PWELL BULK MUX2_X1
X$94062 \$50457 \$40231 \$49885 \$50454 NWELL PWELL BULK MUX2_X1
X$94064 \$51372 \$40231 \$66372 \$66112 NWELL PWELL BULK MUX2_X1
X$94066 \$67936 \$40231 \$70211 \$69934 NWELL PWELL BULK MUX2_X1
X$94070 \$68488 \$40231 \$69672 \$70171 NWELL PWELL BULK MUX2_X1
X$94072 \$47668 \$40231 \$65663 \$65757 NWELL PWELL BULK MUX2_X1
X$94075 \$67074 \$40231 \$67078 \$67653 NWELL PWELL BULK MUX2_X1
X$94077 \$67952 \$40231 \$69308 \$69946 NWELL PWELL BULK MUX2_X1
X$94079 \$67949 \$40231 \$69677 \$69945 NWELL PWELL BULK MUX2_X1
X$94081 \$52345 \$40231 \$52152 \$52584 NWELL PWELL BULK MUX2_X1
X$94083 \$63475 \$40231 \$63975 \$64775 NWELL PWELL BULK MUX2_X1
X$94085 \$47926 \$40231 \$48278 \$48394 NWELL PWELL BULK MUX2_X1
X$94088 \$50228 \$40231 \$50927 \$51080 NWELL PWELL BULK MUX2_X1
X$94091 \$51814 \$40231 \$53383 \$53794 NWELL PWELL BULK MUX2_X1
X$94093 \$58115 \$40231 \$64409 \$64867 NWELL PWELL BULK MUX2_X1
X$94096 \$48098 \$40231 \$52929 \$52928 NWELL PWELL BULK MUX2_X1
X$94098 \$61212 \$40231 \$61216 \$61215 NWELL PWELL BULK MUX2_X1
X$94101 \$56728 \$40231 \$55895 \$55616 NWELL PWELL BULK MUX2_X1
X$94103 \$58137 \$40231 \$58139 \$58963 NWELL PWELL BULK MUX2_X1
X$94105 \$63979 \$40231 \$64110 \$64108 NWELL PWELL BULK MUX2_X1
X$94107 \$64531 \$40231 \$65239 \$65083 NWELL PWELL BULK MUX2_X1
X$94109 \$59494 \$40231 \$64436 \$64437 NWELL PWELL BULK MUX2_X1
X$94111 \$40764 \$40231 \$40239 \$40928 NWELL PWELL BULK MUX2_X1
X$94113 \$42248 \$40231 \$43359 \$43403 NWELL PWELL BULK MUX2_X1
X$94116 \$41234 \$40231 \$41934 \$42319 NWELL PWELL BULK MUX2_X1
X$94190 M1_AXI_WDATA[14] \$40235 NWELL PWELL BULK BUF_X1
X$94230 \$42296 \$42604 \$40252 NWELL PWELL BULK NOR2_X1
X$94247 S0_AXI_RID[4] \$41242 NWELL PWELL BULK CLKBUF_X3
X$94252 S0_AXI_RID[7] \$40819 NWELL PWELL BULK CLKBUF_X3
X$94275 \$40289 \$55498 \$57326 \$57583 NWELL PWELL BULK MUX2_X1
X$94277 \$40289 \$56680 \$57324 \$57930 NWELL PWELL BULK MUX2_X1
X$94279 \$40289 \$54550 \$55095 \$55380 NWELL PWELL BULK MUX2_X1
X$94281 \$55382 \$55501 \$40289 \$55381 NWELL PWELL BULK MUX2_X1
X$94298 \$71818 \$61075 \$40297 \$71972 NWELL PWELL BULK MUX2_X1
X$94300 \$71817 \$63057 \$40297 \$72208 NWELL PWELL BULK MUX2_X1
X$94302 \$70780 \$63530 \$40297 \$70896 NWELL PWELL BULK MUX2_X1
X$94305 \$70779 \$62181 \$40297 \$70556 NWELL PWELL BULK MUX2_X1
X$94316 \$41552 \$42223 \$42074 \$40298 NWELL PWELL BULK NAND3_X4
X$94318 \$42944 \$66760 \$40298 \$67069 \$65077 NWELL PWELL BULK OAI22_X1
X$94320 \$42944 \$66751 \$40298 \$66551 \$62009 NWELL PWELL BULK OAI22_X1
X$94322 \$42944 \$66612 \$66349 \$40298 \$61881 NWELL PWELL BULK OAI22_X2
X$94325 \$42944 \$67054 \$40298 \$66747 \$65063 NWELL PWELL BULK OAI22_X1
X$94328 \$42944 \$67193 \$40298 \$67095 \$60812 NWELL PWELL BULK OAI22_X1
X$94331 \$42944 \$66816 \$40298 \$66042 \$64789 NWELL PWELL BULK OAI22_X1
X$94333 \$42944 \$66825 \$40298 \$66768 \$64096 NWELL PWELL BULK OAI22_X1
X$94335 \$42944 \$50221 \$40298 \$50392 \$50399 NWELL PWELL BULK OAI22_X1
X$94337 \$42944 \$55531 \$40298 \$55870 \$55629 NWELL PWELL BULK OAI22_X1
X$94339 \$42944 \$53787 \$40298 \$52947 \$53034 NWELL PWELL BULK OAI22_X1
X$94343 \$42944 \$48258 \$40298 \$48654 \$44944 NWELL PWELL BULK OAI22_X1
X$94347 \$42944 \$52145 \$40298 \$52579 \$52733 NWELL PWELL BULK OAI22_X1
X$94351 \$42944 \$53777 \$40298 \$53778 \$53557 NWELL PWELL BULK OAI22_X1
X$94353 \$42944 \$50737 \$49535 \$40298 \$41708 NWELL PWELL BULK OAI22_X2
X$94355 \$42944 \$65631 \$64767 \$40298 \$65404 NWELL PWELL BULK OAI22_X2
X$94359 \$42944 \$60735 \$40298 \$60736 \$57747 NWELL PWELL BULK OAI22_X1
X$94361 \$42944 \$63155 \$40298 \$60427 \$62976 NWELL PWELL BULK OAI22_X1
X$94364 \$42944 \$58134 \$40298 \$57356 \$57358 NWELL PWELL BULK OAI22_X1
X$94367 \$42944 \$57740 \$40298 \$57341 \$56401 NWELL PWELL BULK OAI22_X1
X$94369 \$42944 \$47932 \$40298 \$48286 \$48366 NWELL PWELL BULK OAI22_X1
X$94375 \$42944 \$50230 \$40298 \$50231 \$50683 NWELL PWELL BULK OAI22_X1
X$94383 \$42944 \$47603 \$40298 \$47264 \$42296 NWELL PWELL BULK OAI22_X1
X$94389 \$42944 \$46350 \$40298 \$46354 \$44943 NWELL PWELL BULK OAI22_X1
X$94393 \$42944 \$50936 \$40298 \$50938 \$51017 NWELL PWELL BULK OAI22_X1
X$94395 \$42944 \$54582 \$40298 \$54125 \$54720 NWELL PWELL BULK OAI22_X1
X$94399 \$42944 \$58552 \$40298 \$58151 \$58555 NWELL PWELL BULK OAI22_X1
X$94401 \$42944 \$64138 \$40298 \$64425 \$63481 NWELL PWELL BULK OAI22_X1
X$94404 \$42944 \$56425 \$40298 \$55904 \$55141 NWELL PWELL BULK OAI22_X1
X$94406 \$42944 \$58146 \$40298 \$57804 \$55905 NWELL PWELL BULK OAI22_X1
X$94408 \$42944 \$64808 \$40298 \$64447 \$61958 NWELL PWELL BULK OAI22_X1
X$94411 \$42944 \$62908 \$40298 \$62296 \$55953 NWELL PWELL BULK OAI22_X1
X$94417 \$42944 \$40298 \$42959 NWELL PWELL BULK NAND2_X1
X$94421 \$42944 \$43609 \$40298 \$43610 \$43399 NWELL PWELL BULK OAI22_X1
X$94526 \$40318 \$43769 \$63203 NWELL PWELL BULK NOR2_X1
X$94540 \$62908 \$42756 \$62296 \$43440 \$43349 \$40318 \$61904 NWELL PWELL
+ BULK OAI222_X2
X$94565 \$72212 \$61075 \$40337 \$72211 NWELL PWELL BULK MUX2_X1
X$94567 \$71071 \$63530 \$40337 \$71610 NWELL PWELL BULK MUX2_X1
X$94570 \$71978 \$63057 \$40337 \$72356 NWELL PWELL BULK MUX2_X1
X$94572 \$71070 \$62181 \$40337 \$72525 NWELL PWELL BULK MUX2_X1
X$94592 \$40344 \$40871 \$40675 \$40671 NWELL PWELL BULK DFF_X1
X$94610 \$I174368 \$40358 \$40892 \$40671 NWELL PWELL BULK DFF_X1
X$94615 \$64082 \$63355 \$40362 \$64074 NWELL PWELL BULK MUX2_X1
X$94617 \$64060 \$61075 \$40362 \$63573 NWELL PWELL BULK MUX2_X1
X$94620 \$64503 \$62784 \$40362 \$65165 NWELL PWELL BULK MUX2_X1
X$94622 \$64341 \$62350 \$40362 \$64834 NWELL PWELL BULK MUX2_X1
X$94649 \$40378 \$41977 \$57680 \$58223 NWELL PWELL BULK MUX2_X1
X$94651 \$58396 \$47751 \$40378 \$59071 NWELL PWELL BULK MUX2_X1
X$94653 \$57678 \$53989 \$40378 \$58215 NWELL PWELL BULK MUX2_X1
X$94656 \$40378 \$42849 \$59594 \$59593 NWELL PWELL BULK MUX2_X1
X$94666 \$48576 \$42511 \$40379 \$48827 NWELL PWELL BULK MUX2_X1
X$94668 \$40379 \$41977 \$49478 \$51071 NWELL PWELL BULK MUX2_X1
X$94670 \$50154 \$42506 \$40379 \$50023 NWELL PWELL BULK MUX2_X1
X$94672 \$40379 \$42849 \$48188 \$48830 NWELL PWELL BULK MUX2_X1
X$94686 \$40383 \$40504 \$40772 \$40771 NWELL PWELL BULK MUX2_X1
X$94700 \$64695 \$61799 \$40391 \$64855 NWELL PWELL BULK MUX2_X1
X$94703 \$64694 \$61102 \$40391 \$65205 NWELL PWELL BULK MUX2_X1
X$94706 \$66259 \$63355 \$40391 \$66104 NWELL PWELL BULK MUX2_X1
X$94709 \$65561 \$62784 \$40391 \$66108 NWELL PWELL BULK MUX2_X1
X$94750 \$40434 \$41977 \$61097 \$61990 NWELL PWELL BULK MUX2_X1
X$94753 \$61096 \$53989 \$40434 \$61378 NWELL PWELL BULK MUX2_X1
X$94755 \$60877 \$47751 \$40434 \$60135 NWELL PWELL BULK MUX2_X1
X$94757 \$40434 \$42849 \$59627 \$59379 NWELL PWELL BULK MUX2_X1
X$94811 \$43593 \$40496 \$44083 \$44089 NWELL PWELL BULK MUX2_X1
X$94813 \$48029 \$40496 \$49200 \$48677 NWELL PWELL BULK MUX2_X1
X$94816 \$68488 \$40496 \$69414 \$69724 NWELL PWELL BULK MUX2_X1
X$94819 \$67065 \$40496 \$68873 \$69292 NWELL PWELL BULK MUX2_X1
X$94822 \$67936 \$40496 \$69933 \$70252 NWELL PWELL BULK MUX2_X1
X$94824 \$67038 \$40496 \$67636 \$67745 NWELL PWELL BULK MUX2_X1
X$94827 \$56728 \$40496 \$56890 \$56461 NWELL PWELL BULK MUX2_X1
X$94831 \$63979 \$40496 \$64431 \$64558 NWELL PWELL BULK MUX2_X1
X$94834 \$59494 \$40496 \$64105 \$64541 NWELL PWELL BULK MUX2_X1
X$94837 \$64531 \$40496 \$64441 \$64529 NWELL PWELL BULK MUX2_X1
X$94839 \$52176 \$40496 \$60130 \$60483 NWELL PWELL BULK MUX2_X1
X$94841 \$61212 \$40496 \$61879 \$61712 NWELL PWELL BULK MUX2_X1
X$94844 \$48098 \$40496 \$54094 \$54948 NWELL PWELL BULK MUX2_X1
X$94846 \$47926 \$40496 \$48395 \$48046 NWELL PWELL BULK MUX2_X1
X$94849 \$45882 \$40496 \$47578 \$47406 NWELL PWELL BULK MUX2_X1
X$94852 \$50228 \$40496 \$50364 \$50687 NWELL PWELL BULK MUX2_X1
X$94854 \$47668 \$40496 \$66040 \$66376 NWELL PWELL BULK MUX2_X1
X$94856 \$67074 \$40496 \$67076 \$67073 NWELL PWELL BULK MUX2_X1
X$94858 \$41234 \$40496 \$42663 \$42679 NWELL PWELL BULK MUX2_X1
X$94860 \$42248 \$40496 \$43357 \$43411 NWELL PWELL BULK MUX2_X1
X$94864 \$51372 \$40496 \$65798 \$65806 NWELL PWELL BULK MUX2_X1
X$94866 \$67647 \$40496 \$67943 \$67942 NWELL PWELL BULK MUX2_X1
X$94868 \$66745 \$40496 \$68658 \$68863 NWELL PWELL BULK MUX2_X1
X$94870 \$67550 \$40496 \$68860 \$69048 NWELL PWELL BULK MUX2_X1
X$94872 \$67949 \$40496 \$69717 \$70137 NWELL PWELL BULK MUX2_X1
X$94874 \$67952 \$40496 \$69384 \$69714 NWELL PWELL BULK MUX2_X1
X$94876 \$52345 \$40496 \$52938 \$52725 NWELL PWELL BULK MUX2_X1
X$94879 \$53272 \$40496 \$53786 \$53865 NWELL PWELL BULK MUX2_X1
X$94881 \$50457 \$40496 \$51912 \$51916 NWELL PWELL BULK MUX2_X1
X$94883 \$55880 \$40496 \$60140 \$60143 NWELL PWELL BULK MUX2_X1
X$94885 \$63475 \$40496 \$64151 \$63730 NWELL PWELL BULK MUX2_X1
X$94888 \$46492 \$40496 \$55655 \$56200 NWELL PWELL BULK MUX2_X1
X$94890 \$51814 \$40496 \$52957 \$52682 NWELL PWELL BULK MUX2_X1
X$94893 \$58115 \$40496 \$63461 \$64236 NWELL PWELL BULK MUX2_X1
X$94895 \$50741 \$40496 \$56703 \$56511 NWELL PWELL BULK MUX2_X1
X$94898 \$53056 \$40496 \$55103 \$55663 NWELL PWELL BULK MUX2_X1
X$94901 \$58535 \$40496 \$58537 \$58968 NWELL PWELL BULK MUX2_X1
X$94904 \$58137 \$40496 \$58528 \$57759 NWELL PWELL BULK MUX2_X1
X$94906 \$61904 \$40496 \$63490 \$63634 NWELL PWELL BULK MUX2_X1
X$94909 \$46559 \$40496 \$62281 \$62521 NWELL PWELL BULK MUX2_X1
X$94911 \$40764 \$40496 \$40770 \$40925 NWELL PWELL BULK MUX2_X1
X$94913 \$43600 \$40496 \$43606 \$43361 NWELL PWELL BULK MUX2_X1
X$94982 \$40502 \$40996 NWELL PWELL BULK INV_X1
X$94986 \$67065 \$40504 \$69291 \$69007 NWELL PWELL BULK MUX2_X1
X$94988 \$67647 \$40504 \$68875 \$69295 NWELL PWELL BULK MUX2_X1
X$94991 \$51372 \$40504 \$67367 \$67071 NWELL PWELL BULK MUX2_X1
X$94993 \$56728 \$40504 \$57761 \$58225 NWELL PWELL BULK MUX2_X1
X$94995 \$58115 \$40504 \$64764 \$64873 NWELL PWELL BULK MUX2_X1
X$94997 \$63475 \$40504 \$64774 \$64586 NWELL PWELL BULK MUX2_X1
X$95000 \$48098 \$40504 \$53257 \$53639 NWELL PWELL BULK MUX2_X1
X$95002 \$64531 \$40504 \$64786 \$65245 NWELL PWELL BULK MUX2_X1
X$95005 \$58535 \$40504 \$59493 \$59622 NWELL PWELL BULK MUX2_X1
X$95008 \$50741 \$40504 \$57895 \$58114 NWELL PWELL BULK MUX2_X1
X$95011 \$51814 \$40504 \$51374 \$51679 NWELL PWELL BULK MUX2_X1
X$95013 \$47668 \$40504 \$67256 \$67702 NWELL PWELL BULK MUX2_X1
X$95015 \$50228 \$40504 \$51674 \$51371 NWELL PWELL BULK MUX2_X1
X$95018 \$40764 \$40504 \$41224 \$41567 NWELL PWELL BULK MUX2_X1
X$95022 \$43593 \$40504 \$43355 \$43057 NWELL PWELL BULK MUX2_X1
X$95024 \$42248 \$40504 \$42250 \$42680 NWELL PWELL BULK MUX2_X1
X$95027 \$52345 \$40504 \$54108 \$53782 NWELL PWELL BULK MUX2_X1
X$95030 \$46492 \$40504 \$57343 \$57526 NWELL PWELL BULK MUX2_X1
X$95033 \$50457 \$40504 \$50208 \$50458 NWELL PWELL BULK MUX2_X1
X$95036 \$67550 \$40504 \$67545 \$67045 NWELL PWELL BULK MUX2_X1
X$95038 \$66745 \$40504 \$67519 \$66746 NWELL PWELL BULK MUX2_X1
X$95041 \$68488 \$40504 \$68610 \$68983 NWELL PWELL BULK MUX2_X1
X$95043 \$67936 \$40504 \$67938 \$68637 NWELL PWELL BULK MUX2_X1
X$95046 \$67949 \$40504 \$68491 \$68590 NWELL PWELL BULK MUX2_X1
X$95049 \$67074 \$40504 \$68133 \$68595 NWELL PWELL BULK MUX2_X1
X$95052 \$67952 \$40504 \$68884 \$68954 NWELL PWELL BULK MUX2_X1
X$95054 \$53272 \$40504 \$52586 \$53520 NWELL PWELL BULK MUX2_X1
X$95056 \$45882 \$40504 \$46081 \$46496 NWELL PWELL BULK MUX2_X1
X$95058 \$55880 \$40504 \$60436 \$60147 NWELL PWELL BULK MUX2_X1
X$95061 \$48029 \$40504 \$48375 \$48037 NWELL PWELL BULK MUX2_X1
X$95063 \$43600 \$40504 \$44406 \$44405 NWELL PWELL BULK MUX2_X1
X$95065 \$47926 \$40504 \$48276 \$47927 NWELL PWELL BULK MUX2_X1
X$95068 \$67038 \$40504 \$67635 \$67746 NWELL PWELL BULK MUX2_X1
X$95070 \$53056 \$40504 \$56698 \$57129 NWELL PWELL BULK MUX2_X1
X$95072 \$61212 \$40504 \$62762 \$62255 NWELL PWELL BULK MUX2_X1
X$95074 \$52176 \$40504 \$61411 \$60834 NWELL PWELL BULK MUX2_X1
X$95076 \$58137 \$40504 \$59629 \$59634 NWELL PWELL BULK MUX2_X1
X$95078 \$59494 \$40504 \$64434 \$64832 NWELL PWELL BULK MUX2_X1
X$95080 \$63979 \$40504 \$63981 \$64427 NWELL PWELL BULK MUX2_X1
X$95083 \$46559 \$40504 \$62864 \$62947 NWELL PWELL BULK MUX2_X1
X$95085 \$61904 \$40504 \$61907 \$62493 NWELL PWELL BULK MUX2_X1
X$95087 \$41234 \$40504 \$41651 \$41656 NWELL PWELL BULK MUX2_X1
X$95150 \$40510 \$43769 \$67048 NWELL PWELL BULK NOR2_X1
X$95153 \$66612 \$42756 \$66349 \$43440 \$43349 \$40510 \$67550 NWELL PWELL
+ BULK OAI222_X2
X$95173 \$40543 \$73977 \$75173 \$I241541 NWELL PWELL BULK HA_X1
X$95175 \$40543 \$74166 \$73980 NWELL PWELL BULK NAND2_X1
X$95178 \$40543 \$71837 \$73385 NWELL PWELL BULK NAND2_X1
X$95180 \$40543 \$73386 NWELL PWELL BULK INV_X2
X$95183 \$73391 \$40543 \$74182 \$73983 NWELL PWELL BULK OAI21_X1
X$95186 \$73391 \$74182 \$40543 \$74594 NWELL PWELL BULK OR3_X1
X$95189 \$40543 \$71838 \$72542 NWELL PWELL BULK NAND2_X1
X$95191 \$71836 \$71666 \$40543 \$62451 NWELL PWELL BULK NOR3_X4
X$95193 \$71836 \$71838 \$40543 \$62181 NWELL PWELL BULK NOR3_X4
X$95196 \$71837 \$71666 \$40543 \$69838 NWELL PWELL BULK NOR3_X4
X$95198 \$71837 \$71838 \$40543 \$62350 NWELL PWELL BULK NOR3_X4
X$95216 \$75014 \$40548 NWELL PWELL BULK INV_X2
X$95250 \$40592 \$40601 NWELL PWELL BULK INV_X1
X$95307 \$42139 \$42150 \$42465 \$40633 \$41891 NWELL PWELL BULK AND4_X1
X$95309 \$41808 \$40633 \$41117 \$42119 NWELL PWELL BULK NAND3_X1
X$95340 M1_AXI_AWADDR[7] \$41129 NWELL PWELL BULK BUF_X1
X$95358 \$50149 \$51049 \$40656 \$46024 NWELL PWELL BULK MUX2_X2
X$95366 \$40656 \$50040 NWELL PWELL BULK BUF_X16
X$95370 \$40656 \$41862 NWELL PWELL BULK INV_X1
X$95408 \$44687 \$42506 \$40661 \$44873 NWELL PWELL BULK MUX2_X1
X$95410 \$40661 \$41977 \$44562 \$44699 NWELL PWELL BULK MUX2_X1
X$95412 \$44235 \$42511 \$40661 \$44370 NWELL PWELL BULK MUX2_X1
X$95415 \$40661 \$42849 \$44048 \$44047 NWELL PWELL BULK MUX2_X1
X$95419 \$55921 \$56774 \$50040 \$40664 NWELL PWELL BULK MUX2_X2
X$95436 \$I174554 \$42311 \$42662 \$40671 NWELL PWELL BULK DFF_X1
X$95439 \$I177537 \$43499 \$43264 \$40671 NWELL PWELL BULK DFF_X1
X$95441 \$I174489 \$43498 \$44058 \$40671 NWELL PWELL BULK DFF_X1
X$95444 \$I177409 \$42856 \$42681 \$40671 NWELL PWELL BULK DFF_X1
X$95446 \$I174396 \$41490 \$41650 \$40671 NWELL PWELL BULK DFF_X1
X$95448 \$I177414 \$41996 \$41999 \$40671 NWELL PWELL BULK DFF_X1
X$95450 \$I177413 \$42857 \$43266 \$40671 NWELL PWELL BULK DFF_X1
X$95453 \$41300 \$40866 \$41293 \$40671 NWELL PWELL BULK DFF_X1
X$95458 \$I174359 \$41489 \$42325 \$40671 NWELL PWELL BULK DFF_X1
X$95462 \$I174367 \$42859 \$43270 \$40671 NWELL PWELL BULK DFF_X1
X$95465 \$I177405 \$43513 \$43512 \$40671 NWELL PWELL BULK DFF_X1
X$95468 \$I178832 \$42169 \$42514 \$40671 NWELL PWELL BULK DFF_X1
X$95470 \$I177415 \$41849 \$42013 \$40671 NWELL PWELL BULK DFF_X1
X$95472 \$I174370 \$41850 \$42339 \$40671 NWELL PWELL BULK DFF_X1
X$95474 \$I174425 \$42513 \$42694 \$40671 NWELL PWELL BULK DFF_X1
X$95477 \$I174391 \$43506 \$43702 \$40671 NWELL PWELL BULK DFF_X1
X$95479 \$I177269 \$43003 \$43410 \$40671 NWELL PWELL BULK DFF_X1
X$95482 \$43496 \$43654 \$43495 \$40671 NWELL PWELL BULK DFF_X1
X$95484 \$I174512 \$42850 \$43016 \$40671 NWELL PWELL BULK DFF_X1
X$95486 \$I175078 \$42508 \$42290 \$40671 NWELL PWELL BULK DFF_X1
X$95488 \$I177462 \$41987 \$41986 \$40671 NWELL PWELL BULK DFF_X1
X$95490 \$I178478 \$40689 \$41147 \$40671 NWELL PWELL BULK DFF_X1
X$95493 \$I177544 \$40688 \$41146 \$40671 NWELL PWELL BULK DFF_X1
X$95495 \$I177491 \$41493 \$41492 \$40671 NWELL PWELL BULK DFF_X1
X$95498 \$I178819 \$43273 \$43274 \$40671 NWELL PWELL BULK DFF_X1
X$95529 M0_AXI_ARVALID \$40682 NWELL PWELL BULK BUF_X2
X$95538 M0_AXI_AWADDR[22] \$40684 NWELL PWELL BULK BUF_X1
X$95585 \$40709 \$41025 NWELL PWELL BULK INV_X1
X$95594 \$41160 \$40711 NWELL PWELL BULK INV_X1
X$95638 \$40730 \$41509 \$40732 NWELL PWELL BULK XOR2_X2
X$95642 \$41781 \$41511 \$40731 NWELL PWELL BULK XOR2_X2
X$95655 \$41516 \$41876 \$40733 NWELL PWELL BULK XOR2_X2
X$95669 \$41412 \$40754 \$41043 NWELL PWELL BULK AND2_X1
X$95672 \$41552 \$40754 \$41550 NWELL PWELL BULK AND2_X1
X$95675 \$41042 \$40754 \$41046 NWELL PWELL BULK AND2_X1
X$95716 M1_AXI_WDATA[0] \$40784 NWELL PWELL BULK BUF_X1
X$95737 M1_AXI_WDATA[28] \$40978 NWELL PWELL BULK BUF_X1
X$95742 M0_AXI_AWADDR[27] \$40806 NWELL PWELL BULK BUF_X1
X$95757 \$41131 \$41130 \$41132 \$40813 NWELL PWELL BULK MUX2_X1
X$95770 \$40819 \$56680 \$56383 \$57212 NWELL PWELL BULK MUX2_X1
X$95772 \$40819 \$54550 \$54554 \$54087 NWELL PWELL BULK MUX2_X1
X$95774 \$40819 \$55498 \$56684 \$56384 NWELL PWELL BULK MUX2_X1
X$95776 \$55687 \$55501 \$40819 \$56269 NWELL PWELL BULK MUX2_X1
X$95788 \$66685 \$63210 \$40830 \$66951 NWELL PWELL BULK MUX2_X1
X$95790 \$65955 \$63530 \$40830 \$66250 NWELL PWELL BULK MUX2_X1
X$95793 \$67565 \$63057 \$40830 \$67991 NWELL PWELL BULK MUX2_X1
X$95795 \$67830 \$61075 \$40830 \$68530 NWELL PWELL BULK MUX2_X1
X$95822 M1_AXI_WDATA[17] \$40862 NWELL PWELL BULK BUF_X1
X$95855 \$40883 \$43769 \$67951 NWELL PWELL BULK NOR2_X1
X$95858 \$66825 \$42756 \$66768 \$43440 \$43349 \$40883 \$67949 NWELL PWELL
+ BULK OAI222_X2
X$95943 \$40993 \$43769 \$62265 NWELL PWELL BULK NOR2_X1
X$95945 \$60735 \$42756 \$60736 \$43440 \$43349 \$40993 \$61212 NWELL PWELL
+ BULK OAI222_X2
X$95985 \$41042 \$41909 \$41412 \$42076 \$41554 NWELL PWELL BULK NOR4_X2
X$95988 \$41552 \$41042 \$43140 NWELL PWELL BULK NOR2_X1
X$95993 \$41042 \$41910 \$43229 \$42798 \$42212 \$41746 \$42213 NWELL PWELL
+ BULK AOI222_X2
X$95999 \$41042 \$42223 NWELL PWELL BULK INV_X1
X$96020 \$41079 \$41086 NWELL PWELL BULK INV_X1
X$96040 \$41107 \$42894 \$42893 NWELL PWELL BULK NAND2_X1
X$96042 \$41107 \$42822 \$43197 NWELL PWELL BULK NAND2_X1
X$96045 \$41107 \$42540 \$42456 NWELL PWELL BULK NAND2_X1
X$96048 \$41107 \$42812 \$43190 NWELL PWELL BULK NAND2_X1
X$96050 \$42106 \$41509 \$41107 \$41491 NWELL PWELL BULK NAND3_X4
X$96052 \$41107 \$42539 \$42453 NWELL PWELL BULK NAND2_X1
X$96055 \$41107 \$42825 \$42891 NWELL PWELL BULK NAND2_X1
X$96058 \$41511 \$41509 \$41107 \$41601 NWELL PWELL BULK NAND3_X4
X$96061 \$41110 \$41107 NWELL PWELL BULK INV_X4
X$96073 \$41865 \$43153 \$41110 NWELL PWELL BULK NAND2_X4
X$96075 \$41110 \$42540 \$42888 NWELL PWELL BULK NAND2_X1
X$96077 \$41509 \$41511 \$41110 \$42023 NWELL PWELL BULK NOR3_X4
X$96079 \$41110 \$41509 \$42451 NWELL PWELL BULK NAND2_X1
X$96082 \$41110 \$41511 \$42193 NWELL PWELL BULK NAND2_X1
X$96084 \$41110 \$42106 \$41509 \$41845 NWELL PWELL BULK OR3_X4
X$96087 \$41110 \$42539 \$43193 NWELL PWELL BULK NAND2_X1
X$96089 \$41110 \$41876 \$42460 NWELL PWELL BULK NAND2_X1
X$96104 \$41889 \$41888 \$41117 \$41526 NWELL PWELL BULK HA_X1
X$96106 \$41117 \$41182 NWELL PWELL BULK INV_X1
X$96111 \$41887 \$41891 \$41117 \$42489 NWELL PWELL BULK MUX2_X1
X$96146 \$43765 \$41130 \$43943 \$41158 NWELL PWELL BULK MUX2_X1
X$96149 \$42521 \$41130 \$42178 \$42065 NWELL PWELL BULK MUX2_X1
X$96152 \$42357 \$41130 \$41853 \$42038 NWELL PWELL BULK MUX2_X1
X$96154 \$44253 \$41130 \$43946 \$41502 NWELL PWELL BULK MUX2_X1
X$96156 \$44030 \$41130 \$43496 \$43258 NWELL PWELL BULK MUX2_X1
X$96158 \$41489 \$41130 \$41490 \$41312 NWELL PWELL BULK MUX2_X1
X$96163 \$45097 \$41130 \$45111 \$45109 NWELL PWELL BULK MUX2_X1
X$96165 \$44246 \$41130 \$44247 \$44445 NWELL PWELL BULK MUX2_X1
X$96168 \$44871 \$41130 \$44234 \$44683 NWELL PWELL BULK MUX2_X1
X$96170 \$44661 \$41130 \$44555 \$44367 NWELL PWELL BULK MUX2_X1
X$96174 \$42500 \$41130 \$42501 \$42623 NWELL PWELL BULK MUX2_X1
X$96176 \$41475 \$41130 \$41476 \$41477 NWELL PWELL BULK MUX2_X1
X$96179 \$41850 \$41130 \$42169 \$42348 NWELL PWELL BULK MUX2_X1
X$96181 \$41493 \$41130 \$41849 \$41144 NWELL PWELL BULK MUX2_X1
X$96184 \$43636 \$41130 \$43644 \$43254 NWELL PWELL BULK MUX2_X1
X$96188 \$42626 \$41130 \$42634 \$42635 NWELL PWELL BULK MUX2_X1
X$96190 \$42868 \$41130 \$42175 \$42381 NWELL PWELL BULK MUX2_X1
X$96193 \$41130 \$45663 NWELL PWELL BULK BUF_X16
X$96293 \$41174 \$41456 \$41458 \$41175 NWELL PWELL BULK MUX2_X1
X$96298 \$41178 \$41519 \$41806 \$41179 NWELL PWELL BULK MUX2_X1
X$96305 \$41524 \$41887 \$I241060 \$41183 NWELL PWELL BULK HA_X1
X$96311 \$41186 \$42137 \$41529 \$42465 NWELL PWELL BULK OAI21_X1
X$96329 \$50221 \$42756 \$50392 \$43440 \$43349 \$41220 \$50228 NWELL PWELL
+ BULK OAI222_X2
X$96332 \$41220 \$43769 \$50219 NWELL PWELL BULK NOR2_X1
X$96379 \$41242 \$56680 \$55500 \$56261 NWELL PWELL BULK MUX2_X1
X$96381 \$41242 \$54550 \$54982 \$54987 NWELL PWELL BULK MUX2_X1
X$96383 \$56379 \$55501 \$41242 \$56530 NWELL PWELL BULK MUX2_X1
X$96386 \$41242 \$55498 \$55091 \$55699 NWELL PWELL BULK MUX2_X1
X$96398 \$41243 S0_AXI_WID[5] NWELL PWELL BULK BUF_X1
X$96404 \$41638 S0_AXI_WDATA[9] NWELL PWELL BULK BUF_X1
X$96411 \$41247 \$42023 \$41471 \$41588 NWELL PWELL BULK MUX2_X1
X$96440 \$66684 \$63210 \$41266 \$67137 NWELL PWELL BULK MUX2_X1
X$96442 \$67113 \$63057 \$41266 \$66248 NWELL PWELL BULK MUX2_X1
X$96444 \$67126 \$61075 \$41266 \$67116 NWELL PWELL BULK MUX2_X1
X$96446 \$66058 \$63530 \$41266 \$66394 NWELL PWELL BULK MUX2_X1
X$96506 \$57549 \$56704 \$41352 \$57894 NWELL PWELL BULK MUX2_X2
X$96509 \$69410 \$41352 \$69673 \$65136 NWELL PWELL BULK MUX2_X1
X$96512 \$65918 \$41352 \$65433 \$65916 NWELL PWELL BULK MUX2_X1
X$96515 \$63459 \$41352 \$63151 \$63791 NWELL PWELL BULK MUX2_X1
X$96518 \$64429 \$41352 \$64841 \$59546 NWELL PWELL BULK MUX2_X1
X$96521 \$64421 \$41352 \$63976 \$62371 NWELL PWELL BULK MUX2_X1
X$96523 \$54093 \$54557 \$41352 \$55342 NWELL PWELL BULK MUX2_X2
X$96526 \$57140 \$56396 \$41352 \$57122 NWELL PWELL BULK MUX2_X2
X$96529 \$47745 \$47744 \$41352 \$47743 NWELL PWELL BULK MUX2_X2
X$96531 \$67707 \$41352 \$66767 \$65128 NWELL PWELL BULK MUX2_X1
X$96534 \$67072 \$41352 \$66373 \$66418 NWELL PWELL BULK MUX2_X1
X$96536 \$57880 \$56407 \$41352 \$57872 NWELL PWELL BULK MUX2_X2
X$96538 \$69434 \$41352 \$67648 \$66051 NWELL PWELL BULK MUX2_X1
X$96540 \$68227 \$41352 \$68866 \$69732 NWELL PWELL BULK MUX2_X1
X$96543 \$69290 \$41352 \$70213 \$70224 NWELL PWELL BULK MUX2_X1
X$96546 \$67932 \$41352 \$69663 \$70961 NWELL PWELL BULK MUX2_X1
X$96550 \$68617 \$41352 \$68619 \$65725 NWELL PWELL BULK MUX2_X1
X$96552 \$52940 \$41352 \$52941 \$52994 NWELL PWELL BULK MUX2_X1
X$96554 \$53872 \$41352 \$53533 \$53319 NWELL PWELL BULK MUX2_X1
X$96556 \$50729 \$41352 \$51193 \$50914 NWELL PWELL BULK MUX2_X1
X$96558 \$68265 \$41352 \$67742 \$68666 NWELL PWELL BULK MUX2_X1
X$96670 \$41730 \$41411 NWELL PWELL BULK INV_X1
X$96673 \$41916 \$41412 \$43140 \$42944 NWELL PWELL BULK NAND3_X4
X$96676 \$41412 \$41916 \$43140 \$42930 NWELL PWELL BULK AND3_X1
X$96679 \$41909 \$41412 \$42074 NWELL PWELL BULK NOR2_X2
X$96684 \$41412 \$41910 \$42916 \$42437 \$42212 \$41546 \$42213 NWELL PWELL
+ BULK AOI222_X2
X$96687 \$42223 \$41909 \$41412 \$41552 \$41913 NWELL PWELL BULK NOR4_X2
X$96699 \$41545 \$41416 \$41417 NWELL PWELL BULK XNOR2_X1
X$96777 M2_AXI_AWADDR[6] \$41471 NWELL PWELL BULK BUF_X1
X$96780 \$41471 \$41845 \$41834 \$41949 NWELL PWELL BULK MUX2_X1
X$96783 \$41471 \$41601 \$41962 \$41952 NWELL PWELL BULK MUX2_X1
X$96786 \$41471 \$41491 \$41595 \$41472 NWELL PWELL BULK MUX2_X1
X$96808 M2_AXI_AWADDR[17] \$41487 NWELL PWELL BULK BUF_X1
X$96811 \$41487 \$41845 \$41490 \$41650 NWELL PWELL BULK MUX2_X1
X$96813 \$41489 \$42023 \$41487 \$42325 NWELL PWELL BULK MUX2_X1
X$96816 \$41487 \$41491 \$41493 \$41492 NWELL PWELL BULK MUX2_X1
X$96818 \$41487 \$41601 \$41849 \$42013 NWELL PWELL BULK MUX2_X1
X$96839 \$42520 \$41491 \$42521 \$43115 NWELL PWELL BULK MUX2_X1
X$96842 \$59960 \$41491 \$60160 \$60903 NWELL PWELL BULK MUX2_X1
X$96844 \$53439 \$41491 \$54738 \$54460 NWELL PWELL BULK MUX2_X1
X$96847 \$45662 \$41491 \$46044 \$46042 NWELL PWELL BULK MUX2_X1
X$96849 \$44572 \$41491 \$45097 \$45465 NWELL PWELL BULK MUX2_X1
X$96851 \$71595 \$41491 \$74383 \$74137 NWELL PWELL BULK MUX2_X1
X$96854 \$54432 \$41491 \$55172 \$55165 NWELL PWELL BULK MUX2_X1
X$96859 \$55763 \$41491 \$56319 \$56501 NWELL PWELL BULK MUX2_X1
X$96861 \$51582 \$41491 \$52342 \$52518 NWELL PWELL BULK MUX2_X1
X$96865 \$56604 \$41491 \$56923 \$56922 NWELL PWELL BULK MUX2_X1
X$96867 \$58397 \$41491 \$59676 \$59140 NWELL PWELL BULK MUX2_X1
X$96869 \$43252 \$41491 \$43921 \$44345 NWELL PWELL BULK MUX2_X1
X$96872 \$72207 \$41491 \$74128 \$74549 NWELL PWELL BULK MUX2_X1
X$96875 \$72353 \$41491 \$72721 \$73220 NWELL PWELL BULK MUX2_X1
X$96878 \$72204 \$41491 \$73571 \$73576 NWELL PWELL BULK MUX2_X1
X$96880 \$72689 \$41491 \$74799 \$75151 NWELL PWELL BULK MUX2_X1
X$96882 \$49837 \$41491 \$49485 \$49483 NWELL PWELL BULK MUX2_X1
X$96885 \$48584 \$41491 \$49121 \$49335 NWELL PWELL BULK MUX2_X1
X$96887 \$43520 \$41491 \$44253 \$44476 NWELL PWELL BULK MUX2_X1
X$96890 \$47159 \$41491 \$47678 \$47675 NWELL PWELL BULK MUX2_X1
X$96893 \$58845 \$41491 \$58243 \$59099 NWELL PWELL BULK MUX2_X1
X$96895 \$59638 \$41491 \$59120 \$59959 NWELL PWELL BULK MUX2_X1
X$96898 \$60169 \$41491 \$61435 \$61434 NWELL PWELL BULK MUX2_X1
X$96900 \$57432 \$41491 \$57877 \$57873 NWELL PWELL BULK MUX2_X1
X$96903 \$53836 \$41491 \$54768 \$54761 NWELL PWELL BULK MUX2_X1
X$96905 \$53426 \$41491 \$54004 \$54719 NWELL PWELL BULK MUX2_X1
X$96907 \$57898 \$41491 \$58054 \$58052 NWELL PWELL BULK MUX2_X1
X$96909 \$55582 \$41491 \$56324 \$56898 NWELL PWELL BULK MUX2_X1
X$96912 \$75274 \$41491 \$75985 \$75984 NWELL PWELL BULK MUX2_X1
X$96915 \$72706 \$41491 \$73084 \$73083 NWELL PWELL BULK MUX2_X1
X$96918 \$50544 \$41491 \$51051 \$50551 NWELL PWELL BULK MUX2_X1
X$96921 \$52512 \$41491 \$53165 \$53404 NWELL PWELL BULK MUX2_X1
X$96924 \$54450 \$41491 \$54455 \$54000 NWELL PWELL BULK MUX2_X1
X$96927 \$48553 \$41491 \$48183 \$48399 NWELL PWELL BULK MUX2_X1
X$96930 \$59358 \$41491 \$61287 \$61077 NWELL PWELL BULK MUX2_X1
X$96934 \$55757 \$41491 \$57225 \$57387 NWELL PWELL BULK MUX2_X1
X$96937 \$58380 \$41491 \$58998 \$59518 NWELL PWELL BULK MUX2_X1
X$96940 \$54809 \$41491 \$55298 \$54474 NWELL PWELL BULK MUX2_X1
X$96943 \$72530 \$41491 \$75969 \$75534 NWELL PWELL BULK MUX2_X1
X$96946 \$75636 \$41491 \$76612 \$76499 NWELL PWELL BULK MUX2_X1
X$96949 \$73199 \$41491 \$74802 \$74948 NWELL PWELL BULK MUX2_X1
X$96951 \$74798 \$41491 \$76620 \$76617 NWELL PWELL BULK MUX2_X1
X$96953 \$72521 \$41491 \$75664 \$75822 NWELL PWELL BULK MUX2_X1
X$96955 \$74121 \$41491 \$75532 \$75671 NWELL PWELL BULK MUX2_X1
X$96957 \$42503 \$41491 \$42988 \$42974 NWELL PWELL BULK MUX2_X1
X$96963 \$42164 \$41491 \$42357 \$42515 NWELL PWELL BULK MUX2_X1
X$96969 \$44553 \$41491 \$45354 \$45359 NWELL PWELL BULK MUX2_X1
X$97097 \$41511 \$42106 NWELL PWELL BULK INV_X1
X$97114 \$41884 \$41883 \$41519 \$41882 NWELL PWELL BULK AOI21_X1
X$97116 \$41519 \$42138 \$41884 NWELL PWELL BULK NOR2_X1
X$97131 \$41524 \$41887 \$41526 \$42488 NWELL PWELL BULK NOR3_X1
X$97136 \$41892 \$41524 \$41890 \$41891 \$42474 NWELL PWELL BULK AND4_X1
X$97138 \$41891 \$41524 \$42546 NWELL PWELL BULK NOR2_X1
X$97146 \$41526 \$41892 NWELL PWELL BULK INV_X1
X$97168 \$42773 \$41545 \$42214 \$42213 NWELL PWELL BULK NOR3_X2
X$97177 \$43896 \$42214 \$41546 \$41905 \$42928 NWELL PWELL BULK NOR4_X2
X$97179 \$41746 \$42214 \$41546 \$42416 \$43171 NWELL PWELL BULK NOR4_X2
X$97181 \$42214 \$41546 \$43317 NWELL PWELL BULK NOR2_X2
X$97187 \$41546 \$41547 \$41749 NWELL PWELL BULK AND2_X1
X$97190 \$41546 \$41907 \$42218 \$43184 NWELL PWELL BULK AND3_X1
X$97192 \$41907 \$41546 \$42218 \$42756 NWELL PWELL BULK NAND3_X4
X$97203 \$41905 \$41547 \$42096 NWELL PWELL BULK AND2_X1
X$97205 \$41746 \$41547 \$41548 NWELL PWELL BULK AND2_X1
X$97207 \$41907 \$41547 \$41906 NWELL PWELL BULK AND2_X1
X$97218 \$41552 \$42076 NWELL PWELL BULK INV_X1
X$97221 \$41910 \$41552 \$42913 \$42213 \$41905 \$43315 NWELL PWELL BULK
+ AOI221_X2
X$97243 M1_AXI_WDATA[26] \$41562 NWELL PWELL BULK BUF_X1
X$97265 \$41573 S0_AXI_WID[1] NWELL PWELL BULK BUF_X1
X$97272 \$64808 \$42756 \$64447 \$43440 \$43349 \$41576 \$64531 NWELL PWELL
+ BULK OAI222_X2
X$97276 \$41576 \$43769 \$65180 NWELL PWELL BULK NOR2_X1
X$97313 \$41591 S0_AXI_WDATA[30] NWELL PWELL BULK BUF_X1
X$97320 \$42164 \$41601 \$41853 \$42171 NWELL PWELL BULK MUX2_X1
X$97323 \$60169 \$41601 \$61436 \$60927 NWELL PWELL BULK MUX2_X1
X$97325 \$43520 \$41601 \$43946 \$43944 NWELL PWELL BULK MUX2_X1
X$97327 \$54450 \$41601 \$55026 \$55232 NWELL PWELL BULK MUX2_X1
X$97330 \$53439 \$41601 \$54744 \$54463 NWELL PWELL BULK MUX2_X1
X$97333 \$58845 \$41601 \$59381 \$59631 NWELL PWELL BULK MUX2_X1
X$97335 \$59638 \$41601 \$59117 \$59115 NWELL PWELL BULK MUX2_X1
X$97337 \$52512 \$41601 \$53413 \$53403 NWELL PWELL BULK MUX2_X1
X$97340 \$48553 \$41601 \$48184 \$48807 NWELL PWELL BULK MUX2_X1
X$97342 \$56604 \$41601 \$56549 \$56547 NWELL PWELL BULK MUX2_X1
X$97344 \$47159 \$41601 \$46895 \$47317 NWELL PWELL BULK MUX2_X1
X$97347 \$44553 \$41601 \$44233 \$44232 NWELL PWELL BULK MUX2_X1
X$97351 \$72521 \$41601 \$76337 \$76500 NWELL PWELL BULK MUX2_X1
X$97354 \$74121 \$41601 \$75963 \$75967 NWELL PWELL BULK MUX2_X1
X$97356 \$72530 \$41601 \$76338 \$76184 NWELL PWELL BULK MUX2_X1
X$97359 \$57898 \$41601 \$57901 \$57903 NWELL PWELL BULK MUX2_X1
X$97361 \$74798 \$41601 \$76326 \$76329 NWELL PWELL BULK MUX2_X1
X$97364 \$75636 \$41601 \$75944 \$76177 NWELL PWELL BULK MUX2_X1
X$97367 \$51582 \$41601 \$51589 \$51590 NWELL PWELL BULK MUX2_X1
X$97369 \$49837 \$41601 \$50159 \$50393 NWELL PWELL BULK MUX2_X1
X$97371 \$48584 \$41601 \$49123 \$49704 NWELL PWELL BULK MUX2_X1
X$97373 \$45662 \$41601 \$45245 \$45919 NWELL PWELL BULK MUX2_X1
X$97375 \$44572 \$41601 \$45111 \$45481 NWELL PWELL BULK MUX2_X1
X$97377 \$43252 \$41601 \$44024 \$44014 NWELL PWELL BULK MUX2_X1
X$97380 \$59960 \$41601 \$60338 \$60910 NWELL PWELL BULK MUX2_X1
X$97382 \$53836 \$41601 \$54759 \$54762 NWELL PWELL BULK MUX2_X1
X$97385 \$57432 \$41601 \$58255 \$58252 NWELL PWELL BULK MUX2_X1
X$97387 \$58397 \$41601 \$58050 \$58049 NWELL PWELL BULK MUX2_X1
X$97390 \$53426 \$41601 \$54459 \$55027 NWELL PWELL BULK MUX2_X1
X$97393 \$55582 \$41601 \$55453 \$56043 NWELL PWELL BULK MUX2_X1
X$97396 \$75274 \$41601 \$75306 \$75307 NWELL PWELL BULK MUX2_X1
X$97398 \$71595 \$41601 \$73369 \$73635 NWELL PWELL BULK MUX2_X1
X$97400 \$72706 \$41601 \$73643 \$73376 NWELL PWELL BULK MUX2_X1
X$97402 \$50544 \$41601 \$50840 \$50359 NWELL PWELL BULK MUX2_X1
X$97404 \$59358 \$41601 \$60082 \$59938 NWELL PWELL BULK MUX2_X1
X$97406 \$54432 \$41601 \$55577 \$54436 NWELL PWELL BULK MUX2_X1
X$97410 \$55763 \$41601 \$56850 \$56858 NWELL PWELL BULK MUX2_X1
X$97412 \$55757 \$41601 \$57396 \$57394 NWELL PWELL BULK MUX2_X1
X$97415 \$58380 \$41601 \$58586 \$58385 NWELL PWELL BULK MUX2_X1
X$97417 \$54809 \$41601 \$55300 \$54475 NWELL PWELL BULK MUX2_X1
X$97419 \$73199 \$41601 \$74950 \$74804 NWELL PWELL BULK MUX2_X1
X$97421 \$72204 \$41601 \$73574 \$73201 NWELL PWELL BULK MUX2_X1
X$97423 \$72689 \$41601 \$74510 \$74516 NWELL PWELL BULK MUX2_X1
X$97425 \$72353 \$41601 \$74118 \$74377 NWELL PWELL BULK MUX2_X1
X$97430 \$72207 \$41601 \$73080 \$73625 NWELL PWELL BULK MUX2_X1
X$97434 \$42503 \$41601 \$42630 \$42627 NWELL PWELL BULK MUX2_X1
X$97436 \$42520 \$41601 \$42178 \$42177 NWELL PWELL BULK MUX2_X1
X$97529 \$41646 \$43769 \$58550 NWELL PWELL BULK NOR2_X1
X$97531 \$58146 \$42756 \$57804 \$43440 \$43349 \$41646 \$56728 NWELL PWELL
+ BULK OAI222_X2
X$97572 \$46427 \$42511 \$41671 \$46230 NWELL PWELL BULK MUX2_X1
X$97575 \$41671 \$41977 \$44240 \$44242 NWELL PWELL BULK MUX2_X1
X$97577 \$45649 \$42506 \$41671 \$45231 NWELL PWELL BULK MUX2_X1
X$97579 \$41671 \$42849 \$45863 \$46229 NWELL PWELL BULK MUX2_X1
X$97618 \$66751 \$42756 \$66551 \$43440 \$43349 \$41698 \$67936 NWELL PWELL
+ BULK OAI222_X2
X$97621 \$41698 \$43769 \$67937 NWELL PWELL BULK NOR2_X1
X$97663 \$41725 \$43769 \$58693 NWELL PWELL BULK NOR2_X1
X$97666 \$57740 \$42756 \$57341 \$43440 \$43349 \$41725 \$58115 NWELL PWELL
+ BULK OAI222_X2
X$97683 \$42416 \$41746 \$43317 \$43349 NWELL PWELL BULK NAND3_X4
X$97686 \$41746 \$43896 NWELL PWELL BULK INV_X1
X$97694 \$41905 \$41746 \$42218 NWELL PWELL BULK NOR2_X1
X$97707 \$41750 \$42090 NWELL PWELL BULK INV_X1
X$97730 \$41773 \$41901 NWELL PWELL BULK INV_X1
X$97752 \$42202 \$42130 \$41803 NWELL PWELL BULK XOR2_X1
X$97755 \$41883 \$42130 \$42138 \$42475 \$41806 NWELL PWELL BULK FA_X1
X$97785 \$57305 \$57726 \$58092 \$41829 \$58468 NWELL PWELL BULK OAI22_X4
X$97801 \$41841 \$41977 \$44883 \$45426 NWELL PWELL BULK MUX2_X1
X$97804 \$45226 \$42511 \$41841 \$45224 NWELL PWELL BULK MUX2_X1
X$97806 \$41841 \$42849 \$44879 \$45039 NWELL PWELL BULK MUX2_X1
X$97808 \$44567 \$42506 \$41841 \$44719 NWELL PWELL BULK MUX2_X1
X$97818 \$41843 \$41977 \$41996 \$41999 NWELL PWELL BULK MUX2_X1
X$97821 \$42311 \$42506 \$41843 \$42662 NWELL PWELL BULK MUX2_X1
X$97823 \$41843 \$42849 \$42857 \$43266 NWELL PWELL BULK MUX2_X1
X$97825 \$42856 \$42511 \$41843 \$42681 NWELL PWELL BULK MUX2_X1
X$97832 \$57898 \$41845 \$59686 \$59684 NWELL PWELL BULK MUX2_X1
X$97835 \$43520 \$41845 \$43943 \$43942 NWELL PWELL BULK MUX2_X1
X$97837 \$58845 \$41845 \$59095 \$59091 NWELL PWELL BULK MUX2_X1
X$97839 \$75274 \$41845 \$75829 \$76341 NWELL PWELL BULK MUX2_X1
X$97841 \$54432 \$41845 \$55563 \$55559 NWELL PWELL BULK MUX2_X1
X$97844 \$54450 \$41845 \$54698 \$55023 NWELL PWELL BULK MUX2_X1
X$97846 \$55763 \$41845 \$57462 \$57461 NWELL PWELL BULK MUX2_X1
X$97849 \$58397 \$41845 \$58408 \$58683 NWELL PWELL BULK MUX2_X1
X$97851 \$53439 \$41845 \$53171 \$53067 NWELL PWELL BULK MUX2_X1
X$97853 \$44553 \$41845 \$45213 \$45343 NWELL PWELL BULK MUX2_X1
X$97856 \$71595 \$41845 \$72534 \$73629 NWELL PWELL BULK MUX2_X1
X$97859 \$72207 \$41845 \$73361 \$73359 NWELL PWELL BULK MUX2_X1
X$97862 \$72204 \$41845 \$73549 \$73551 NWELL PWELL BULK MUX2_X1
X$97864 \$42503 \$41845 \$43654 \$43495 NWELL PWELL BULK MUX2_X1
X$97867 \$75636 \$41845 \$76315 \$76312 NWELL PWELL BULK MUX2_X1
X$97871 \$51582 \$41845 \$51586 \$52334 NWELL PWELL BULK MUX2_X1
X$97873 \$49837 \$41845 \$50747 \$50556 NWELL PWELL BULK MUX2_X1
X$97875 \$48584 \$41845 \$48435 \$48195 NWELL PWELL BULK MUX2_X1
X$97878 \$52512 \$41845 \$52515 \$53051 NWELL PWELL BULK MUX2_X1
X$97880 \$53426 \$41845 \$53432 \$53892 NWELL PWELL BULK MUX2_X1
X$97883 \$45662 \$41845 \$46440 \$47402 NWELL PWELL BULK MUX2_X1
X$97885 \$44572 \$41845 \$44247 \$45105 NWELL PWELL BULK MUX2_X1
X$97887 \$47159 \$41845 \$47319 \$47315 NWELL PWELL BULK MUX2_X1
X$97889 \$59638 \$41845 \$60337 \$60897 NWELL PWELL BULK MUX2_X1
X$97891 \$60169 \$41845 \$60926 \$60558 NWELL PWELL BULK MUX2_X1
X$97893 \$59960 \$41845 \$59664 \$59663 NWELL PWELL BULK MUX2_X1
X$97895 \$57432 \$41845 \$58041 \$58247 NWELL PWELL BULK MUX2_X1
X$97897 \$55582 \$41845 \$55449 \$55782 NWELL PWELL BULK MUX2_X1
X$97899 \$53836 \$41845 \$56902 \$56904 NWELL PWELL BULK MUX2_X1
X$97901 \$56604 \$41845 \$56542 \$56910 NWELL PWELL BULK MUX2_X1
X$97903 \$72706 \$41845 \$74386 \$74385 NWELL PWELL BULK MUX2_X1
X$97905 \$48553 \$41845 \$49675 \$49673 NWELL PWELL BULK MUX2_X1
X$97907 \$50544 \$41845 \$50709 \$50711 NWELL PWELL BULK MUX2_X1
X$97909 \$59358 \$41845 \$59937 \$60077 NWELL PWELL BULK MUX2_X1
X$97911 \$55757 \$41845 \$56440 \$56441 NWELL PWELL BULK MUX2_X1
X$97913 \$58380 \$41845 \$58165 \$57784 NWELL PWELL BULK MUX2_X1
X$97916 \$54809 \$41845 \$56938 \$56609 NWELL PWELL BULK MUX2_X1
X$97918 \$73199 \$41845 \$73594 \$73352 NWELL PWELL BULK MUX2_X1
X$97920 \$72530 \$41845 \$75304 \$75300 NWELL PWELL BULK MUX2_X1
X$97922 \$72353 \$41845 \$74535 \$74532 NWELL PWELL BULK MUX2_X1
X$97924 \$74798 \$41845 \$75952 \$75652 NWELL PWELL BULK MUX2_X1
X$97926 \$72689 \$41845 \$73967 \$74095 NWELL PWELL BULK MUX2_X1
X$97929 \$72521 \$41845 \$75665 \$75154 NWELL PWELL BULK MUX2_X1
X$97931 \$74121 \$41845 \$74811 \$74380 NWELL PWELL BULK MUX2_X1
X$97935 \$43252 \$41845 \$42848 \$42970 NWELL PWELL BULK MUX2_X1
X$97937 \$42164 \$41845 \$42169 \$42514 NWELL PWELL BULK MUX2_X1
X$97939 \$42520 \$41845 \$42175 \$42737 NWELL PWELL BULK MUX2_X1
X$98033 \$41850 \$42023 \$42164 \$42339 NWELL PWELL BULK MUX2_X1
X$98052 \$41865 M2_AXI_AWREADY NWELL PWELL BULK BUF_X1
X$98076 \$41880 \$42897 \$43209 \$43828 NWELL PWELL BULK HA_X1
X$98078 \$42200 \$41880 \$43827 NWELL PWELL BULK NAND2_X1
X$98132 \$41893 \$56661 \$57128 \$58020 NWELL PWELL BULK AOI21_X4
X$98143 \$41905 \$43896 \$43317 \$43440 NWELL PWELL BULK NAND3_X4
X$98151 \$41905 \$42416 NWELL PWELL BULK INV_X1
X$98168 \$41907 \$42214 NWELL PWELL BULK INV_X2
X$98182 \$41916 \$41909 NWELL PWELL BULK INV_X2
X$98221 M1_AXI_WDATA[20] \$41930 NWELL PWELL BULK BUF_X1
X$98278 \$43295 \$43535 \$42200 \$41977 NWELL PWELL BULK NAND3_X4
X$98285 \$43275 \$41977 \$45238 \$45463 NWELL PWELL BULK MUX2_X1
X$98293 \$56304 \$41977 \$57668 \$57665 NWELL PWELL BULK MUX2_X1
X$98295 \$46590 \$41977 \$54446 \$55207 NWELL PWELL BULK MUX2_X1
X$98298 \$50698 \$41977 \$56821 \$56824 NWELL PWELL BULK MUX2_X1
X$98300 \$50536 \$41977 \$54441 \$54440 NWELL PWELL BULK MUX2_X1
X$98305 \$52496 \$41977 \$60633 \$60820 NWELL PWELL BULK MUX2_X1
X$98307 \$53704 \$41977 \$61791 \$62374 NWELL PWELL BULK MUX2_X1
X$98313 \$52084 \$41977 \$59580 \$58840 NWELL PWELL BULK MUX2_X1
X$98315 \$46389 \$41977 \$46066 \$46463 NWELL PWELL BULK MUX2_X1
X$98318 \$56610 \$41977 \$62195 \$62196 NWELL PWELL BULK MUX2_X1
X$98321 \$52877 \$41977 \$60659 \$60951 NWELL PWELL BULK MUX2_X1
X$98324 \$52540 \$41977 \$54480 \$54825 NWELL PWELL BULK MUX2_X1
X$98332 \$42295 \$41977 \$43498 \$44058 NWELL PWELL BULK MUX2_X1
X$98334 \$43055 \$41977 \$44741 \$44739 NWELL PWELL BULK MUX2_X1
X$98339 \$52520 \$41977 \$53709 \$54294 NWELL PWELL BULK MUX2_X1
X$98341 \$52749 \$41977 \$54471 \$55459 NWELL PWELL BULK MUX2_X1
X$98344 \$50692 \$41977 \$53700 \$54214 NWELL PWELL BULK MUX2_X1
X$98347 \$53021 \$41977 \$58839 \$59568 NWELL PWELL BULK MUX2_X1
X$98349 \$50667 \$41977 \$59540 \$59538 NWELL PWELL BULK MUX2_X1
X$98352 \$52232 \$41977 \$61081 \$61303 NWELL PWELL BULK MUX2_X1
X$98356 \$43290 \$41977 \$43816 \$43813 NWELL PWELL BULK MUX2_X1
X$98360 \$51628 \$41977 \$52809 \$52891 NWELL PWELL BULK MUX2_X1
X$98362 \$53958 \$41977 \$55325 \$55465 NWELL PWELL BULK MUX2_X1
X$98365 \$47542 \$41977 \$47546 \$48123 NWELL PWELL BULK MUX2_X1
X$98367 \$52533 \$41977 \$56613 \$57521 NWELL PWELL BULK MUX2_X1
X$98369 \$53134 \$41977 \$56086 \$56085 NWELL PWELL BULK MUX2_X1
X$98371 \$49510 \$41977 \$63913 \$64577 NWELL PWELL BULK MUX2_X1
X$98373 \$41977 \$63919 \$64580 NWELL PWELL BULK NAND2_X1
X$98478 \$42508 \$42159 \$41987 \$42509 NWELL PWELL BULK MUX2_X1
X$98486 \$68018 \$63210 \$41991 \$67833 NWELL PWELL BULK MUX2_X1
X$98489 \$66252 \$61075 \$41991 \$66412 NWELL PWELL BULK MUX2_X1
X$98491 \$67836 \$63530 \$41991 \$68392 NWELL PWELL BULK MUX2_X1
X$98493 \$66954 \$62350 \$41991 \$67164 NWELL PWELL BULK MUX2_X1
X$98505 \$42311 \$42159 \$41996 \$42670 NWELL PWELL BULK MUX2_X1
X$98524 \$42868 \$42023 \$42520 \$43102 NWELL PWELL BULK MUX2_X1
X$98527 \$42845 \$42023 \$43252 \$42968 NWELL PWELL BULK MUX2_X1
X$98529 \$43651 \$42023 \$42503 \$43645 NWELL PWELL BULK MUX2_X1
X$98531 \$46734 \$42023 NWELL PWELL BULK BUF_X8
X$98533 \$44246 \$42023 \$44572 \$44758 NWELL PWELL BULK MUX2_X1
X$98536 \$44656 \$42023 \$44553 \$44346 NWELL PWELL BULK MUX2_X1
X$98545 \$43765 \$42023 \$43520 \$43761 NWELL PWELL BULK MUX2_X1
X$98636 \$42088 \$42222 \$43320 NWELL PWELL BULK NOR2_X1
X$98665 \$42210 \$42117 NWELL PWELL BULK INV_X1
X$98696 \$42156 S0_AXI_AWADDR[0] NWELL PWELL BULK BUF_X1
X$98705 \$42670 \$42853 \$42684 \$42156 NWELL PWELL BULK MUX2_X1
X$98710 \$43529 \$42159 \$43289 \$43530 NWELL PWELL BULK MUX2_X1
X$98712 \$44464 \$42159 \$44251 \$44463 NWELL PWELL BULK MUX2_X1
X$98715 \$47519 \$42159 \$47167 \$47862 NWELL PWELL BULK MUX2_X1
X$98717 \$45906 \$42159 \$46283 \$46438 NWELL PWELL BULK MUX2_X1
X$98720 \$44752 \$42159 \$45238 \$44891 NWELL PWELL BULK MUX2_X1
X$98723 \$46035 \$42159 \$45889 \$46259 NWELL PWELL BULK MUX2_X1
X$98726 \$48581 \$42159 \$49117 \$49324 NWELL PWELL BULK MUX2_X1
X$98728 \$47175 \$42159 \$46733 \$47391 NWELL PWELL BULK MUX2_X1
X$98730 \$46046 \$42159 \$45936 \$46647 NWELL PWELL BULK MUX2_X1
X$98733 \$48576 \$42159 \$48188 \$48577 NWELL PWELL BULK MUX2_X1
X$98735 \$46427 \$42159 \$45863 \$46603 NWELL PWELL BULK MUX2_X1
X$98737 \$44687 \$42159 \$44562 \$44563 NWELL PWELL BULK MUX2_X1
X$98739 \$43928 \$42159 \$43691 \$44400 NWELL PWELL BULK MUX2_X1
X$98741 \$45226 \$42159 \$44879 \$45228 NWELL PWELL BULK MUX2_X1
X$98743 \$44567 \$42159 \$44883 \$45063 NWELL PWELL BULK MUX2_X1
X$98746 \$45649 \$42159 \$44240 \$45651 NWELL PWELL BULK MUX2_X1
X$98748 \$43930 \$42159 \$44741 \$44426 NWELL PWELL BULK MUX2_X1
X$98750 \$45438 \$42159 \$45236 \$46029 NWELL PWELL BULK MUX2_X1
X$98752 \$42856 \$42159 \$42857 \$42684 NWELL PWELL BULK MUX2_X1
X$98754 \$43811 \$42159 \$43816 \$44265 NWELL PWELL BULK MUX2_X1
X$98757 \$45584 \$42159 \$45268 \$46064 NWELL PWELL BULK MUX2_X1
X$98762 \$43003 \$42159 \$42850 \$42651 NWELL PWELL BULK MUX2_X1
X$98764 \$50154 \$42159 \$49478 \$49480 NWELL PWELL BULK MUX2_X1
X$98766 \$47863 \$42159 \$48192 \$48857 NWELL PWELL BULK MUX2_X1
X$98768 \$43938 \$42159 \$43519 \$43940 NWELL PWELL BULK MUX2_X1
X$98770 \$44577 \$42159 \$45250 \$46648 NWELL PWELL BULK MUX2_X1
X$98773 \$47169 \$42159 \$47524 \$48043 NWELL PWELL BULK MUX2_X1
X$98775 \$44117 \$42159 \$44571 \$44892 NWELL PWELL BULK MUX2_X1
X$98777 \$46039 \$42159 \$45898 \$46264 NWELL PWELL BULK MUX2_X1
X$98779 \$46027 \$42159 \$46429 \$46031 NWELL PWELL BULK MUX2_X1
X$98782 \$44235 \$42159 \$44048 \$44875 NWELL PWELL BULK MUX2_X1
X$98784 \$43499 \$42159 \$43498 \$43924 NWELL PWELL BULK MUX2_X1
X$98786 \$45173 \$42159 NWELL PWELL BULK BUF_X16
X$98789 \$46457 \$42159 \$46388 \$46709 NWELL PWELL BULK MUX2_X1
X$98791 \$44587 \$42159 \$44528 \$44836 NWELL PWELL BULK MUX2_X1
X$98793 \$44512 \$42159 \$44261 \$44520 NWELL PWELL BULK MUX2_X1
X$98795 \$43513 \$42159 \$42859 \$44088 NWELL PWELL BULK MUX2_X1
X$98797 \$43273 \$42159 \$43728 \$43934 NWELL PWELL BULK MUX2_X1
X$98799 \$43506 \$42159 \$42513 \$43509 NWELL PWELL BULK MUX2_X1
X$98859 M2_AXI_AWADDR[12] \$42164 NWELL PWELL BULK BUF_X1
X$98893 M0_AXI_AWADDR[26] \$42180 NWELL PWELL BULK BUF_X1
X$98913 \$42894 \$42891 \$42196 NWELL PWELL BULK XOR2_X1
X$98916 \$42200 \$43300 \$43834 NWELL PWELL BULK NAND2_X1
X$98918 \$42200 \$43828 \$43473 NWELL PWELL BULK NAND2_X1
X$98922 \$42200 \$42897 \$43825 NWELL PWELL BULK NAND2_X1
X$98928 \$42200 \$43209 \$43210 NWELL PWELL BULK NAND2_X1
X$98930 \$43295 \$43959 \$42200 \$42849 NWELL PWELL BULK NAND3_X4
X$98933 \$42200 \$42898 \$I241091 \$42202 NWELL PWELL BULK HA_X1
X$98935 \$42200 \$42838 \$42201 NWELL PWELL BULK NAND2_X1
X$98944 \$42202 \$42475 NWELL PWELL BULK INV_X1
X$98954 \$42559 \$42212 \$42221 \$42913 \$42550 NWELL PWELL BULK AOI22_X1
X$98987 \$46402 \$46401 \$46668 \$42221 NWELL PWELL BULK NAND3_X4
X$98999 \$42221 \$43552 NWELL PWELL BULK INV_X1
X$99001 \$42221 \$43309 \$42439 \$44186 NWELL PWELL BULK NAND3_X1
X$99033 M1_AXI_WDATA[9] \$42232 NWELL PWELL BULK CLKBUF_X2
X$99087 M1_AXI_WDATA[31] \$42592 NWELL PWELL BULK BUF_X1
X$99102 \$43499 \$42506 \$42295 \$43264 NWELL PWELL BULK MUX2_X1
X$99104 \$42295 \$42849 \$43691 \$44071 NWELL PWELL BULK MUX2_X1
X$99107 \$43928 \$42511 \$42295 \$43929 NWELL PWELL BULK MUX2_X1
X$99153 \$57364 \$42346 \$56728 \$57835 NWELL PWELL BULK MUX2_X1
X$99156 \$58967 \$42346 \$58535 \$59089 NWELL PWELL BULK MUX2_X1
X$99159 \$60751 \$42346 \$55880 \$60856 NWELL PWELL BULK MUX2_X1
X$99161 \$64532 \$42346 \$64531 \$64823 NWELL PWELL BULK MUX2_X1
X$99163 \$62284 \$42346 \$61904 \$62509 NWELL PWELL BULK MUX2_X1
X$99166 \$48274 \$42346 \$47926 \$48937 NWELL PWELL BULK MUX2_X1
X$99172 \$51817 \$42346 \$51814 \$51818 NWELL PWELL BULK MUX2_X1
X$99175 \$68958 \$42346 \$67952 \$68576 NWELL PWELL BULK MUX2_X1
X$99178 \$51671 \$42346 \$50228 \$51669 NWELL PWELL BULK MUX2_X1
X$99181 \$67651 \$42346 \$51372 \$67650 NWELL PWELL BULK MUX2_X1
X$99184 \$69301 \$42346 \$68488 \$68985 NWELL PWELL BULK MUX2_X1
X$99187 \$67086 \$42346 \$47668 \$67701 NWELL PWELL BULK MUX2_X1
X$99189 \$68881 \$42346 \$67949 \$69303 NWELL PWELL BULK MUX2_X1
X$99191 \$67948 \$42346 \$67074 \$68592 NWELL PWELL BULK MUX2_X1
X$99193 \$48851 \$42346 \$48029 \$48675 NWELL PWELL BULK MUX2_X1
X$99195 \$58525 \$42346 \$58137 \$58629 NWELL PWELL BULK MUX2_X1
X$99197 \$64785 \$42346 \$59494 \$65277 NWELL PWELL BULK MUX2_X1
X$99199 \$63172 \$42346 \$46559 \$63171 NWELL PWELL BULK MUX2_X1
X$99201 \$60490 \$42346 \$52176 \$60488 NWELL PWELL BULK MUX2_X1
X$99281 \$67933 \$42378 \$67550 \$67931 NWELL PWELL BULK MUX2_X1
X$99283 \$68482 \$42378 \$67065 \$68484 NWELL PWELL BULK MUX2_X1
X$99286 \$53784 \$42378 \$52345 \$54569 NWELL PWELL BULK MUX2_X1
X$99289 \$50906 \$42378 \$50457 \$51211 NWELL PWELL BULK MUX2_X1
X$99291 \$67639 \$42378 \$66745 \$67734 NWELL PWELL BULK MUX2_X1
X$99293 \$68869 \$42378 \$67936 \$69288 NWELL PWELL BULK MUX2_X1
X$99295 \$69296 \$42378 \$67647 \$69293 NWELL PWELL BULK MUX2_X1
X$99297 \$52716 \$42378 \$53272 \$53041 NWELL PWELL BULK MUX2_X1
X$99300 \$46325 \$42378 \$45882 \$47042 NWELL PWELL BULK MUX2_X1
X$99302 \$65068 \$42378 \$63475 \$65343 NWELL PWELL BULK MUX2_X1
X$99304 \$56707 \$42378 \$46492 \$57060 NWELL PWELL BULK MUX2_X1
X$99307 \$65055 \$42378 \$58115 \$64874 NWELL PWELL BULK MUX2_X1
X$99309 \$63455 \$42378 \$61212 \$63803 NWELL PWELL BULK MUX2_X1
X$99311 \$67037 \$42378 \$67038 \$67526 NWELL PWELL BULK MUX2_X1
X$99313 \$57339 \$42378 \$50741 \$57553 NWELL PWELL BULK MUX2_X1
X$99316 \$56697 \$42378 \$53056 \$57153 NWELL PWELL BULK MUX2_X1
X$99319 \$54092 \$42378 \$48098 \$54324 NWELL PWELL BULK MUX2_X1
X$99321 \$64778 \$42378 \$63979 \$64426 NWELL PWELL BULK MUX2_X1
X$99399 \$42423 \$42793 NWELL PWELL BULK INV_X1
X$99406 \$42437 \$42439 NWELL PWELL BULK INV_X1
X$99409 \$42553 \$42439 \$42557 NWELL PWELL BULK NOR2_X1
X$99412 \$42439 \$42555 \$43866 NWELL PWELL BULK NAND2_X1
X$99414 \$42798 \$42439 \$43307 NWELL PWELL BULK NOR2_X1
X$99420 \$42439 \$43313 \$43309 \$42914 \$42559 NWELL PWELL BULK OAI22_X1
X$99430 \$42448 \$43238 \$43541 \$42913 NWELL PWELL BULK NOR3_X1
X$99475 \$42965 S0_AXI_AWADDR[2] NWELL PWELL BULK BUF_X1
X$99480 M0_AXI_AWADDR[1] \$44359 NWELL PWELL BULK BUF_X1
X$99485 M0_AXI_AWADDR[3] \$42499 NWELL PWELL BULK BUF_X1
X$99507 M2_AXI_AWBURST[0] \$42503 NWELL PWELL BULK BUF_X1
X$99522 \$43930 \$42506 \$43055 \$44413 NWELL PWELL BULK MUX2_X1
X$99532 \$44752 \$42506 \$43275 \$44751 NWELL PWELL BULK MUX2_X1
X$99537 \$43811 \$42506 \$43290 \$43808 NWELL PWELL BULK MUX2_X1
X$99542 \$42506 \$43956 NWELL PWELL BULK BUF_X8
X$99578 \$42509 \$42853 \$42651 \$42965 NWELL PWELL BULK MUX2_X1
X$99591 \$43273 \$42511 \$43055 \$43274 NWELL PWELL BULK MUX2_X1
X$99595 \$44587 \$42511 \$43290 \$44263 NWELL PWELL BULK MUX2_X1
X$99601 \$47751 \$42511 NWELL PWELL BULK BUF_X8
X$99605 \$42511 \$44584 NWELL PWELL BULK BUF_X8
X$99610 \$44117 \$42511 \$43275 \$43935 NWELL PWELL BULK MUX2_X1
X$99650 M0_AXI_AWADDR[28] \$42517 NWELL PWELL BULK BUF_X1
X$99664 M2_AXI_AWADDR[29] \$42520 NWELL PWELL BULK BUF_X1
X$99700 \$42539 \$42540 \$42822 \$42825 NWELL PWELL BULK HA_X1
X$99736 \$42553 \$43541 \$43861 NWELL PWELL BULK NOR2_X1
X$99738 \$42553 \$43309 \$43461 NWELL PWELL BULK NOR2_X1
X$99742 \$43541 \$42555 \$42908 \$43307 \$43542 NWELL PWELL BULK AND4_X2
X$99748 \$42555 \$43238 NWELL PWELL BULK INV_X1
X$99761 \$49754 \$48646 \$49386 \$42569 NWELL PWELL BULK NAND3_X4
X$99771 \$43310 \$43307 \$42569 \$43879 NWELL PWELL BULK AOI21_X1
X$99773 \$42569 \$43313 NWELL PWELL BULK INV_X1
X$99792 \$46350 \$42756 \$46354 \$43440 \$43349 \$42583 \$46492 NWELL PWELL
+ BULK OAI222_X2
X$99794 \$42583 \$43769 \$47054 NWELL PWELL BULK NOR2_X1
X$99804 M1_AXI_WDATA[15] \$42586 NWELL PWELL BULK BUF_X1
X$99832 M1_AXI_WDATA[23] \$42601 NWELL PWELL BULK BUF_X1
X$99868 M0_AXI_AWADDR[5] \$42619 NWELL PWELL BULK BUF_X1
X$99889 \$42632 S1_AXI_WDATA[13] NWELL PWELL BULK BUF_X1
X$100005 \$42756 \$43440 \$67647 NWELL PWELL BULK NAND2_X1
X$100008 \$66760 \$42756 \$67069 \$43440 \$43349 \$43076 \$68488 NWELL PWELL
+ BULK OAI222_X2
X$100030 \$52145 \$42756 \$52579 \$43440 \$43349 \$43116 \$50457 NWELL PWELL
+ BULK OAI222_X2
X$100041 \$58134 \$42756 \$57356 \$43440 \$43349 \$43069 \$58137 NWELL PWELL
+ BULK OAI222_X2
X$100064 \$58552 \$42756 \$58151 \$43440 \$43349 \$43012 \$58535 NWELL PWELL
+ BULK OAI222_X2
X$100067 \$64138 \$42756 \$64425 \$43440 \$43349 \$43095 \$63979 NWELL PWELL
+ BULK OAI222_X2
X$100081 \$43565 \$43349 \$42756 \$43327 \$43569 \$43440 \$48098 NWELL PWELL
+ BULK OAI222_X2
X$100185 \$43322 \$43320 \$42773 NWELL PWELL BULK AND2_X1
X$100210 \$42798 \$43309 NWELL PWELL BULK INV_X1
X$100228 \$42819 \$57308 NWELL PWELL BULK INV_X1
X$100230 \$56353 \$42819 \$57724 NWELL PWELL BULK NOR2_X1
X$100232 \$57976 \$42819 \$58475 \$57905 NWELL PWELL BULK OAI21_X2
X$100235 \$42819 \$56353 \$57115 NWELL PWELL BULK OR2_X1
X$100239 \$42819 \$59321 \$58900 \$59850 NWELL PWELL BULK OR3_X1
X$100299 \$43275 \$42849 \$44571 \$44244 NWELL PWELL BULK MUX2_X1
X$100304 \$43055 \$42849 \$43728 \$43514 NWELL PWELL BULK MUX2_X1
X$100308 \$50667 \$42849 \$58391 \$59029 NWELL PWELL BULK MUX2_X1
X$100310 \$50698 \$42849 \$56840 \$57676 NWELL PWELL BULK MUX2_X1
X$100313 \$46590 \$42849 \$55021 \$55216 NWELL PWELL BULK MUX2_X1
X$100315 \$52749 \$42849 \$55037 \$55673 NWELL PWELL BULK MUX2_X1
X$100318 \$52496 \$42849 \$60322 \$59944 NWELL PWELL BULK MUX2_X1
X$100322 \$52533 \$42849 \$55795 \$55462 NWELL PWELL BULK MUX2_X1
X$100325 \$52877 \$42849 \$61117 \$61808 NWELL PWELL BULK MUX2_X1
X$100328 \$52520 \$42849 \$52522 \$52868 NWELL PWELL BULK MUX2_X1
X$100342 \$53021 \$42849 \$58392 \$58204 NWELL PWELL BULK MUX2_X1
X$100344 \$50692 \$42849 \$54660 \$55199 NWELL PWELL BULK MUX2_X1
X$100346 \$52232 \$42849 \$61315 \$62359 NWELL PWELL BULK MUX2_X1
X$100348 \$53704 \$42849 \$61090 \$61349 NWELL PWELL BULK MUX2_X1
X$100350 \$52084 \$42849 \$60327 \$60848 NWELL PWELL BULK MUX2_X1
X$100353 \$50536 \$42849 \$54192 \$53359 NWELL PWELL BULK MUX2_X1
X$100357 \$56304 \$42849 \$56307 \$56790 NWELL PWELL BULK MUX2_X1
X$100359 \$51628 \$42849 \$51633 \$51630 NWELL PWELL BULK MUX2_X1
X$100361 \$46389 \$42849 \$47554 \$47837 NWELL PWELL BULK MUX2_X1
X$100363 \$53958 \$42849 \$54039 \$54038 NWELL PWELL BULK MUX2_X1
X$100365 \$47542 \$42849 \$48222 \$48535 NWELL PWELL BULK MUX2_X1
X$100367 \$52540 \$42849 \$53190 \$52889 NWELL PWELL BULK MUX2_X1
X$100369 \$53134 \$42849 \$55796 \$55685 NWELL PWELL BULK MUX2_X1
X$100372 \$42849 \$62800 \$62798 NWELL PWELL BULK NAND2_X1
X$100375 \$49510 \$42849 \$62494 \$61803 NWELL PWELL BULK MUX2_X1
X$100377 \$56610 \$42849 \$63684 \$63379 NWELL PWELL BULK MUX2_X1
X$100379 \$43290 \$42849 \$44528 \$43954 NWELL PWELL BULK MUX2_X1
X$100473 \$43940 \$42853 \$44463 \$44038 NWELL PWELL BULK MUX2_X1
X$100476 \$47862 \$42853 \$48043 \$47955 NWELL PWELL BULK MUX2_X1
X$100479 \$44891 \$42853 \$44892 \$45088 NWELL PWELL BULK MUX2_X1
X$100481 \$48857 \$42853 \$49324 \$48843 NWELL PWELL BULK MUX2_X1
X$100483 \$46438 \$42853 \$47391 \$47392 NWELL PWELL BULK MUX2_X1
X$100485 \$43924 \$42853 \$44400 \$44712 NWELL PWELL BULK MUX2_X1
X$100487 \$46709 \$46064 \$42853 \$47073 NWELL PWELL BULK MUX2_X2
X$100489 \$43530 \$42853 \$44520 \$44195 NWELL PWELL BULK MUX2_X1
X$100492 \$44265 \$44836 \$42853 \$44872 NWELL PWELL BULK MUX2_X2
X$100494 \$49480 \$42853 \$48577 \$49457 NWELL PWELL BULK MUX2_X1
X$100497 \$46648 \$42853 \$46647 \$46644 NWELL PWELL BULK MUX2_X1
X$100500 \$46259 \$42853 \$46264 \$46025 NWELL PWELL BULK MUX2_X1
X$100502 \$45651 \$42853 \$46603 \$46600 NWELL PWELL BULK MUX2_X1
X$100505 \$46029 \$42853 \$46031 \$46857 NWELL PWELL BULK MUX2_X1
X$100507 \$44563 \$42853 \$44875 \$44983 NWELL PWELL BULK MUX2_X1
X$100510 \$45063 \$42853 \$45228 \$45841 NWELL PWELL BULK MUX2_X1
X$100513 \$44426 \$42853 \$43934 \$44343 NWELL PWELL BULK MUX2_X1
X$100515 \$43509 \$42853 \$44088 \$44012 NWELL PWELL BULK MUX2_X1
X$100517 \$47824 \$42853 \$48128 \$48531 NWELL PWELL BULK MUX2_X1
X$100519 \$42853 \$47483 NWELL PWELL BULK BUF_X16
X$100521 \$45595 \$43962 \$I245665 \$42853 NWELL PWELL BULK DFF_X2
X$100605 \$45270 \$45593 \$42898 NWELL PWELL BULK NAND2_X2
X$100607 \$42898 \$43216 NWELL PWELL BULK INV_X2
X$100609 \$42898 \$44851 \$45191 NWELL PWELL BULK NAND2_X1
X$100612 \$42898 \$44541 \$44592 NWELL PWELL BULK NAND2_X1
X$100615 \$42898 \$45276 \$45277 NWELL PWELL BULK NAND2_X1
X$100617 \$42898 \$44534 \$44839 NWELL PWELL BULK NAND2_X1
X$100619 \$42898 \$45181 \$45274 NWELL PWELL BULK NAND2_X1
X$100629 \$43300 \$43473 \$42899 NWELL PWELL BULK XOR2_X1
X$100632 \$42908 \$43327 NWELL PWELL BULK INV_X1
X$100635 \$45715 \$46482 \$46092 \$42908 NWELL PWELL BULK MUX2_X2
X$100647 \$44183 \$43879 \$42909 \$43310 \$44186 \$44537 NWELL PWELL BULK
+ AOI221_X2
X$100666 \$43548 \$43313 \$43550 \$42916 NWELL PWELL BULK AOI21_X4
X$100906 \$43008 S1_AXI_WDATA[29] NWELL PWELL BULK BUF_X1
X$100911 \$43012 \$43769 \$59567 NWELL PWELL BULK NOR2_X1
X$100971 \$43069 \$43769 \$58232 NWELL PWELL BULK NOR2_X1
X$100979 \$43076 \$43769 \$68149 NWELL PWELL BULK NOR2_X1
X$101023 \$43095 \$43769 \$65826 NWELL PWELL BULK NOR2_X1
X$101058 \$43116 \$43769 \$52935 NWELL PWELL BULK NOR2_X1
X$101088 \$65570 \$62451 \$43152 \$65774 NWELL PWELL BULK MUX2_X1
X$101090 \$65567 \$61102 \$43152 \$65766 NWELL PWELL BULK MUX2_X1
X$101093 \$66267 \$62181 \$43152 \$66490 NWELL PWELL BULK MUX2_X1
X$101095 \$65967 \$61799 \$43152 \$65765 NWELL PWELL BULK MUX2_X1
X$101104 M2_AXI_AWVALID \$43153 NWELL PWELL BULK BUF_X2
X$101150 \$43216 \$44851 \$44848 NWELL PWELL BULK NAND2_X1
X$101152 \$43216 \$45611 \$45192 NWELL PWELL BULK NAND2_X1
X$101155 \$43216 \$45279 \$44593 NWELL PWELL BULK NAND2_X1
X$101158 \$43216 \$45694 \$45974 NWELL PWELL BULK NAND2_X1
X$101161 \$43216 \$45278 \$45617 NWELL PWELL BULK NAND2_X1
X$101163 \$43216 \$45276 \$45600 NWELL PWELL BULK NAND2_X1
X$101189 M2_AXI_AWSIZE[1] \$43252 NWELL PWELL BULK BUF_X1
X$101206 \$62899 \$63530 \$43259 \$63061 NWELL PWELL BULK MUX2_X1
X$101208 \$61076 \$61075 \$43259 \$61931 NWELL PWELL BULK MUX2_X1
X$101210 \$61786 \$63057 \$43259 \$62318 NWELL PWELL BULK MUX2_X1
X$101212 \$62329 \$63210 \$43259 \$62332 NWELL PWELL BULK MUX2_X1
X$101272 \$43295 \$44534 \$44272 NWELL PWELL BULK XNOR2_X2
X$101287 \$52479 \$51480 \$43303 \$54045 NWELL PWELL BULK NAND3_X4
X$101290 \$54405 \$43303 \$52479 \$51480 \$54886 NWELL PWELL BULK NAND4_X1
X$101292 \$43303 \$52479 \$52553 \$53230 NWELL PWELL BULK NAND3_X2
X$101295 \$43303 \$53210 NWELL PWELL BULK INV_X2
X$101298 \$52553 \$52479 \$43303 \$52128 NWELL PWELL BULK AND3_X2
X$101319 \$43316 \$43309 \$43310 \$43311 NWELL PWELL BULK NAND3_X2
X$101329 \$43310 \$43541 NWELL PWELL BULK INV_X1
X$101336 \$44202 \$43866 \$43311 \$44199 NWELL PWELL BULK AOI21_X4
X$101349 \$43314 \$44282 \$44533 NWELL PWELL BULK AND2_X1
X$101351 \$43314 \$44286 NWELL PWELL BULK INV_X1
X$101353 \$43314 \$44822 \$44525 \$43769 NWELL PWELL BULK NAND3_X4
X$101355 \$43915 \$43898 \$43314 \$43557 \$43909 NWELL PWELL BULK OR4_X4
X$101357 \$43549 \$43314 \$43454 NWELL PWELL BULK NAND2_X1
X$101366 \$44276 \$43552 \$43894 \$43315 NWELL PWELL BULK AOI21_X4
X$101370 \$44801 \$44134 \$43978 \$43316 NWELL PWELL BULK MUX2_X2
X$101372 \$43316 \$43569 NWELL PWELL BULK INV_X1
X$101391 \$43320 \$43322 \$43323 NWELL PWELL BULK NOR2_X1
X$101400 \$43323 \$43558 \$43974 NWELL PWELL BULK NOR2_X2
X$101409 \$44943 \$43980 \$43333 NWELL PWELL BULK NOR2_X1
X$101480 \$43440 \$43349 \$67065 NWELL PWELL BULK NAND2_X1
X$101596 \$46274 \$46091 \$46092 \$43350 NWELL PWELL BULK MUX2_X2
X$101600 \$43915 \$43350 \$43352 \$43566 \$44105 NWELL PWELL BULK OAI22_X2
X$101605 \$45488 \$44726 \$44630 \$43352 NWELL PWELL BULK MUX2_X1
X$101632 M2_AXI_WDATA[3] \$43619 NWELL PWELL BULK BUF_X1
X$101857 M0_AXI_AWADDR[7] \$43492 NWELL PWELL BULK BUF_X1
X$101937 M2_AXI_AWADDR[14] \$43520 NWELL PWELL BULK BUF_X1
X$101957 \$43959 \$43535 NWELL PWELL BULK INV_X2
X$101964 \$I178014 \$43839 \$43537 \$43962 NWELL PWELL BULK DFF_X1
X$101976 \$43542 \$48134 \$44202 \$48234 \$48136 NWELL PWELL BULK NOR4_X1
X$101984 \$46481 \$43548 \$48637 \$I241515 NWELL PWELL BULK HA_X1
X$101986 \$43548 \$47224 \$46776 NWELL PWELL BULK NAND2_X1
X$101988 \$43548 \$47790 \$47571 NWELL PWELL BULK NAND2_X1
X$101990 \$43548 \$47782 \$48489 NWELL PWELL BULK NAND2_X1
X$101992 \$43548 \$47574 \$48483 NWELL PWELL BULK NAND2_X1
X$101994 \$43548 \$47575 \$47780 NWELL PWELL BULK NAND2_X1
X$101996 \$43548 \$48240 \$48642 NWELL PWELL BULK NAND2_X1
X$101999 \$43548 \$47901 NWELL PWELL BULK INV_X2
X$102010 \$43549 \$43966 \$43550 NWELL PWELL BULK NAND2_X1
X$102012 \$43974 \$44291 \$43557 \$43549 NWELL PWELL BULK NOR3_X1
X$102014 \$43549 \$43898 \$43894 NWELL PWELL BULK NAND2_X1
X$102027 \$44292 \$43557 \$44926 \$45145 NWELL PWELL BULK NOR3_X1
X$102029 \$44157 \$43974 \$44291 \$43557 \$44292 NWELL PWELL BULK NOR4_X1
X$102032 \$44822 \$43557 NWELL PWELL BULK INV_X1
X$102035 \$43973 \$44148 \$43558 NWELL PWELL BULK OR2_X1
X$102039 \$43915 \$43561 NWELL PWELL BULK INV_X1
X$102045 \$43566 \$43564 NWELL PWELL BULK INV_X1
X$102052 \$43915 \$64138 \$43566 \$64425 \$66123 NWELL PWELL BULK OAI22_X1
X$102055 \$43915 \$66760 \$43566 \$67069 \$67945 NWELL PWELL BULK OAI22_X1
X$102057 \$43915 \$65631 \$43566 \$64767 \$66147 NWELL PWELL BULK OAI22_X1
X$102059 \$43915 \$66612 \$43566 \$66349 \$66598 NWELL PWELL BULK OAI22_X1
X$102061 \$43915 \$66751 \$43566 \$66551 \$67730 NWELL PWELL BULK OAI22_X1
X$102063 \$43915 \$67054 \$43566 \$66747 \$67643 NWELL PWELL BULK OAI22_X1
X$102066 \$43915 \$67193 \$43566 \$67095 \$68045 NWELL PWELL BULK OAI22_X1
X$102069 \$43915 \$66816 \$43566 \$66042 \$67237 NWELL PWELL BULK OAI22_X1
X$102071 \$43769 \$43566 \$68013 NWELL PWELL BULK NAND2_X1
X$102074 \$43915 \$43566 \$67963 NWELL PWELL BULK NAND2_X1
X$102077 \$43915 \$66825 \$43566 \$66768 \$67286 NWELL PWELL BULK OAI22_X1
X$102079 \$43915 \$50221 \$43566 \$50392 \$50707 NWELL PWELL BULK OAI22_X1
X$102082 \$43915 \$47584 \$43566 \$47586 \$48411 NWELL PWELL BULK OAI22_X1
X$102085 \$43915 \$55531 \$43566 \$55870 \$56083 NWELL PWELL BULK OAI22_X1
X$102087 \$43915 \$53787 \$43566 \$52947 \$53855 NWELL PWELL BULK OAI22_X1
X$102089 \$43915 \$48258 \$43566 \$48654 \$49695 NWELL PWELL BULK OAI22_X1
X$102091 \$43915 \$46350 \$46354 \$43566 \$46494 NWELL PWELL BULK OAI22_X2
X$102094 \$43915 \$52145 \$43566 \$52579 \$53052 NWELL PWELL BULK OAI22_X1
X$102096 \$43915 \$53777 \$43566 \$53778 \$54104 NWELL PWELL BULK OAI22_X1
X$102098 \$43915 \$50737 \$43566 \$49535 \$50901 NWELL PWELL BULK OAI22_X1
X$102101 \$43915 \$60735 \$43566 \$60736 \$61885 NWELL PWELL BULK OAI22_X1
X$102104 \$43915 \$63155 \$43566 \$60427 \$64179 NWELL PWELL BULK OAI22_X1
X$102107 \$43915 \$58134 \$43566 \$57356 \$59121 NWELL PWELL BULK OAI22_X1
X$102109 \$43915 \$57740 \$43566 \$57341 \$58262 NWELL PWELL BULK OAI22_X1
X$102111 \$43915 \$47932 \$43566 \$48286 \$48287 NWELL PWELL BULK OAI22_X1
X$102115 \$43915 \$43595 \$43566 \$43596 \$44415 NWELL PWELL BULK OAI22_X1
X$102117 \$43915 \$44637 \$44636 \$43566 \$45059 NWELL PWELL BULK OAI22_X2
X$102119 \$43915 \$50230 \$43566 \$50231 \$50348 NWELL PWELL BULK OAI22_X1
X$102121 \$43915 \$45817 \$43566 \$45384 \$46115 NWELL PWELL BULK OAI22_X1
X$102124 \$43915 \$43609 \$43566 \$43610 \$44714 NWELL PWELL BULK OAI22_X1
X$102128 \$43915 \$47603 \$43566 \$47264 \$48340 NWELL PWELL BULK OAI22_X1
X$102130 \$43915 \$45726 \$45307 \$43566 \$46635 NWELL PWELL BULK OAI22_X2
X$102132 \$43915 \$43588 \$43589 \$43566 \$43991 NWELL PWELL BULK OAI22_X2
X$102134 \$43915 \$50936 \$43566 \$50938 \$51759 NWELL PWELL BULK OAI22_X1
X$102136 \$43915 \$54582 \$43566 \$54125 \$55543 NWELL PWELL BULK OAI22_X1
X$102138 \$43915 \$58552 \$43566 \$58151 \$59042 NWELL PWELL BULK OAI22_X1
X$102140 \$43915 \$56425 \$43566 \$55904 \$59059 NWELL PWELL BULK OAI22_X1
X$102142 \$43915 \$58146 \$43566 \$57804 \$59053 NWELL PWELL BULK OAI22_X1
X$102144 \$43915 \$62908 \$43566 \$62296 \$63204 NWELL PWELL BULK OAI22_X1
X$102147 \$43915 \$64808 \$43566 \$64447 \$65092 NWELL PWELL BULK OAI22_X1
X$102150 \$44286 \$43898 \$43909 \$44822 \$43566 NWELL PWELL BULK NAND4_X4
X$102155 \$43915 \$43613 \$43674 \$43566 \$44051 NWELL PWELL BULK OAI22_X2
X$102252 \$51377 \$43583 \$49907 \$50332 NWELL PWELL BULK MUX2_X1
X$102254 \$45428 \$43583 \$45435 \$45324 NWELL PWELL BULK MUX2_X1
X$102257 \$45461 \$43583 \$45460 \$45453 NWELL PWELL BULK MUX2_X1
X$102260 \$46118 \$43583 \$45751 \$46165 NWELL PWELL BULK MUX2_X1
X$102262 \$46160 \$43583 \$45332 \$46119 NWELL PWELL BULK MUX2_X1
X$102264 \$44688 \$43583 \$44649 \$45013 NWELL PWELL BULK MUX2_X1
X$102266 \$56852 \$43583 \$57466 \$57763 NWELL PWELL BULK MUX2_X1
X$102268 \$54212 \$43583 \$54211 \$54590 NWELL PWELL BULK MUX2_X1
X$102271 \$54580 \$43583 \$54122 \$55133 NWELL PWELL BULK MUX2_X1
X$102273 \$64470 \$43583 \$64451 \$64469 NWELL PWELL BULK MUX2_X1
X$102275 \$48266 \$43583 \$48419 \$48414 NWELL PWELL BULK MUX2_X1
X$102277 \$45477 \$43583 \$45475 \$44633 NWELL PWELL BULK MUX2_X1
X$102280 \$44626 \$43583 \$44627 \$44630 NWELL PWELL BULK MUX2_X1
X$102283 \$45533 \$43583 \$44616 \$45116 NWELL PWELL BULK MUX2_X1
X$102286 \$44112 \$43583 \$44115 \$43989 NWELL PWELL BULK MUX2_X1
X$102288 \$44493 \$43583 NWELL PWELL BULK BUF_X16
X$102290 \$43798 \$43583 \$43585 \$44113 NWELL PWELL BULK MUX2_X1
X$102292 \$52244 \$43583 \$52178 \$52177 NWELL PWELL BULK MUX2_X1
X$102294 \$66810 \$43583 \$67092 \$67093 NWELL PWELL BULK MUX2_X1
X$102296 \$66444 \$43583 \$66438 \$66804 NWELL PWELL BULK MUX2_X1
X$102299 \$65706 \$43583 \$65141 \$66396 NWELL PWELL BULK MUX2_X1
X$102301 \$49302 \$43583 \$49297 \$49643 NWELL PWELL BULK MUX2_X1
X$102303 \$52338 \$43583 \$52155 \$52704 NWELL PWELL BULK MUX2_X1
X$102306 \$48970 \$43583 \$49190 \$48268 NWELL PWELL BULK MUX2_X1
X$102308 \$65667 \$43583 \$66056 \$65668 NWELL PWELL BULK MUX2_X1
X$102311 \$49548 \$43583 \$48666 \$49655 NWELL PWELL BULK MUX2_X1
X$102314 \$52158 \$43583 \$52159 \$52588 NWELL PWELL BULK MUX2_X1
X$102316 \$53417 \$43583 \$52954 \$52955 NWELL PWELL BULK MUX2_X1
X$102318 \$50339 \$43583 \$50336 \$50234 NWELL PWELL BULK MUX2_X1
X$102320 \$44068 \$43583 \$43612 \$44334 NWELL PWELL BULK MUX2_X1
X$102322 \$44697 \$43583 \$45025 \$44333 NWELL PWELL BULK MUX2_X1
X$102324 \$44650 \$43583 \$44361 \$44988 NWELL PWELL BULK MUX2_X1
X$102326 \$44969 \$43583 \$44705 \$44645 NWELL PWELL BULK MUX2_X1
X$102328 \$45832 \$43583 \$45320 \$45834 NWELL PWELL BULK MUX2_X1
X$102330 \$48291 \$43583 \$48017 \$48355 NWELL PWELL BULK MUX2_X1
X$102332 \$45507 \$43583 \$45499 \$45488 NWELL PWELL BULK MUX2_X1
X$102335 \$44429 \$43583 \$43995 \$44315 NWELL PWELL BULK MUX2_X1
X$102337 \$45309 \$43583 \$46288 \$45860 NWELL PWELL BULK MUX2_X1
X$102340 \$45550 \$43583 \$45544 \$45897 NWELL PWELL BULK MUX2_X1
X$102342 \$48808 \$43583 \$48292 \$48293 NWELL PWELL BULK MUX2_X1
X$102344 \$51792 \$43583 \$50935 \$51381 NWELL PWELL BULK MUX2_X1
X$102346 \$56818 \$43583 \$56448 \$56742 NWELL PWELL BULK MUX2_X1
X$102348 \$57368 \$43583 \$58219 \$57821 NWELL PWELL BULK MUX2_X1
X$102350 \$55203 \$43583 \$55970 \$55547 NWELL PWELL BULK MUX2_X1
X$102352 \$56820 \$43583 \$56807 \$57373 NWELL PWELL BULK MUX2_X1
X$102354 \$62902 \$43583 \$62342 \$62348 NWELL PWELL BULK MUX2_X1
X$102356 \$63578 \$43583 \$64449 \$63997 NWELL PWELL BULK MUX2_X1
X$102358 \$63218 \$43583 \$63187 \$62295 NWELL PWELL BULK MUX2_X1
X$102421 \$44309 \$43986 \$43584 \$44119 NWELL PWELL BULK MUX2_X1
X$102426 \$44309 \$44310 \$43586 \$44440 NWELL PWELL BULK MUX2_X1
X$102432 \$44105 \$43587 \$44312 NWELL PWELL BULK NOR2_X4
X$102434 \$71555 \$72837 \$48100 \$43588 NWELL PWELL BULK MUX2_X2
X$102449 \$44113 \$43989 \$44726 \$43589 NWELL PWELL BULK MUX2_X2
X$102466 \$46244 \$46239 \$46092 \$43595 NWELL PWELL BULK MUX2_X2
X$102471 \$45453 \$44726 \$45834 \$43596 NWELL PWELL BULK MUX2_X1
X$102487 \$I178104 \$43607 \$43605 \$43999 NWELL PWELL BULK DFF_X1
X$102502 \$46925 \$46092 \$46915 \$43609 NWELL PWELL BULK MUX2_X1
X$102512 \$45324 \$44726 \$44645 \$43610 NWELL PWELL BULK MUX2_X1
X$102526 \$46550 \$46854 \$46092 \$43613 NWELL PWELL BULK MUX2_X2
X$102543 \$44648 \$44622 \$43619 \$45016 NWELL PWELL BULK MUX2_X1
X$102546 \$43619 \$43986 \$44365 \$44364 NWELL PWELL BULK MUX2_X1
X$102548 \$43619 \$44621 \$44682 \$44996 NWELL PWELL BULK MUX2_X1
X$102551 \$43619 \$44310 \$44360 \$44363 NWELL PWELL BULK MUX2_X1
X$102558 M2_AXI_WVALID \$43669 NWELL PWELL BULK CLKBUF_X2
X$102563 \$43981 M2_AXI_WREADY NWELL PWELL BULK BUF_X1
X$102572 \$43636 \$43921 \$44345 \$43920 NWELL PWELL BULK DFF_X1
X$102602 \$43981 \$43669 \$43972 NWELL PWELL BULK NAND2_X4
X$102611 \$44333 \$44334 \$44726 \$43674 NWELL PWELL BULK MUX2_X2
X$102620 \$44387 \$44310 \$44003 \$43682 NWELL PWELL BULK MUX2_X1
X$102627 \$I178029 \$43691 \$44071 \$43920 NWELL PWELL BULK DFF_X1
X$102727 \$43769 \$43975 NWELL PWELL BULK INV_X1
X$102832 \$43798 \$44619 \$44449 \$43987 NWELL PWELL BULK DFF_X1
X$102845 \$I178034 \$43805 \$44124 \$43985 NWELL PWELL BULK DFF_X1
X$102894 \$43839 \$44541 \$44845 NWELL PWELL BULK XNOR2_X2
X$102938 \$43898 \$44282 \$45573 NWELL PWELL BULK AND2_X1
X$102941 \$43898 \$43966 \$44525 NWELL PWELL BULK NOR2_X2
X$102951 \$43966 \$43909 NWELL PWELL BULK INV_X1
X$103108 \$44012 S0_AXI_AWADDR[20] NWELL PWELL BULK BUF_X1
X$103113 \$44038 S0_AXI_AWADDR[31] NWELL PWELL BULK BUF_X1
X$103118 \$I176391 \$45236 \$45873 \$43920 NWELL PWELL BULK DFF_X1
X$103120 \$44234 \$44233 \$44232 \$43920 NWELL PWELL BULK DFF_X1
X$103122 \$44871 \$45354 \$45359 \$43920 NWELL PWELL BULK DFF_X1
X$103124 \$45217 \$45371 \$45368 \$43920 NWELL PWELL BULK DFF_X1
X$103126 \$45635 \$45796 \$45790 \$43920 NWELL PWELL BULK DFF_X1
X$103128 \$45638 \$45391 \$45219 \$43920 NWELL PWELL BULK DFF_X1
X$103131 \$44555 \$45213 \$45343 \$43920 NWELL PWELL BULK DFF_X1
X$103134 \$44661 \$44656 \$44346 \$43920 NWELL PWELL BULK DFF_X1
X$103137 \$I174708 \$44235 \$44370 \$43920 NWELL PWELL BULK DFF_X1
X$103139 \$I174698 \$44687 \$44873 \$43920 NWELL PWELL BULK DFF_X1
X$103141 \$I178018 \$44048 \$44047 \$43920 NWELL PWELL BULK DFF_X1
X$103143 \$46721 \$47319 \$47315 \$43920 NWELL PWELL BULK DFF_X1
X$103145 \$46177 \$46175 \$46016 \$43920 NWELL PWELL BULK DFF_X1
X$103147 \$46191 \$45400 \$45641 \$43920 NWELL PWELL BULK DFF_X1
X$103149 \$I179304 \$44562 \$44699 \$43920 NWELL PWELL BULK DFF_X1
X$103152 \$I174730 \$45226 \$45224 \$43920 NWELL PWELL BULK DFF_X1
X$103155 \$45668 \$43920 NWELL PWELL BULK BUF_X4
X$103158 \$45223 \$44877 \$45037 \$43920 NWELL PWELL BULK DFF_X1
X$103160 \$47160 \$47678 \$47675 \$43920 NWELL PWELL BULK DFF_X1
X$103162 \$46897 \$46895 \$47317 \$43920 NWELL PWELL BULK DFF_X1
X$103165 \$46921 \$46913 \$47161 \$43920 NWELL PWELL BULK DFF_X1
X$103168 \$I178671 \$44741 \$44739 \$43920 NWELL PWELL BULK DFF_X1
X$103171 \$I174970 \$43930 \$44413 \$43920 NWELL PWELL BULK DFF_X1
X$103173 \$I178659 \$45649 \$45231 \$43920 NWELL PWELL BULK DFF_X1
X$103176 \$I174761 \$44879 \$45039 \$43920 NWELL PWELL BULK DFF_X1
X$103179 \$I178655 \$44567 \$44719 \$43920 NWELL PWELL BULK DFF_X1
X$103183 \$I178043 \$43928 \$43929 \$43920 NWELL PWELL BULK DFF_X1
X$103186 \$I178656 \$44240 \$44242 \$43920 NWELL PWELL BULK DFF_X1
X$103189 \$I174683 \$44883 \$45426 \$43920 NWELL PWELL BULK DFF_X1
X$103238 \$I178013 \$44117 \$43935 \$44245 NWELL PWELL BULK DFF_X1
X$103242 \$I178010 \$43938 \$44136 \$44245 NWELL PWELL BULK DFF_X1
X$103250 \$I175032 \$43943 \$43942 \$44164 NWELL PWELL BULK DFF_X1
X$103265 \$43947 \$44159 \$44255 \$44164 NWELL PWELL BULK DFF_X1
X$103282 \$I174415 \$44261 \$43951 \$44262 NWELL PWELL BULK DFF_X1
X$103285 \$I176325 \$44528 \$43954 \$44262 NWELL PWELL BULK DFF_X1
X$103287 \$64166 \$43956 \$49510 \$63664 NWELL PWELL BULK MUX2_X1
X$103290 \$52801 \$43956 \$51628 \$52471 NWELL PWELL BULK MUX2_X1
X$103292 \$55042 \$43956 \$53958 \$55690 NWELL PWELL BULK MUX2_X1
X$103294 \$46462 \$43956 \$46389 \$47085 NWELL PWELL BULK MUX2_X1
X$103296 \$47544 \$43956 \$47542 \$47816 NWELL PWELL BULK MUX2_X1
X$103299 \$56612 \$43956 \$52533 \$56611 NWELL PWELL BULK MUX2_X1
X$103301 \$53989 \$43956 NWELL PWELL BULK BUF_X8
X$103304 \$63916 \$43956 \$63668 NWELL PWELL BULK OR2_X1
X$103307 \$56964 \$43956 \$53134 \$56965 NWELL PWELL BULK MUX2_X1
X$103309 \$59703 \$43956 \$52877 \$60198 NWELL PWELL BULK MUX2_X1
X$103311 \$62802 \$43956 \$56610 \$62513 NWELL PWELL BULK MUX2_X1
X$103333 \$43959 \$45181 \$44844 NWELL PWELL BULK XNOR2_X2
X$103337 \$44224 \$43962 \$I245696 \$43959 NWELL PWELL BULK DFF_X2
X$103349 \$I175177 \$47885 \$48621 \$43962 NWELL PWELL BULK DFF_X1
X$103352 \$48232 \$48632 \$49040 \$43962 NWELL PWELL BULK DFF_X1
X$103354 \$50055 \$49165 \$49523 \$43962 NWELL PWELL BULK DFF_X1
X$103356 \$49791 \$49162 \$49441 \$43962 NWELL PWELL BULK DFF_X1
X$103359 \$49025 \$48627 \$48623 \$43962 NWELL PWELL BULK DFF_X1
X$103362 \$I177505 \$46462 \$47085 \$43962 NWELL PWELL BULK DFF_X1
X$103365 \$I174671 \$46388 \$46708 \$43962 NWELL PWELL BULK DFF_X1
X$103367 \$I177503 \$47554 \$47837 \$43962 NWELL PWELL BULK DFF_X1
X$103370 \$48153 \$47202 \$47200 \$43962 NWELL PWELL BULK DFF_X1
X$103372 \$I177501 \$46066 \$46463 \$43962 NWELL PWELL BULK DFF_X1
X$103375 \$I176437 \$46695 \$46759 \$43962 NWELL PWELL BULK DFF_X1
X$103377 \$47841 \$48144 \$47557 \$43962 NWELL PWELL BULK DFF_X1
X$103380 \$I178801 \$48234 \$48148 \$43962 NWELL PWELL BULK DFF_X1
X$103382 \$47107 \$47499 \$47205 \$43962 NWELL PWELL BULK DFF_X1
X$103385 \$48510 \$47890 \$48508 \$43962 NWELL PWELL BULK DFF_X1
X$103391 \$I176127 \$44541 \$44854 \$43962 NWELL PWELL BULK DFF_X1
X$103394 \$I176088 \$45283 \$45958 \$43962 NWELL PWELL BULK DFF_X1
X$103396 \$I176099 \$45203 \$45196 \$43962 NWELL PWELL BULK DFF_X1
X$103399 \$45694 \$45276 \$45693 \$43962 NWELL PWELL BULK DFF_X1
X$103401 \$I176288 \$45279 \$45619 \$43962 NWELL PWELL BULK DFF_X1
X$103403 \$46465 \$43962 \$I245661 \$46763 NWELL PWELL BULK DFF_X2
X$103405 \$47887 \$43962 NWELL PWELL BULK BUF_X4
X$103407 \$I176353 \$44851 \$45179 \$43962 NWELL PWELL BULK DFF_X1
X$103409 \$I176374 \$45181 \$45595 \$43962 NWELL PWELL BULK DFF_X1
X$103413 \$I176317 \$45268 \$45269 \$43962 NWELL PWELL BULK DFF_X1
X$103416 \$I178806 \$52121 \$52477 \$43962 NWELL PWELL BULK DFF_X1
X$103448 \$43966 \$44282 \$44176 NWELL PWELL BULK AND2_X1
X$103457 \$43972 \$46475 \$46070 \$47126 NWELL PWELL BULK NOR3_X2
X$103460 \$43972 \$46479 \$46070 \$43986 NWELL PWELL BULK OR3_X4
X$103463 \$43972 \$47220 \$48126 NWELL PWELL BULK NAND2_X1
X$103465 \$43972 \$44276 \$45290 \$I241598 NWELL PWELL BULK HA_X1
X$103467 \$43972 \$46069 \$46405 NWELL PWELL BULK NAND2_X1
X$103469 \$43972 \$47218 \$47803 NWELL PWELL BULK NAND2_X1
X$103472 \$43972 \$46070 \$47222 NWELL PWELL BULK NAND2_X1
X$103474 \$43972 \$46475 \$47141 NWELL PWELL BULK NAND2_X1
X$103477 \$43972 \$45701 NWELL PWELL BULK INV_X4
X$103490 \$43973 \$70521 \$84284 \$83899 NWELL PWELL BULK OAI21_X1
X$103492 \$43973 \$71173 \$83028 \$82610 NWELL PWELL BULK OAI21_X1
X$103495 \$43973 \$70514 \$83033 \$82732 NWELL PWELL BULK OAI21_X1
X$103498 \$43973 \$71156 \$82269 \$82343 NWELL PWELL BULK OAI21_X1
X$103511 \$43974 \$44291 \$44608 NWELL PWELL BULK NOR2_X1
X$103513 \$43974 \$44148 \$44291 \$44504 NWELL PWELL BULK OR3_X4
X$103525 \$43978 \$44726 NWELL PWELL BULK BUF_X16
X$103530 \$44300 \$44621 \$44302 \$43979 NWELL PWELL BULK MUX2_X1
X$103532 \$I175002 \$44302 \$43979 \$43985 NWELL PWELL BULK DFF_X1
X$103536 \$45293 \$43981 NWELL PWELL BULK INV_X2
X$103544 \$I178027 \$44306 \$43984 \$43985 NWELL PWELL BULK DFF_X1
X$103546 \$44780 \$44127 \$44782 \$43984 NWELL PWELL BULK AOI21_X1
X$103548 \$45744 \$43985 NWELL PWELL BULK BUF_X4
X$103550 \$47754 \$47235 \$47419 \$43985 NWELL PWELL BULK DFF_X1
X$103553 \$48257 \$48458 \$48457 \$43985 NWELL PWELL BULK DFF_X1
X$103555 \$47006 \$47018 \$47025 \$43985 NWELL PWELL BULK DFF_X1
X$103557 \$47422 \$47763 \$47429 \$43985 NWELL PWELL BULK DFF_X1
X$103560 \$46789 \$46311 \$46499 \$43985 NWELL PWELL BULK DFF_X1
X$103563 \$I177352 \$46081 \$46496 \$43985 NWELL PWELL BULK DFF_X1
X$103566 \$I174745 \$47578 \$47406 \$43985 NWELL PWELL BULK DFF_X1
X$103569 \$I177382 \$46325 \$47042 \$43985 NWELL PWELL BULK DFF_X1
X$103572 \$46288 \$46087 \$46284 \$43985 NWELL PWELL BULK DFF_X1
X$103574 \$45309 \$44954 \$44953 \$43985 NWELL PWELL BULK DFF_X1
X$103577 \$46791 \$46985 \$47384 \$43985 NWELL PWELL BULK DFF_X1
X$103579 \$I174945 \$44611 \$45141 \$43985 NWELL PWELL BULK DFF_X1
X$103581 \$I174999 \$44298 \$44498 \$43985 NWELL PWELL BULK DFF_X1
X$103583 \$45296 \$45295 \$45557 \$43985 NWELL PWELL BULK DFF_X1
X$103586 \$I177354 \$44484 \$44489 \$43985 NWELL PWELL BULK DFF_X1
X$103590 \$46372 \$46655 \$47096 \$43985 NWELL PWELL BULK DFF_X1
X$103592 \$46071 \$47080 \$47084 \$43985 NWELL PWELL BULK DFF_X1
X$103595 \$I179095 \$46780 \$47098 \$43985 NWELL PWELL BULK DFF_X1
X$103598 \$48477 \$47907 \$47908 \$43985 NWELL PWELL BULK DFF_X1
X$103600 \$45550 \$45298 \$45297 \$43985 NWELL PWELL BULK DFF_X1
X$103603 \$45720 \$46373 \$46375 \$43985 NWELL PWELL BULK DFF_X1
X$103605 \$45544 \$45887 \$45546 \$43985 NWELL PWELL BULK DFF_X1
X$103608 \$I174894 \$44304 \$44129 \$43985 NWELL PWELL BULK DFF_X1
X$103610 \$I177341 \$45302 \$45299 \$43985 NWELL PWELL BULK DFF_X1
X$103613 \$I175010 \$44950 \$45538 \$43985 NWELL PWELL BULK DFF_X1
X$103617 \$I176332 \$47228 \$47434 \$43985 NWELL PWELL BULK DFF_X1
X$103620 \$I179037 \$45293 \$45292 \$43985 NWELL PWELL BULK DFF_X1
X$103638 \$45321 \$43986 \$45466 \$45458 NWELL PWELL BULK MUX2_X1
X$103642 \$63170 \$43986 \$67427 \$67428 NWELL PWELL BULK MUX2_X1
X$103644 \$60793 \$43986 \$66759 \$66837 NWELL PWELL BULK MUX2_X1
X$103646 \$52631 \$43986 \$55901 \$55988 NWELL PWELL BULK MUX2_X1
X$103648 \$66021 \$43986 \$66340 \$66632 NWELL PWELL BULK MUX2_X1
X$103651 \$57423 \$43986 \$65348 \$65062 NWELL PWELL BULK MUX2_X1
X$103654 \$60925 \$43986 \$60730 \$61681 NWELL PWELL BULK MUX2_X1
X$103656 \$62303 \$43986 \$64478 \$64482 NWELL PWELL BULK MUX2_X1
X$103658 \$63503 \$43986 \$65178 \$65090 NWELL PWELL BULK MUX2_X1
X$103660 \$59508 \$43986 \$61916 \$62401 NWELL PWELL BULK MUX2_X1
X$103663 \$44631 \$43986 \$45734 \$45847 NWELL PWELL BULK MUX2_X1
X$103665 \$44300 \$43986 \$44298 \$44498 NWELL PWELL BULK MUX2_X1
X$103667 \$49905 \$43986 \$50934 \$50661 NWELL PWELL BULK MUX2_X1
X$103669 \$53284 \$43986 \$53407 \$53405 NWELL PWELL BULK MUX2_X1
X$103672 \$58181 \$43986 \$67209 \$67090 NWELL PWELL BULK MUX2_X1
X$103674 \$55163 \$43986 \$56948 \$56947 NWELL PWELL BULK MUX2_X1
X$103677 \$52936 \$43986 \$53586 \$53054 NWELL PWELL BULK MUX2_X1
X$103680 \$50969 \$43986 \$52572 \$53061 NWELL PWELL BULK MUX2_X1
X$103683 \$48331 \$43986 \$48931 \$48925 NWELL PWELL BULK MUX2_X1
X$103685 \$51362 \$43986 \$52331 \$52330 NWELL PWELL BULK MUX2_X1
X$103688 \$60806 \$43986 \$66098 \$66099 NWELL PWELL BULK MUX2_X1
X$103690 \$48663 \$43986 \$49316 \$49669 NWELL PWELL BULK MUX2_X1
X$103692 \$50226 \$43986 \$55116 \$55530 NWELL PWELL BULK MUX2_X1
X$103694 \$47914 \$43986 \$48458 \$48457 NWELL PWELL BULK MUX2_X1
X$103696 \$64042 \$43986 \$64213 \$64211 NWELL PWELL BULK MUX2_X1
X$103698 \$54566 \$43986 \$59737 \$59743 NWELL PWELL BULK MUX2_X1
X$103700 \$44387 \$43986 \$44975 \$45405 NWELL PWELL BULK MUX2_X1
X$103703 \$44007 \$43986 \$45329 \$45398 NWELL PWELL BULK MUX2_X1
X$103706 \$44034 \$43986 \$45432 \$45821 NWELL PWELL BULK MUX2_X1
X$103709 \$44381 \$43986 \$44777 \$44775 NWELL PWELL BULK MUX2_X1
X$103711 \$44768 \$43986 \$45093 \$44623 NWELL PWELL BULK MUX2_X1
X$103713 \$45717 \$43986 \$45295 \$45557 NWELL PWELL BULK MUX2_X1
X$103715 \$47934 \$43986 \$48797 \$48798 NWELL PWELL BULK MUX2_X1
X$103717 \$51685 \$43986 \$51033 \$51035 NWELL PWELL BULK MUX2_X1
X$103720 \$49877 \$43986 \$50504 \$50030 NWELL PWELL BULK MUX2_X1
X$103722 \$59004 \$43986 \$63774 \$63775 NWELL PWELL BULK MUX2_X1
X$103724 \$54097 \$43986 \$54931 \$54311 NWELL PWELL BULK MUX2_X1
X$103726 \$56740 \$43986 \$55907 \$55941 NWELL PWELL BULK MUX2_X1
X$103729 \$56424 \$43986 \$58606 \$58218 NWELL PWELL BULK MUX2_X1
X$103820 \$49190 \$49316 \$49669 \$43987 NWELL PWELL BULK DFF_X1
X$103823 \$48994 \$49002 \$49006 \$43987 NWELL PWELL BULK DFF_X1
X$103826 \$48970 \$48662 \$48975 \$43987 NWELL PWELL BULK DFF_X1
X$103828 \$I174311 \$50609 \$50608 \$43987 NWELL PWELL BULK DFF_X1
X$103830 \$I177277 \$48274 \$48937 \$43987 NWELL PWELL BULK DFF_X1
X$103833 \$48666 \$48931 \$48925 \$43987 NWELL PWELL BULK DFF_X1
X$103835 \$49548 \$49193 \$49312 \$43987 NWELL PWELL BULK DFF_X1
X$103837 \$49302 \$48905 \$49301 \$43987 NWELL PWELL BULK DFF_X1
X$103840 \$46277 \$46624 \$46628 \$43987 NWELL PWELL BULK DFF_X1
X$103843 \$46089 \$46270 \$46263 \$43987 NWELL PWELL BULK DFF_X1
X$103845 \$48266 \$47921 \$47919 \$43987 NWELL PWELL BULK DFF_X1
X$103847 \$45744 \$43987 NWELL PWELL BULK BUF_X4
X$103850 \$47918 \$47582 \$48077 \$43987 NWELL PWELL BULK DFF_X1
X$103852 \$46792 \$47241 \$47240 \$43987 NWELL PWELL BULK DFF_X1
X$103855 \$48419 \$48959 \$48262 \$43987 NWELL PWELL BULK DFF_X1
X$103857 \$47243 \$46963 \$47242 \$43987 NWELL PWELL BULK DFF_X1
X$103860 \$44626 \$44624 \$45090 \$43987 NWELL PWELL BULK DFF_X1
X$103863 \$44627 \$45082 \$45085 \$43987 NWELL PWELL BULK DFF_X1
X$103866 \$44429 \$44747 \$44749 \$43987 NWELL PWELL BULK DFF_X1
X$103868 \$45499 \$45093 \$44623 \$43987 NWELL PWELL BULK DFF_X1
X$103872 \$45477 \$45079 \$45476 \$43987 NWELL PWELL BULK DFF_X1
X$103875 \$44112 \$43988 \$44118 \$43987 NWELL PWELL BULK DFF_X1
X$103877 \$45507 \$45102 \$44769 \$43987 NWELL PWELL BULK DFF_X1
X$103880 \$47246 \$46801 \$47362 \$43987 NWELL PWELL BULK DFF_X1
X$103882 \$I176748 \$48276 \$47927 \$43987 NWELL PWELL BULK DFF_X1
X$103884 \$46094 \$46258 \$46260 \$43987 NWELL PWELL BULK DFF_X1
X$103886 \$47372 \$46620 \$46621 \$43987 NWELL PWELL BULK DFF_X1
X$103888 \$46610 \$46502 \$46612 \$43987 NWELL PWELL BULK DFF_X1
X$103890 \$45533 \$45306 \$45520 \$43987 NWELL PWELL BULK DFF_X1
X$103892 \$44616 \$44777 \$44775 \$43987 NWELL PWELL BULK DFF_X1
X$103919 \$44309 \$44621 \$43988 \$44118 NWELL PWELL BULK MUX2_X1
X$103926 \$43991 \$44106 \$44435 NWELL PWELL BULK NOR2_X4
X$103928 \$43995 \$44093 \$44095 \$44314 NWELL PWELL BULK DFF_X1
X$103931 \$46100 \$46916 \$46511 \$43999 NWELL PWELL BULK DFF_X1
X$103934 \$46814 \$46815 \$46907 \$43999 NWELL PWELL BULK DFF_X1
X$103936 \$46103 \$46102 \$46233 \$43999 NWELL PWELL BULK DFF_X1
X$103938 \$46205 \$46218 \$46577 \$43999 NWELL PWELL BULK DFF_X1
X$103940 \$46818 \$47330 \$47333 \$43999 NWELL PWELL BULK DFF_X1
X$103942 \$45832 \$46236 \$45739 \$43999 NWELL PWELL BULK DFF_X1
X$103944 \$I178874 \$44319 \$44725 \$43999 NWELL PWELL BULK DFF_X1
X$103947 \$I174614 \$44083 \$44089 \$43999 NWELL PWELL BULK DFF_X1
X$103949 \$45025 \$44975 \$45405 \$43999 NWELL PWELL BULK DFF_X1
X$103951 \$44688 \$44648 \$45016 \$43999 NWELL PWELL BULK DFF_X1
X$103954 \$44068 \$44383 \$44391 \$43999 NWELL PWELL BULK DFF_X1
X$103956 \$44697 \$45033 \$45038 \$43999 NWELL PWELL BULK DFF_X1
X$103959 \$44705 \$44070 \$44000 \$43999 NWELL PWELL BULK DFF_X1
X$103961 \$45332 \$45374 \$45330 \$43999 NWELL PWELL BULK DFF_X1
X$103963 \$46883 \$46566 \$46567 \$43999 NWELL PWELL BULK DFF_X1
X$103965 \$45744 \$43999 NWELL PWELL BULK BUF_X4
X$103967 \$46204 \$46206 \$46219 \$43999 NWELL PWELL BULK DFF_X1
X$103969 \$46118 \$45804 \$45748 \$43999 NWELL PWELL BULK DFF_X1
X$103971 \$45751 \$45329 \$45398 \$43999 NWELL PWELL BULK DFF_X1
X$103973 \$46160 \$45380 \$45385 \$43999 NWELL PWELL BULK DFF_X1
X$103976 \$44361 \$44360 \$44363 \$43999 NWELL PWELL BULK DFF_X1
X$103978 \$44650 \$44682 \$44996 \$43999 NWELL PWELL BULK DFF_X1
X$103981 \$44649 \$44365 \$44364 \$43999 NWELL PWELL BULK DFF_X1
X$103983 \$44969 \$45042 \$45044 \$43999 NWELL PWELL BULK DFF_X1
X$103987 \$45435 \$45432 \$45821 \$43999 NWELL PWELL BULK DFF_X1
X$103989 \$45428 \$45437 \$45053 \$43999 NWELL PWELL BULK DFF_X1
X$103991 \$I178798 \$44406 \$44405 \$43999 NWELL PWELL BULK DFF_X1
X$103994 \$I176222 \$44323 \$44402 \$43999 NWELL PWELL BULK DFF_X1
X$103996 \$45320 \$45440 \$45450 \$43999 NWELL PWELL BULK DFF_X1
X$103999 \$46825 \$46526 \$46538 \$43999 NWELL PWELL BULK DFF_X1
X$104030 \$44034 \$44310 \$44070 \$44000 NWELL PWELL BULK MUX2_X1
X$104035 M2_AXI_WDATA[30] \$44007 NWELL PWELL BULK BUF_X1
X$104037 \$45804 \$44622 \$44007 \$45748 NWELL PWELL BULK MUX2_X1
X$104039 \$44007 \$44310 \$45374 \$45330 NWELL PWELL BULK MUX2_X1
X$104042 \$44007 \$44621 \$45380 \$45385 NWELL PWELL BULK MUX2_X1
X$104050 \$44008 S0_AXI_WID[4] NWELL PWELL BULK BUF_X1
X$104052 \$45395 S0_AXI_WDATA[11] NWELL PWELL BULK BUF_X1
X$104057 M2_AXI_WDATA[13] \$44034 NWELL PWELL BULK BUF_X1
X$104091 \$44034 \$44621 \$45042 \$45044 NWELL PWELL BULK MUX2_X1
X$104093 \$45437 \$44622 \$44034 \$45053 NWELL PWELL BULK MUX2_X1
X$104109 \$44051 \$44043 \$44052 NWELL PWELL BULK NOR2_X4
X$104124 \$44052 \$70514 \$78413 \$78423 NWELL PWELL BULK OAI21_X1
X$104126 \$70521 \$44052 \$78136 \$77799 NWELL PWELL BULK OAI21_X1
X$104128 \$44052 \$71173 \$77561 \$77243 NWELL PWELL BULK OAI21_X1
X$104142 \$44052 \$71156 \$77269 \$76960 NWELL PWELL BULK OAI21_X1
X$104150 \$44064 S1_AXI_WDATA[22] NWELL PWELL BULK BUF_X1
X$104186 \$44631 \$44310 \$44093 \$44095 NWELL PWELL BULK MUX2_X1
X$104227 \$44944 \$44948 \$44127 NWELL PWELL BULK NOR2_X1
X$104245 \$44302 \$44493 \$44484 \$44134 NWELL PWELL BULK MUX2_X1
X$104280 M1_AXI_AWLEN[2] \$44162 NWELL PWELL BULK CLKBUF_X2
X$104283 \$47015 \$47008 \$46442 \$44164 NWELL PWELL BULK DFF_X1
X$104286 \$46652 \$47007 \$46998 \$44164 NWELL PWELL BULK DFF_X1
X$104289 \$46052 \$46335 \$46327 \$44164 NWELL PWELL BULK DFF_X1
X$104291 \$47180 \$47179 \$47404 \$44164 NWELL PWELL BULK DFF_X1
X$104293 \$48090 \$47775 \$47425 \$44164 NWELL PWELL BULK DFF_X1
X$104295 \$I178627 \$44464 \$44248 \$44164 NWELL PWELL BULK DFF_X1
X$104297 \$47787 \$47430 \$47778 \$44164 NWELL PWELL BULK DFF_X1
X$104299 \$48097 \$47190 \$48094 \$44164 NWELL PWELL BULK DFF_X1
X$104302 \$48087 \$48085 \$47766 \$44164 NWELL PWELL BULK DFF_X1
X$104305 \$I175019 \$45250 \$45248 \$44164 NWELL PWELL BULK DFF_X1
X$104308 \$I174953 \$44251 \$44249 \$44164 NWELL PWELL BULK DFF_X1
X$104311 \$45976 \$45529 \$45528 \$44164 NWELL PWELL BULK DFF_X1
X$104314 \$I178812 \$44577 \$44896 \$44164 NWELL PWELL BULK DFF_X1
X$104317 \$47178 \$46978 \$46976 \$44164 NWELL PWELL BULK DFF_X1
X$104319 \$I178530 \$45936 \$45932 \$44164 NWELL PWELL BULK DFF_X1
X$104322 \$I178528 \$46046 \$45927 \$44164 NWELL PWELL BULK DFF_X1
X$104325 \$I174948 \$45245 \$45919 \$44164 NWELL PWELL BULK DFF_X1
X$104328 \$45668 \$44164 NWELL PWELL BULK BUF_X4
X$104331 \$I174716 \$46642 \$46736 \$44164 NWELL PWELL BULK DFF_X1
X$104333 \$I174724 \$46044 \$46042 \$44164 NWELL PWELL BULK DFF_X1
X$104335 \$I178625 \$46440 \$47402 \$44164 NWELL PWELL BULK DFF_X1
X$104337 \$I178553 \$45906 \$45908 \$44164 NWELL PWELL BULK DFF_X1
X$104339 \$45515 \$44898 \$45513 \$44164 NWELL PWELL BULK DFF_X1
X$104341 \$46319 \$46316 \$46049 \$44164 NWELL PWELL BULK DFF_X1
X$104343 \$45523 \$45135 \$45518 \$44164 NWELL PWELL BULK DFF_X1
X$104345 \$I175331 \$44253 \$44476 \$44164 NWELL PWELL BULK DFF_X1
X$104348 \$44494 \$44803 \$44492 \$44164 NWELL PWELL BULK DFF_X1
X$104350 \$44506 \$44808 \$44501 \$44164 NWELL PWELL BULK DFF_X1
X$104352 \$44179 \$44174 \$44166 \$44164 NWELL PWELL BULK DFF_X1
X$104409 \$44195 S0_AXI_AWADDR[14] NWELL PWELL BULK BUF_X1
X$104421 \$56353 \$44216 \$58085 NWELL PWELL BULK NOR2_X2
X$104423 \$44216 \$56664 NWELL PWELL BULK INV_X1
X$104425 \$44216 \$59321 \$58900 \$59324 NWELL PWELL BULK OR3_X1
X$104427 \$44216 \$56353 \$56659 NWELL PWELL BULK OR2_X1
X$104443 \$44216 \$55830 \$55485 \$56197 NWELL PWELL BULK AOI21_X1
X$104453 \$44343 S0_AXI_AWADDR[30] NWELL PWELL BULK BUF_X1
X$104458 \$44712 S0_AXI_AWBURST[0] NWELL PWELL BULK BUF_X1
X$104487 \$I174792 \$44571 \$44244 \$44245 NWELL PWELL BULK DFF_X1
X$104489 \$I174912 \$50157 \$50156 \$44245 NWELL PWELL BULK DFF_X1
X$104491 \$I174929 \$49117 \$49325 \$44245 NWELL PWELL BULK DFF_X1
X$104494 \$I174916 \$49485 \$49483 \$44245 NWELL PWELL BULK DFF_X1
X$104497 \$I174939 \$50159 \$50393 \$44245 NWELL PWELL BULK DFF_X1
X$104499 \$I178541 \$49121 \$49335 \$44245 NWELL PWELL BULK DFF_X1
X$104501 \$I178542 \$48192 \$48425 \$44245 NWELL PWELL BULK DFF_X1
X$104503 \$I178470 \$48581 \$48849 \$44245 NWELL PWELL BULK DFF_X1
X$104505 \$I174789 \$45111 \$45481 \$44245 NWELL PWELL BULK DFF_X1
X$104508 \$I178518 \$44247 \$45105 \$44245 NWELL PWELL BULK DFF_X1
X$104511 \$48456 \$48196 \$48446 \$44245 NWELL PWELL BULK DFF_X1
X$104514 \$I178560 \$47169 \$47374 \$44245 NWELL PWELL BULK DFF_X1
X$104516 \$I174952 \$47863 \$48053 \$44245 NWELL PWELL BULK DFF_X1
X$104519 \$I174752 \$47524 \$47724 \$44245 NWELL PWELL BULK DFF_X1
X$104522 \$I178558 \$46283 \$46435 \$44245 NWELL PWELL BULK DFF_X1
X$104525 \$48075 \$48072 \$47868 \$44245 NWELL PWELL BULK DFF_X1
X$104528 \$I174942 \$48435 \$48195 \$44245 NWELL PWELL BULK DFF_X1
X$104531 \$I174694 \$46733 \$47527 \$44245 NWELL PWELL BULK DFF_X1
X$104533 \$I178555 \$47175 \$47172 \$44245 NWELL PWELL BULK DFF_X1
X$104535 \$I178557 \$48059 \$47865 \$44245 NWELL PWELL BULK DFF_X1
X$104537 \$45668 \$44245 NWELL PWELL BULK BUF_X4
X$104543 \$I174709 \$44246 \$44758 \$44245 NWELL PWELL BULK DFF_X1
X$104546 \$I178519 \$45097 \$45465 \$44245 NWELL PWELL BULK DFF_X1
X$104548 \$I178544 \$46039 \$46622 \$44245 NWELL PWELL BULK DFF_X1
X$104551 \$I178561 \$46035 \$46432 \$44245 NWELL PWELL BULK DFF_X1
X$104554 \$I174803 \$44752 \$44751 \$44245 NWELL PWELL BULK DFF_X1
X$104556 \$I178554 \$45898 \$45895 \$44245 NWELL PWELL BULK DFF_X1
X$104558 \$I178516 \$45238 \$45463 \$44245 NWELL PWELL BULK DFF_X1
X$104560 \$I178546 \$45889 \$46033 \$44245 NWELL PWELL BULK DFF_X1
X$104626 \$50885 \$52469 \$52466 \$44262 NWELL PWELL BULK DFF_X1
X$104629 \$49155 \$49424 \$49154 \$44262 NWELL PWELL BULK DFF_X1
X$104631 \$48961 \$48971 \$48539 \$44262 NWELL PWELL BULK DFF_X1
X$104634 \$50787 \$50883 \$51181 \$44262 NWELL PWELL BULK DFF_X1
X$104637 \$48989 \$48983 \$48615 \$44262 NWELL PWELL BULK DFF_X1
X$104639 \$48960 \$48606 \$48948 \$44262 NWELL PWELL BULK DFF_X1
X$104642 \$49860 \$50099 \$50103 \$44262 NWELL PWELL BULK DFF_X1
X$104644 \$I174631 \$46457 \$46701 \$44262 NWELL PWELL BULK DFF_X1
X$104646 \$I177410 \$47544 \$47816 \$44262 NWELL PWELL BULK DFF_X1
X$104649 \$I177433 \$47546 \$48123 \$44262 NWELL PWELL BULK DFF_X1
X$104652 \$I174431 \$47548 \$47475 \$44262 NWELL PWELL BULK DFF_X1
X$104654 \$47887 \$44262 NWELL PWELL BULK BUF_X4
X$104656 \$47058 \$47067 \$46062 \$44262 NWELL PWELL BULK DFF_X1
X$104659 \$I175058 \$48222 \$48535 \$44262 NWELL PWELL BULK DFF_X1
X$104662 \$I177402 \$47552 \$47834 \$44262 NWELL PWELL BULK DFF_X1
X$104664 \$52464 \$52461 \$51625 \$44262 NWELL PWELL BULK DFF_X1
X$104666 \$I177527 \$52888 \$53526 \$44262 NWELL PWELL BULK DFF_X1
X$104668 \$50570 \$50470 \$50471 \$44262 NWELL PWELL BULK DFF_X1
X$104670 \$51184 \$51173 \$51168 \$44262 NWELL PWELL BULK DFF_X1
X$104673 \$51626 \$51489 \$52008 \$44262 NWELL PWELL BULK DFF_X1
X$104675 \$47059 \$47063 \$47061 \$44262 NWELL PWELL BULK DFF_X1
X$104678 \$45685 \$45568 \$45989 \$44262 NWELL PWELL BULK DFF_X1
X$104680 \$I177444 \$44587 \$44263 \$44262 NWELL PWELL BULK DFF_X1
X$104684 \$44589 \$44262 \$I245583 \$45173 NWELL PWELL BULK DFF_X2
X$104686 \$I177438 \$45584 \$45578 \$44262 NWELL PWELL BULK DFF_X1
X$104688 \$I177506 \$44534 \$44589 \$44262 NWELL PWELL BULK DFF_X1
X$104691 \$45259 \$45553 \$45537 \$44262 NWELL PWELL BULK DFF_X1
X$104693 \$I177435 \$44512 \$44824 \$44262 NWELL PWELL BULK DFF_X1
X$104695 \$46380 \$45264 \$45575 \$44262 NWELL PWELL BULK DFF_X1
X$104733 \$44845 \$44844 \$44272 \$45270 NWELL PWELL BULK NAND3_X4
X$104737 \$44276 \$45286 \$45697 NWELL PWELL BULK NAND2_X1
X$104739 \$44276 \$44277 \$44596 NWELL PWELL BULK NAND2_X1
X$104741 \$44276 \$44601 \$44937 NWELL PWELL BULK NAND2_X1
X$104743 \$44276 \$44599 \$45176 NWELL PWELL BULK NAND2_X1
X$104746 \$44276 \$44933 \$45169 NWELL PWELL BULK NAND2_X1
X$104749 \$44276 \$44597 \$44931 NWELL PWELL BULK NAND2_X1
X$104752 \$44276 \$44832 NWELL PWELL BULK INV_X2
X$104761 \$44926 \$44929 \$45176 \$44278 NWELL PWELL BULK AOI21_X1
X$104764 \$44926 \$44602 \$44937 \$44279 NWELL PWELL BULK AOI21_X1
X$104770 \$44606 \$45149 \$44292 \$44282 NWELL PWELL BULK AOI21_X1
X$104780 \$44525 \$44286 \$44607 NWELL PWELL BULK NAND2_X1
X$104785 \$44607 \$44814 \$44822 \$44288 NWELL PWELL BULK NAND3_X1
X$104788 \$62257 \$54313 \$I245531 \$44291 NWELL PWELL BULK DFF_X2
X$104791 \$44291 \$62768 \$62767 NWELL PWELL BULK XNOR2_X1
X$104812 \$44611 \$44493 \$44298 \$44801 NWELL PWELL BULK MUX2_X1
X$104816 M2_AXI_WLAST \$44300 NWELL PWELL BULK CLKBUF_X2
X$104819 \$44300 \$44310 \$44484 \$44489 NWELL PWELL BULK MUX2_X1
X$104825 \$44611 \$44622 \$44300 \$45141 NWELL PWELL BULK MUX2_X1
X$104846 \$44782 \$44306 \$44780 NWELL PWELL BULK NOR2_X1
X$104851 M2_AXI_WID[0] \$44309 NWELL PWELL BULK BUF_X1
X$104854 \$44619 \$44622 \$44309 \$44449 NWELL PWELL BULK MUX2_X1
X$104870 \$45321 \$44310 \$45440 \$45450 NWELL PWELL BULK MUX2_X1
X$104872 \$47934 \$44310 \$48012 \$47677 NWELL PWELL BULK MUX2_X1
X$104875 \$56740 \$44310 \$57376 \$57445 NWELL PWELL BULK MUX2_X1
X$104878 \$59004 \$44310 \$65412 \$64860 NWELL PWELL BULK MUX2_X1
X$104882 \$60925 \$44310 \$62720 \$62718 NWELL PWELL BULK MUX2_X1
X$104885 \$63503 \$44310 \$65098 \$64798 NWELL PWELL BULK MUX2_X1
X$104887 \$46475 \$46070 \$45701 \$44310 NWELL PWELL BULK NAND3_X4
X$104890 \$59508 \$44310 \$62304 \$62896 NWELL PWELL BULK MUX2_X1
X$104893 \$62303 \$44310 \$64005 \$64021 NWELL PWELL BULK MUX2_X1
X$104897 \$49905 \$44310 \$49969 \$49973 NWELL PWELL BULK MUX2_X1
X$104899 \$50226 \$44310 \$56719 \$56969 NWELL PWELL BULK MUX2_X1
X$104901 \$55163 \$44310 \$55623 \$55536 NWELL PWELL BULK MUX2_X1
X$104904 \$54566 \$44310 \$59715 \$59719 NWELL PWELL BULK MUX2_X1
X$104906 \$54097 \$44310 \$54909 \$55334 NWELL PWELL BULK MUX2_X1
X$104908 \$50969 \$44310 \$52747 \$52141 NWELL PWELL BULK MUX2_X1
X$104911 \$49877 \$44310 \$50024 \$50482 NWELL PWELL BULK MUX2_X1
X$104913 \$51362 \$44310 \$52708 \$52709 NWELL PWELL BULK MUX2_X1
X$104915 \$60793 \$44310 \$65809 \$66116 NWELL PWELL BULK MUX2_X1
X$104917 \$57423 \$44310 \$66587 \$66352 NWELL PWELL BULK MUX2_X1
X$104919 \$58181 \$44310 \$66062 \$65745 NWELL PWELL BULK MUX2_X1
X$104921 \$60806 \$44310 \$66093 \$66089 NWELL PWELL BULK MUX2_X1
X$104924 \$48663 \$44310 \$48959 \$48262 NWELL PWELL BULK MUX2_X1
X$104927 \$47914 \$44310 \$49027 \$49021 NWELL PWELL BULK MUX2_X1
X$104929 \$52936 \$44310 \$53565 \$53050 NWELL PWELL BULK MUX2_X1
X$104932 \$48331 \$44310 \$48880 \$48892 NWELL PWELL BULK MUX2_X1
X$104934 \$64042 \$44310 \$64858 \$65365 NWELL PWELL BULK MUX2_X1
X$104938 \$44381 \$44310 \$46087 \$46284 NWELL PWELL BULK MUX2_X1
X$104940 \$44768 \$44310 \$45082 \$45085 NWELL PWELL BULK MUX2_X1
X$104943 \$45717 \$44310 \$45887 \$45546 NWELL PWELL BULK MUX2_X1
X$104946 \$51685 \$44310 \$53371 \$52998 NWELL PWELL BULK MUX2_X1
X$104948 \$66021 \$44310 \$66625 \$66341 NWELL PWELL BULK MUX2_X1
X$104951 \$56424 \$44310 \$56839 \$56738 NWELL PWELL BULK MUX2_X1
X$104953 \$53284 \$44310 \$54747 \$54223 NWELL PWELL BULK MUX2_X1
X$104955 \$63170 \$44310 \$65301 \$65310 NWELL PWELL BULK MUX2_X1
X$104958 \$52631 \$44310 \$54686 \$54688 NWELL PWELL BULK MUX2_X1
X$105044 \$70521 \$44312 \$81572 \$81543 NWELL PWELL BULK OAI21_X1
X$105047 \$44312 \$71156 \$80191 \$80542 NWELL PWELL BULK OAI21_X1
X$105050 \$44312 \$70514 \$81224 \$81542 NWELL PWELL BULK OAI21_X1
X$105053 \$44312 \$71173 \$81555 \$81915 NWELL PWELL BULK OAI21_X1
X$105061 \$51115 \$51104 \$51090 \$44314 NWELL PWELL BULK DFF_X1
X$105063 \$I175286 \$51366 \$51858 \$44314 NWELL PWELL BULK DFF_X1
X$105066 \$50614 \$51102 \$50693 \$44314 NWELL PWELL BULK DFF_X1
X$105068 \$52158 \$51863 \$51866 \$44314 NWELL PWELL BULK DFF_X1
X$105071 \$47254 \$47256 \$47346 \$44314 NWELL PWELL BULK DFF_X1
X$105073 \$47599 \$47598 \$47258 \$44314 NWELL PWELL BULK DFF_X1
X$105076 \$I175993 \$48375 \$48037 \$44314 NWELL PWELL BULK DFF_X1
X$105079 \$45461 \$45315 \$45842 \$44314 NWELL PWELL BULK DFF_X1
X$105081 \$45460 \$45466 \$45458 \$44314 NWELL PWELL BULK DFF_X1
X$105084 \$47353 \$47248 \$47357 \$44314 NWELL PWELL BULK DFF_X1
X$105086 \$I176086 \$48278 \$48394 \$44314 NWELL PWELL BULK DFF_X1
X$105089 \$I174579 \$48395 \$48046 \$44314 NWELL PWELL BULK DFF_X1
X$105092 \$48860 \$47930 \$48383 \$44314 NWELL PWELL BULK DFF_X1
X$105095 \$47253 \$47706 \$47709 \$44314 NWELL PWELL BULK DFF_X1
X$105098 \$47596 \$47711 \$47591 \$44314 NWELL PWELL BULK DFF_X1
X$105101 \$46592 \$46929 \$46932 \$44314 NWELL PWELL BULK DFF_X1
X$105103 \$46508 \$46809 \$46939 \$44314 NWELL PWELL BULK DFF_X1
X$105105 \$46247 \$46250 \$46246 \$44314 NWELL PWELL BULK DFF_X1
X$105108 \$I175188 \$51842 \$51667 \$44314 NWELL PWELL BULK DFF_X1
X$105111 \$I178681 \$48851 \$48675 \$44314 NWELL PWELL BULK DFF_X1
X$105113 \$49995 \$49994 \$49635 \$44314 NWELL PWELL BULK DFF_X1
X$105115 \$50618 \$51083 \$50616 \$44314 NWELL PWELL BULK DFF_X1
X$105117 \$50373 \$49999 \$50371 \$44314 NWELL PWELL BULK DFF_X1
X$105119 \$49552 \$49198 \$49290 \$44314 NWELL PWELL BULK DFF_X1
X$105122 \$I178680 \$50364 \$50687 \$44314 NWELL PWELL BULK DFF_X1
X$105125 \$49297 \$48880 \$48892 \$44314 NWELL PWELL BULK DFF_X1
X$105127 \$48866 \$48868 \$48385 \$44314 NWELL PWELL BULK DFF_X1
X$105130 \$45744 \$44314 NWELL PWELL BULK BUF_X4
X$105132 \$46803 \$46946 \$46951 \$44314 NWELL PWELL BULK DFF_X1
X$105134 \$45475 \$45734 \$45847 \$44314 NWELL PWELL BULK DFF_X1
X$105156 \$44633 \$44315 \$44726 \$44636 NWELL PWELL BULK MUX2_X2
X$105174 \$44714 \$44327 \$44718 NWELL PWELL BULK NOR2_X2
X$105184 M2_AXI_WDATA[6] \$44381 NWELL PWELL BULK BUF_X1
X$105209 \$44354 S1_AXI_WDATA[10] NWELL PWELL BULK BUF_X1
X$105259 \$44381 \$44621 \$44954 \$44953 NWELL PWELL BULK MUX2_X1
X$105262 \$45306 \$44622 \$44381 \$45520 NWELL PWELL BULK MUX2_X1
X$105268 \$44387 \$44621 \$44383 \$44391 NWELL PWELL BULK MUX2_X1
X$105272 M2_AXI_WDATA[10] \$44387 NWELL PWELL BULK BUF_X1
X$105278 \$45033 \$44622 \$44387 \$45038 NWELL PWELL BULK MUX2_X1
X$105305 \$44411 \$71173 \$73513 \$73515 NWELL PWELL BULK OAI21_X1
X$105308 \$44411 \$71156 \$73508 \$74164 NWELL PWELL BULK OAI21_X1
X$105311 \$44411 \$70514 \$73510 \$73225 NWELL PWELL BULK OAI21_X1
X$105313 \$70521 \$44411 \$72322 \$72665 NWELL PWELL BULK OAI21_X1
X$105318 \$44415 \$44414 \$44411 NWELL PWELL BULK NOR2_X2
X$105338 \$70521 \$44435 \$79838 \$79454 NWELL PWELL BULK OAI21_X1
X$105341 \$44435 \$71173 \$78386 \$78744 NWELL PWELL BULK OAI21_X1
X$105345 \$44435 \$71156 \$78382 \$78799 NWELL PWELL BULK OAI21_X1
X$105347 \$44435 \$70514 \$79833 \$79468 NWELL PWELL BULK OAI21_X1
X$105399 \$66027 \$44493 \$67538 \$66135 NWELL PWELL BULK MUX2_X1
X$105401 \$66137 \$44493 \$65639 \$66579 NWELL PWELL BULK MUX2_X1
X$105403 \$66362 \$44493 \$66033 \$65652 NWELL PWELL BULK MUX2_X1
X$105406 \$63967 \$44493 \$64604 \$64769 NWELL PWELL BULK MUX2_X1
X$105409 \$64613 \$44493 \$64766 \$64609 NWELL PWELL BULK MUX2_X1
X$105412 \$59190 \$44493 \$59735 \$60180 NWELL PWELL BULK MUX2_X1
X$105415 \$62262 \$44493 \$62719 \$62263 NWELL PWELL BULK MUX2_X1
X$105421 \$56721 \$44493 \$57496 \$57493 NWELL PWELL BULK MUX2_X1
X$105423 \$56114 \$44493 \$55868 \$56106 NWELL PWELL BULK MUX2_X1
X$105425 \$49881 \$44493 \$50027 \$49534 NWELL PWELL BULK MUX2_X1
X$105428 \$49170 \$44493 \$49741 \$49533 NWELL PWELL BULK MUX2_X1
X$105430 \$66524 \$44493 \$66367 \$66369 NWELL PWELL BULK MUX2_X1
X$105433 \$66511 \$44493 \$66508 \$66370 NWELL PWELL BULK MUX2_X1
X$105436 \$66482 \$44493 \$66375 \$66476 NWELL PWELL BULK MUX2_X1
X$105439 \$65782 \$44493 \$66038 \$66483 NWELL PWELL BULK MUX2_X1
X$105442 \$49045 \$44493 \$48656 \$49035 NWELL PWELL BULK MUX2_X1
X$105444 \$48652 \$44493 \$48257 \$49065 NWELL PWELL BULK MUX2_X1
X$105446 \$53589 \$44493 \$52934 \$53886 NWELL PWELL BULK MUX2_X1
X$105448 \$51926 \$44493 \$52143 \$52385 NWELL PWELL BULK MUX2_X1
X$105451 \$52395 \$44493 \$52387 \$52140 NWELL PWELL BULK MUX2_X1
X$105454 \$56715 \$44493 \$56972 \$56092 NWELL PWELL BULK MUX2_X1
X$105457 \$64221 \$44493 \$64223 \$64413 NWELL PWELL BULK MUX2_X1
X$105459 \$65378 \$44493 \$65373 \$65060 NWELL PWELL BULK MUX2_X1
X$105461 \$54291 \$44493 \$53775 \$54287 NWELL PWELL BULK MUX2_X1
X$105463 \$56924 \$44493 \$55881 \$56724 NWELL PWELL BULK MUX2_X1
X$105465 \$59720 \$44493 \$58950 \$59477 NWELL PWELL BULK MUX2_X1
X$105468 \$54308 \$44493 \$54304 \$54908 NWELL PWELL BULK MUX2_X1
X$105470 \$55657 \$44493 \$55518 \$55656 NWELL PWELL BULK MUX2_X1
X$105473 \$45720 \$44493 \$45296 \$45905 NWELL PWELL BULK MUX2_X1
X$105477 \$66638 \$44493 \$66339 \$66157 NWELL PWELL BULK MUX2_X1
X$105480 \$65630 \$44493 \$66022 \$66345 NWELL PWELL BULK MUX2_X1
X$105483 \$61219 \$44493 \$61218 \$61884 NWELL PWELL BULK MUX2_X1
X$105486 \$65329 \$44493 \$65315 \$65073 NWELL PWELL BULK MUX2_X1
X$105543 \$44504 \$74910 \$74476 \$70514 NWELL PWELL BULK OR3_X4
X$105548 \$44504 \$74060 \$73494 NWELL PWELL BULK NAND2_X1
X$105552 \$44504 \$75238 \$76062 NWELL PWELL BULK NAND2_X1
X$105554 \$44504 \$74910 \$75617 NWELL PWELL BULK NAND2_X1
X$105556 \$44504 \$75375 \$74476 \$70521 NWELL PWELL BULK OR3_X4
X$105558 \$44504 \$74640 \$74478 NWELL PWELL BULK NAND2_X1
X$105561 \$44504 \$73843 \$72307 \$I241488 NWELL PWELL BULK HA_X1
X$105564 \$44504 \$74062 NWELL PWELL BULK INV_X4
X$105566 \$44504 \$74476 \$74670 NWELL PWELL BULK NAND2_X1
X$105618 \$44537 \$46764 NWELL PWELL BULK BUF_X4
X$105640 \$44983 S0_AXI_AWADDR[6] NWELL PWELL BULK BUF_X1
X$105645 M0_AXI_AWADDR[9] \$45339 NWELL PWELL BULK BUF_X1
X$105650 M2_AXI_AWADDR[2] \$44553 NWELL PWELL BULK BUF_X1
X$105681 M2_AXI_AWADDR[15] \$44572 NWELL PWELL BULK BUF_X1
X$105700 \$54473 \$44584 \$52749 \$54803 NWELL PWELL BULK MUX2_X1
X$105703 \$47548 \$44584 \$47542 \$47475 NWELL PWELL BULK MUX2_X1
X$105706 \$50886 \$44584 \$51628 \$51485 NWELL PWELL BULK MUX2_X1
X$105709 \$61805 \$44584 \$52877 \$62031 NWELL PWELL BULK MUX2_X1
X$105712 \$54036 \$44584 \$53958 \$54829 NWELL PWELL BULK MUX2_X1
X$105715 \$55308 \$44584 \$52533 \$55310 NWELL PWELL BULK MUX2_X1
X$105718 \$47552 \$44584 \$46389 \$47834 NWELL PWELL BULK MUX2_X1
X$105720 \$52888 \$44584 \$52540 \$53526 NWELL PWELL BULK MUX2_X1
X$105722 \$63087 \$44584 \$56610 \$63675 NWELL PWELL BULK MUX2_X1
X$105724 \$56956 \$44584 \$53134 \$57263 NWELL PWELL BULK MUX2_X1
X$105726 \$62797 \$44584 \$49510 \$63294 NWELL PWELL BULK MUX2_X1
X$105728 \$62189 \$44584 \$62499 NWELL PWELL BULK OR2_X1
X$105767 \$44832 \$44597 \$44849 NWELL PWELL BULK NAND2_X1
X$105770 \$44597 \$44601 \$44599 \$44933 NWELL PWELL BULK HA_X1
X$105781 \$44832 \$44601 \$44929 NWELL PWELL BULK NAND2_X1
X$105787 \$44832 \$44604 \$44602 NWELL PWELL BULK NAND2_X1
X$105791 \$46475 \$44604 \$46668 NWELL PWELL BULK XNOR2_X2
X$105810 \$45321 \$44621 \$46236 \$45739 NWELL PWELL BULK MUX2_X1
X$105816 \$53284 \$44621 \$54754 \$54577 NWELL PWELL BULK MUX2_X1
X$105818 \$60793 \$44621 \$65076 \$65288 NWELL PWELL BULK MUX2_X1
X$105820 \$63170 \$44621 \$65072 \$65336 NWELL PWELL BULK MUX2_X1
X$105822 \$56424 \$44621 \$56853 \$56864 NWELL PWELL BULK MUX2_X1
X$105825 \$46479 \$46070 \$45701 \$44621 NWELL PWELL BULK NAND3_X4
X$105828 \$44631 \$44621 \$44747 \$44749 NWELL PWELL BULK MUX2_X1
X$105833 \$47914 \$44621 \$49049 \$49047 NWELL PWELL BULK MUX2_X1
X$105836 \$45717 \$44621 \$45298 \$45297 NWELL PWELL BULK MUX2_X1
X$105839 \$50226 \$44621 \$56986 \$56411 NWELL PWELL BULK MUX2_X1
X$105842 \$54566 \$44621 \$58509 \$58673 NWELL PWELL BULK MUX2_X1
X$105844 \$51362 \$44621 \$51863 \$51866 NWELL PWELL BULK MUX2_X1
X$105847 \$48663 \$44621 \$47921 \$47919 NWELL PWELL BULK MUX2_X1
X$105849 \$58181 \$44621 \$66071 \$66073 NWELL PWELL BULK MUX2_X1
X$105851 \$57423 \$44621 \$65636 \$66026 NWELL PWELL BULK MUX2_X1
X$105854 \$48331 \$44621 \$48905 \$49301 NWELL PWELL BULK MUX2_X1
X$105857 \$49877 \$44621 \$50492 \$49879 NWELL PWELL BULK MUX2_X1
X$105859 \$50969 \$44621 \$51933 \$51352 NWELL PWELL BULK MUX2_X1
X$105862 \$60925 \$44621 \$62729 \$62733 NWELL PWELL BULK MUX2_X1
X$105864 \$64042 \$44621 \$64770 \$65381 NWELL PWELL BULK MUX2_X1
X$105866 \$52936 \$44621 \$54292 \$54295 NWELL PWELL BULK MUX2_X1
X$105868 \$55163 \$44621 \$56916 \$56917 NWELL PWELL BULK MUX2_X1
X$105870 \$49905 \$44621 \$51416 \$51418 NWELL PWELL BULK MUX2_X1
X$105874 \$47934 \$44621 \$48810 \$48361 NWELL PWELL BULK MUX2_X1
X$105876 \$44768 \$44621 \$44624 \$45090 NWELL PWELL BULK MUX2_X1
X$105880 \$51685 \$44621 \$52174 \$52259 NWELL PWELL BULK MUX2_X1
X$105882 \$52631 \$44621 \$53374 \$53839 NWELL PWELL BULK MUX2_X1
X$105884 \$66021 \$44621 \$65906 \$65908 NWELL PWELL BULK MUX2_X1
X$105886 \$59004 \$44621 \$64863 \$64614 NWELL PWELL BULK MUX2_X1
X$105888 \$54097 \$44621 \$55107 \$56223 NWELL PWELL BULK MUX2_X1
X$105890 \$56740 \$44621 \$57452 \$57454 NWELL PWELL BULK MUX2_X1
X$105892 \$63503 \$44621 \$65158 \$65170 NWELL PWELL BULK MUX2_X1
X$105894 \$62303 \$44621 \$64033 \$64034 NWELL PWELL BULK MUX2_X1
X$105896 \$60806 \$44621 \$65769 \$65254 NWELL PWELL BULK MUX2_X1
X$105899 \$59508 \$44621 \$62363 \$62298 NWELL PWELL BULK MUX2_X1
X$105975 \$50340 \$44622 \$49905 \$49985 NWELL PWELL BULK MUX2_X1
X$105983 \$57369 \$44622 \$56424 \$57470 NWELL PWELL BULK MUX2_X1
X$105985 \$56739 \$44622 \$56740 \$56819 NWELL PWELL BULK MUX2_X1
X$105988 \$65730 \$44622 \$63503 \$65731 NWELL PWELL BULK MUX2_X1
X$105993 \$46373 \$44622 \$45717 \$46375 NWELL PWELL BULK MUX2_X1
X$105996 \$49204 \$44622 \$47934 \$49274 NWELL PWELL BULK MUX2_X1
X$105998 \$66379 \$44622 \$58181 \$66443 NWELL PWELL BULK MUX2_X1
X$106001 \$45315 \$44622 \$45321 \$45842 NWELL PWELL BULK MUX2_X1
X$106004 \$45079 \$44622 \$44631 \$45476 NWELL PWELL BULK MUX2_X1
X$106007 \$45102 \$44622 \$44768 \$44769 NWELL PWELL BULK MUX2_X1
X$106009 \$51684 \$44622 \$51685 \$52260 NWELL PWELL BULK MUX2_X1
X$106011 \$44622 \$46658 NWELL PWELL BULK BUF_X16
X$106014 \$44622 \$47126 NWELL PWELL BULK BUF_X8
X$106017 \$55138 \$44622 \$52631 \$55206 NWELL PWELL BULK MUX2_X1
X$106019 \$64050 \$44622 \$62303 \$64056 NWELL PWELL BULK MUX2_X1
X$106021 \$62415 \$44622 \$59508 \$62916 NWELL PWELL BULK MUX2_X1
X$106062 M2_AXI_WDATA[22] \$44631 NWELL PWELL BULK BUF_X1
X$106086 \$46608 \$46804 \$46092 \$44637 NWELL PWELL BULK MUX2_X2
X$106093 \$45059 \$44638 \$45058 NWELL PWELL BULK NOR2_X4
X$106156 \$44718 \$71156 \$75315 \$75249 NWELL PWELL BULK OAI21_X1
X$106158 \$44718 \$71173 \$75924 \$75923 NWELL PWELL BULK OAI21_X1
X$106160 \$44718 \$70514 \$76599 \$76598 NWELL PWELL BULK OAI21_X1
X$106163 \$70521 \$44718 \$76600 \$76997 NWELL PWELL BULK OAI21_X1
X$106185 \$64769 \$44726 \$65060 \$66747 NWELL PWELL BULK MUX2_X1
X$106188 \$45013 \$44988 \$44726 \$45384 NWELL PWELL BULK MUX2_X2
X$106190 \$48293 \$44726 \$48355 \$48286 NWELL PWELL BULK MUX2_X1
X$106193 \$65652 \$44726 \$65073 \$64425 NWELL PWELL BULK MUX2_X1
X$106195 \$56742 \$44726 \$57373 \$58151 NWELL PWELL BULK MUX2_X1
X$106197 \$55547 \$44726 \$54590 \$55904 NWELL PWELL BULK MUX2_X1
X$106199 \$66157 \$44726 \$66345 \$66349 NWELL PWELL BULK MUX2_X1
X$106201 \$52955 \$44726 \$55133 \$54125 NWELL PWELL BULK MUX2_X1
X$106204 \$64413 \$44726 \$64609 \$64767 NWELL PWELL BULK MUX2_X1
X$106207 \$60180 \$44726 \$59477 \$60427 NWELL PWELL BULK MUX2_X1
X$106209 \$61884 \$44726 \$62263 \$60736 NWELL PWELL BULK MUX2_X1
X$106211 \$62295 \$44726 \$62348 \$62296 NWELL PWELL BULK MUX2_X1
X$106214 \$48268 \$44726 \$48414 \$47586 NWELL PWELL BULK MUX2_X1
X$106218 \$45116 \$45860 \$44726 \$45307 NWELL PWELL BULK MUX2_X2
X$106220 \$45905 \$44726 \$45897 \$46354 NWELL PWELL BULK MUX2_X1
X$106223 \$50234 \$44726 \$50332 \$50231 NWELL PWELL BULK MUX2_X1
X$106225 \$66483 \$44726 \$66476 \$66768 NWELL PWELL BULK MUX2_X1
X$106228 \$67093 \$44726 \$66804 \$67095 NWELL PWELL BULK MUX2_X1
X$106230 \$57493 \$44726 \$56724 \$57356 NWELL PWELL BULK MUX2_X1
X$106232 \$49065 \$44726 \$49035 \$48654 NWELL PWELL BULK MUX2_X1
X$106235 \$49533 \$44726 \$49534 \$49535 NWELL PWELL BULK MUX2_X1
X$106238 \$66369 \$44726 \$66370 \$67069 NWELL PWELL BULK MUX2_X1
X$106240 \$66579 \$44726 \$66135 \$66551 NWELL PWELL BULK MUX2_X1
X$106242 \$65668 \$44726 \$66396 \$66042 NWELL PWELL BULK MUX2_X1
X$106244 \$49655 \$44726 \$49643 \$50392 NWELL PWELL BULK MUX2_X1
X$106246 \$56106 \$44726 \$56092 \$55870 NWELL PWELL BULK MUX2_X1
X$106249 \$52704 \$44726 \$52588 \$52947 NWELL PWELL BULK MUX2_X1
X$106251 \$52140 \$44726 \$52385 \$52579 NWELL PWELL BULK MUX2_X1
X$106255 \$53886 \$44726 \$54287 \$53778 NWELL PWELL BULK MUX2_X1
X$106260 \$54908 \$44726 \$55656 \$57341 NWELL PWELL BULK MUX2_X1
X$106263 \$46165 \$44726 \$46119 \$47264 NWELL PWELL BULK MUX2_X1
X$106268 \$51381 \$44726 \$52177 \$50938 NWELL PWELL BULK MUX2_X1
X$106270 \$57821 \$44726 \$57763 \$57804 NWELL PWELL BULK MUX2_X1
X$106272 \$63997 \$44726 \$64469 \$64447 NWELL PWELL BULK MUX2_X1
X$106379 M2_AXI_WDATA[7] \$44768 NWELL PWELL BULK BUF_X1
X$106411 \$50917 \$50217 \$44782 \$50915 NWELL PWELL BULK AOI21_X1
X$106413 \$44782 \$49893 \$50917 NWELL PWELL BULK NOR2_X1
X$106416 \$48689 \$44782 NWELL PWELL BULK BUF_X8
X$106419 \$44782 \$49184 \$49543 NWELL PWELL BULK NOR2_X1
X$106421 \$49543 \$49541 \$44782 \$49689 NWELL PWELL BULK AOI21_X1
X$106423 \$51455 \$51171 \$44782 \$51904 NWELL PWELL BULK AOI21_X1
X$106427 \$44782 \$52149 \$51455 NWELL PWELL BULK NOR2_X1
X$106430 \$60496 \$58952 \$44782 \$59478 NWELL PWELL BULK AOI21_X1
X$106432 \$44782 \$61231 \$61229 NWELL PWELL BULK NOR2_X1
X$106434 \$61229 \$61227 \$44782 \$60740 NWELL PWELL BULK AOI21_X1
X$106436 \$62560 \$61237 \$44782 \$61240 NWELL PWELL BULK AOI21_X1
X$106438 \$44782 \$62545 \$62560 NWELL PWELL BULK NOR2_X1
X$106441 \$62279 \$62857 \$44782 \$61899 NWELL PWELL BULK AOI21_X1
X$106444 \$44782 \$61243 \$62279 NWELL PWELL BULK NOR2_X1
X$106447 \$44782 \$60038 \$60496 NWELL PWELL BULK NOR2_X1
X$106449 \$44782 \$59484 \$60862 NWELL PWELL BULK NOR2_X1
X$106452 \$60862 \$59482 \$44782 \$60748 NWELL PWELL BULK AOI21_X1
X$106455 \$55524 \$55297 \$44782 \$55649 NWELL PWELL BULK AOI21_X1
X$106457 \$44782 \$55307 \$55524 NWELL PWELL BULK NOR2_X1
X$106459 \$58516 \$58514 \$44782 \$58668 NWELL PWELL BULK AOI21_X1
X$106461 \$44782 \$58517 \$58516 NWELL PWELL BULK NOR2_X1
X$106463 \$44782 \$56711 \$56710 NWELL PWELL BULK NOR2_X1
X$106465 \$56710 \$56709 \$44782 \$57514 NWELL PWELL BULK AOI21_X1
X$106472 \$44782 \$61895 \$62603 NWELL PWELL BULK NOR2_X1
X$106475 \$62603 \$61891 \$44782 \$61531 NWELL PWELL BULK AOI21_X1
X$106503 \$70429 \$63210 \$44789 \$70614 NWELL PWELL BULK MUX2_X1
X$106506 \$69839 \$62451 \$44789 \$70432 NWELL PWELL BULK MUX2_X1
X$106509 \$70434 \$61799 \$44789 \$70626 NWELL PWELL BULK MUX2_X1
X$106511 \$70094 \$69838 \$44789 \$70097 NWELL PWELL BULK MUX2_X1
X$106538 \$44814 \$45149 NWELL PWELL BULK INV_X1
X$106557 \$45701 \$44832 \$I241030 \$45706 NWELL PWELL BULK HA_X1
X$106560 \$44832 \$45699 \$45956 NWELL PWELL BULK NAND2_X1
X$106563 \$44832 \$45700 \$45591 NWELL PWELL BULK NAND2_X1
X$106596 \$45276 \$44851 \$45611 \$45278 NWELL PWELL BULK HA_X1
X$106619 M1_AXI_AWADDR[3] \$45365 NWELL PWELL BULK BUF_X1
X$106630 \$44872 S0_AXI_AWID[1] NWELL PWELL BULK BUF_X1
X$106703 M0_AXI_AWLEN[2] \$44899 NWELL PWELL BULK CLKBUF_X2
X$106728 \$61170 \$44926 \$61045 NWELL PWELL BULK NOR2_X1
X$106731 \$60012 \$60390 \$60389 \$44926 \$59448 NWELL PWELL BULK NOR4_X1
X$106734 \$60364 \$62819 \$56641 \$44926 \$63400 NWELL PWELL BULK NOR4_X1
X$106737 \$44926 \$73665 \$73379 \$74156 NWELL PWELL BULK AOI21_X1
X$106739 \$44926 \$73980 \$74175 \$73674 NWELL PWELL BULK AOI21_X1
X$106741 \$44926 \$73666 \$73667 \$72221 NWELL PWELL BULK AOI21_X1
X$106743 \$44926 \$74979 \$74980 \$74820 NWELL PWELL BULK AOI21_X1
X$106745 \$44926 \$73671 \$73979 \$71835 NWELL PWELL BULK AOI21_X1
X$106747 \$70962 \$44926 \$70795 NWELL PWELL BULK NOR2_X1
X$106749 \$44926 \$70973 \$70800 \$70968 NWELL PWELL BULK AOI21_X1
X$106751 \$61120 \$44926 \$60963 NWELL PWELL BULK NOR2_X1
X$106753 \$72638 \$44926 \$73833 NWELL PWELL BULK NOR2_X1
X$106758 \$65316 \$44926 \$65327 NWELL PWELL BULK NOR2_X1
X$106761 \$44926 \$64720 \$65349 \$64928 NWELL PWELL BULK AOI21_X1
X$106764 \$44926 \$64717 \$65345 \$64715 NWELL PWELL BULK AOI21_X1
X$106767 \$44926 \$74478 \$74913 \$74914 NWELL PWELL BULK AOI21_X1
X$106770 \$44926 \$76062 \$75239 \$75237 NWELL PWELL BULK AOI21_X1
X$106773 \$44926 \$75617 \$75236 \$75912 NWELL PWELL BULK AOI21_X1
X$106776 \$44926 \$74670 \$75028 \$75035 NWELL PWELL BULK AOI21_X1
X$106779 \$54555 \$44926 \$54556 NWELL PWELL BULK NOR2_X1
X$106781 \$57220 \$44926 \$56686 NWELL PWELL BULK NOR2_X1
X$106783 \$44926 \$45956 \$45697 \$45696 NWELL PWELL BULK AOI21_X1
X$106785 \$47139 \$44926 \$46681 NWELL PWELL BULK NOR2_X1
X$106788 \$45184 \$44926 \$45603 NWELL PWELL BULK NOR2_X1
X$106790 \$44926 \$47222 \$47221 \$46770 NWELL PWELL BULK AOI21_X1
X$106792 \$48486 \$44926 \$48236 NWELL PWELL BULK NOR2_X1
X$106795 \$44926 \$47793 \$47571 \$47570 NWELL PWELL BULK AOI21_X1
X$106798 \$44926 \$47903 \$47780 \$47772 NWELL PWELL BULK AOI21_X1
X$106801 \$44926 \$51986 \$51348 \$51985 NWELL PWELL BULK AOI21_X1
X$106803 \$44926 \$51472 \$51345 \$51647 NWELL PWELL BULK AOI21_X1
X$106807 \$44926 \$49869 \$50515 \$50516 NWELL PWELL BULK AOI21_X1
X$106809 \$44926 \$65941 \$65626 \$66167 NWELL PWELL BULK AOI21_X1
X$106811 \$44926 \$50584 \$50760 \$50200 NWELL PWELL BULK AOI21_X1
X$106814 \$44926 \$49394 \$48642 \$48641 NWELL PWELL BULK AOI21_X1
X$106817 \$44926 \$48644 \$48483 \$48245 NWELL PWELL BULK AOI21_X1
X$106819 \$50764 \$44926 \$51242 NWELL PWELL BULK NOR2_X1
X$106822 \$49762 \$44926 \$49525 NWELL PWELL BULK NOR2_X1
X$106824 \$44926 \$56391 \$56242 \$55855 NWELL PWELL BULK AOI21_X1
X$106827 \$44926 \$55361 \$55511 \$55097 NWELL PWELL BULK AOI21_X1
X$106830 \$56297 \$44926 \$55849 NWELL PWELL BULK NOR2_X1
X$106833 \$44926 \$58493 \$57333 \$58491 NWELL PWELL BULK AOI21_X1
X$106836 \$62767 \$44926 \$62257 NWELL PWELL BULK NOR2_X1
X$106838 \$44926 \$64888 \$65476 \$64753 NWELL PWELL BULK AOI21_X1
X$106840 \$44926 \$64639 \$64889 \$64404 NWELL PWELL BULK AOI21_X1
X$106842 \$61205 \$44926 \$61207 NWELL PWELL BULK NOR2_X1
X$106845 \$44926 \$57181 \$55854 \$57334 NWELL PWELL BULK AOI21_X1
X$106847 \$44926 \$64760 \$64884 \$64759 NWELL PWELL BULK AOI21_X1
X$106849 \$44926 \$62737 \$62248 NWELL PWELL BULK OR2_X1
X$106851 \$62836 \$44926 \$63146 NWELL PWELL BULK NOR2_X1
X$106855 \$60971 \$44926 \$60021 NWELL PWELL BULK NOR2_X1
X$106857 \$44926 \$75905 \$75906 \$76418 NWELL PWELL BULK AOI21_X1
X$106859 \$44926 \$74673 \$74057 \$74472 NWELL PWELL BULK AOI21_X1
X$106861 \$44926 \$75397 \$75405 \$75401 NWELL PWELL BULK AOI21_X1
X$106863 \$44926 \$75718 \$75717 \$75903 NWELL PWELL BULK AOI21_X1
X$106865 \$44926 \$45591 \$44931 \$45287 NWELL PWELL BULK AOI21_X1
X$106872 \$44926 \$46405 \$46766 \$46470 NWELL PWELL BULK AOI21_X1
X$106875 \$48497 \$44926 \$48121 NWELL PWELL BULK NOR2_X1
X$106878 \$44926 \$48126 \$47797 \$47568 NWELL PWELL BULK AOI21_X1
X$106880 \$44926 \$47141 \$47145 \$46473 NWELL PWELL BULK AOI21_X1
X$106883 \$45291 \$44926 \$45292 NWELL PWELL BULK NOR2_X1
X$106886 \$45708 \$44926 \$45928 NWELL PWELL BULK NOR2_X1
X$106888 \$66565 \$44926 \$66566 NWELL PWELL BULK NOR2_X1
X$106890 \$44926 \$65982 \$66204 \$65848 NWELL PWELL BULK AOI21_X1
X$106892 \$44926 \$66924 \$66292 \$66923 NWELL PWELL BULK AOI21_X1
X$106895 \$44926 \$74594 \$73983 \$74988 NWELL PWELL BULK AOI21_X1
X$106898 \$75831 \$44926 \$75989 NWELL PWELL BULK NOR2_X1
X$106900 \$75175 \$44926 \$75696 NWELL PWELL BULK NOR2_X1
X$106902 \$44926 \$73702 \$73394 \$74190 NWELL PWELL BULK AOI21_X1
X$106905 \$44926 \$72044 \$71847 \$72046 NWELL PWELL BULK AOI21_X1
X$106907 \$44926 \$71683 \$71096 \$71492 NWELL PWELL BULK AOI21_X1
X$106910 \$44926 \$73680 \$73982 NWELL PWELL BULK OR2_X1
X$106912 \$44926 \$73385 \$73678 \$73088 NWELL PWELL BULK AOI21_X1
X$106915 \$44926 \$72542 \$73265 \$72761 NWELL PWELL BULK AOI21_X1
X$106918 \$44926 \$73711 \$73712 \$72552 NWELL PWELL BULK AOI21_X1
X$106920 \$44926 \$72429 \$72551 \$71850 NWELL PWELL BULK AOI21_X1
X$106922 \$44926 \$71314 \$71100 \$71493 NWELL PWELL BULK AOI21_X1
X$106924 \$70452 \$44926 \$70671 NWELL PWELL BULK NOR2_X1
X$106926 \$67328 \$44926 \$66915 NWELL PWELL BULK NOR2_X1
X$106928 \$44926 \$70445 \$69845 \$70446 NWELL PWELL BULK AOI21_X1
X$107064 \$45370 S0_AXI_WDATA[2] NWELL PWELL BULK BUF_X1
X$107123 \$45058 \$70514 \$82625 \$82624 NWELL PWELL BULK OAI21_X1
X$107126 \$70521 \$45058 \$82653 \$82663 NWELL PWELL BULK OAI21_X1
X$107129 \$45058 \$71156 \$81230 \$81549 NWELL PWELL BULK OAI21_X1
X$107132 \$45058 \$71173 \$82630 \$82954 NWELL PWELL BULK OAI21_X1
X$107164 \$45088 S0_AXI_AWADDR[22] NWELL PWELL BULK BUF_X1
X$107228 \$45286 \$45169 \$45184 NWELL PWELL BULK XOR2_X1
X$107231 \$47548 \$45173 \$48222 \$48128 NWELL PWELL BULK MUX2_X1
X$107233 \$62802 \$45173 \$62195 \$63317 NWELL PWELL BULK MUX2_X1
X$107236 \$52801 \$45173 \$52809 \$52816 NWELL PWELL BULK MUX2_X1
X$107238 \$50886 \$45173 \$51633 \$52120 NWELL PWELL BULK MUX2_X1
X$107240 \$56956 \$45173 \$55796 \$57532 NWELL PWELL BULK MUX2_X1
X$107242 \$59703 \$45173 \$60659 \$60660 NWELL PWELL BULK MUX2_X1
X$107244 \$55042 \$45173 \$55325 \$55328 NWELL PWELL BULK MUX2_X1
X$107246 \$54036 \$45173 \$54039 \$55044 NWELL PWELL BULK MUX2_X1
X$107248 \$46462 \$45173 \$46066 \$47480 NWELL PWELL BULK MUX2_X1
X$107250 \$47544 \$45173 \$47546 \$47824 NWELL PWELL BULK MUX2_X1
X$107252 \$47552 \$45173 \$47554 \$47553 NWELL PWELL BULK MUX2_X1
X$107254 \$45173 \$53151 NWELL PWELL BULK BUF_X16
X$107256 \$56612 \$45173 \$56613 \$56946 NWELL PWELL BULK MUX2_X1
X$107258 \$62189 \$45173 \$62190 \$63086 NWELL PWELL BULK MUX2_X1
X$107261 \$63916 \$45173 \$64187 \$63917 NWELL PWELL BULK MUX2_X1
X$107263 \$63087 \$45173 \$63684 \$63691 NWELL PWELL BULK MUX2_X1
X$107265 \$62797 \$45173 \$62494 \$63085 NWELL PWELL BULK MUX2_X1
X$107267 \$64166 \$45173 \$63913 \$63377 NWELL PWELL BULK MUX2_X1
X$107269 \$56964 \$45173 \$56086 \$56617 NWELL PWELL BULK MUX2_X1
X$107271 \$61805 \$45173 \$61117 \$61474 NWELL PWELL BULK MUX2_X1
X$107336 M0_AXI_AWADDR[8] \$46006 NWELL PWELL BULK BUF_X1
X$107347 \$45631 \$45215 \$46135 \$45630 NWELL PWELL BULK DFF_X1
X$107388 \$46044 \$45663 \$45245 \$46045 NWELL PWELL BULK MUX2_X1
X$107410 \$45674 \$45261 NWELL PWELL BULK INV_X1
X$107413 M1_AXI_AWID[3] \$45262 NWELL PWELL BULK CLKBUF_X2
X$107441 \$45270 S0_AXI_AWVALID NWELL PWELL BULK BUF_X1
X$107470 \$45279 \$45617 \$45618 NWELL PWELL BULK XNOR2_X1
X$107498 \$45703 \$45290 \$45705 \$45704 NWELL PWELL BULK MUX2_X1
X$107501 \$45290 \$46390 \$45712 NWELL PWELL BULK NOR2_X1
X$107503 \$45940 \$45290 \$45924 NWELL PWELL BULK NOR2_X1
X$107506 \$45712 \$45710 \$45290 \$45708 NWELL PWELL BULK AOI21_X1
X$107511 \$45293 \$45924 \$45291 NWELL PWELL BULK XNOR2_X1
X$107561 M2_AXI_WDATA[29] \$45321 NWELL PWELL BULK BUF_X1
X$107586 \$45714 M0_AXI_WREADY NWELL PWELL BULK BUF_X1
X$107595 M0_AXI_WVALID \$45793 NWELL PWELL BULK BUF_X2
X$107717 \$I174739 \$45438 \$45442 \$45652 NWELL PWELL BULK DFF_X1
X$107875 S0_AXI_AWREADY \$45593 NWELL PWELL BULK CLKBUF_X2
X$107927 \$46012 \$46013 \$46151 \$45630 NWELL PWELL BULK DFF_X1
X$107931 \$46008 \$46124 \$46131 \$45630 NWELL PWELL BULK DFF_X1
X$107935 \$47647 \$47301 \$47157 \$45630 NWELL PWELL BULK DFF_X1
X$107938 \$48171 \$47850 \$47851 \$45630 NWELL PWELL BULK DFF_X1
X$107941 \$47514 \$47855 \$47667 \$45630 NWELL PWELL BULK DFF_X1
X$107943 \$48757 \$48351 \$48173 \$45630 NWELL PWELL BULK DFF_X1
X$107946 \$48730 \$48727 \$48168 \$45630 NWELL PWELL BULK DFF_X1
X$107949 \$47615 \$48311 \$47950 \$45630 NWELL PWELL BULK DFF_X1
X$107952 \$46839 \$46834 \$46716 \$45630 NWELL PWELL BULK DFF_X1
X$107955 \$46841 \$47282 \$46840 \$45630 NWELL PWELL BULK DFF_X1
X$107957 \$46542 \$46848 \$46413 \$45630 NWELL PWELL BULK DFF_X1
X$107960 \$46875 \$46171 \$46417 \$45630 NWELL PWELL BULK DFF_X1
X$107963 \$46877 \$46864 \$46867 \$45630 NWELL PWELL BULK DFF_X1
X$107965 \$47848 \$47968 \$47622 \$45630 NWELL PWELL BULK DFF_X1
X$107967 \$47649 \$47629 \$47293 \$45630 NWELL PWELL BULK DFF_X1
X$107970 \$48560 \$48765 \$48559 \$45630 NWELL PWELL BULK DFF_X1
X$107973 \$49095 \$49571 \$49458 \$45630 NWELL PWELL BULK DFF_X1
X$107975 \$49461 \$49937 \$49933 \$45630 NWELL PWELL BULK DFF_X1
X$107978 \$51718 \$51714 \$51702 \$45630 NWELL PWELL BULK DFF_X1
X$107980 \$52064 \$52063 \$52061 \$45630 NWELL PWELL BULK DFF_X1
X$107982 \$53318 \$53303 \$52850 \$45630 NWELL PWELL BULK DFF_X1
X$107984 \$51699 \$51695 \$51269 \$45630 NWELL PWELL BULK DFF_X1
X$107986 \$50533 \$50959 \$50951 \$45630 NWELL PWELL BULK DFF_X1
X$107988 \$48748 \$48747 \$49098 \$45630 NWELL PWELL BULK DFF_X1
X$107991 \$48554 \$49239 \$49232 \$45630 NWELL PWELL BULK DFF_X1
X$107994 \$49978 \$49259 \$49256 \$45630 NWELL PWELL BULK DFF_X1
X$107996 \$50248 \$50246 \$50630 \$45630 NWELL PWELL BULK DFF_X1
X$107998 \$48551 \$48165 \$48549 \$45630 NWELL PWELL BULK DFF_X1
X$108000 \$45668 \$45630 NWELL PWELL BULK BUF_X4
X$108003 \$48717 \$49216 \$49222 \$45630 NWELL PWELL BULK DFF_X1
X$108052 \$45668 \$45652 NWELL PWELL BULK BUF_X4
X$108055 \$I178457 \$51585 \$51583 \$45652 NWELL PWELL BULK DFF_X1
X$108058 \$I174910 \$51586 \$52334 \$45652 NWELL PWELL BULK DFF_X1
X$108061 \$I174914 \$50747 \$50556 \$45652 NWELL PWELL BULK DFF_X1
X$108063 \$I177966 \$48188 \$48830 \$45652 NWELL PWELL BULK DFF_X1
X$108065 \$I178000 \$48576 \$48827 \$45652 NWELL PWELL BULK DFF_X1
X$108068 \$I178002 \$49478 \$51071 \$45652 NWELL PWELL BULK DFF_X1
X$108071 \$I178462 \$52515 \$53051 \$45652 NWELL PWELL BULK DFF_X1
X$108073 \$I174684 \$46427 \$46230 \$45652 NWELL PWELL BULK DFF_X1
X$108075 \$48011 \$46934 \$46729 \$45652 NWELL PWELL BULK DFF_X1
X$108078 \$48175 \$48359 \$48363 \$45652 NWELL PWELL BULK DFF_X1
X$108080 \$47162 \$47349 \$47686 \$45652 NWELL PWELL BULK DFF_X1
X$108083 \$I178569 \$46027 \$46428 \$45652 NWELL PWELL BULK DFF_X1
X$108085 \$I177953 \$46429 \$46430 \$45652 NWELL PWELL BULK DFF_X1
X$108087 \$47517 \$47704 \$47703 \$45652 NWELL PWELL BULK DFF_X1
X$108090 \$I178006 \$47167 \$47356 \$45652 NWELL PWELL BULK DFF_X1
X$108092 \$I176393 \$47519 \$47710 \$45652 NWELL PWELL BULK DFF_X1
X$108095 \$I175059 \$48183 \$48399 \$45652 NWELL PWELL BULK DFF_X1
X$108099 \$I178564 \$45863 \$46229 \$45652 NWELL PWELL BULK DFF_X1
X$108101 \$I177997 \$51580 \$52324 \$45652 NWELL PWELL BULK DFF_X1
X$108104 \$51067 \$50842 \$50730 \$45652 NWELL PWELL BULK DFF_X1
X$108107 \$I176363 \$50154 \$50023 \$45652 NWELL PWELL BULK DFF_X1
X$108109 \$I179229 \$49675 \$49673 \$45652 NWELL PWELL BULK DFF_X1
X$108112 \$48791 \$48380 \$48377 \$45652 NWELL PWELL BULK DFF_X1
X$108115 \$51047 \$51051 \$50551 \$45652 NWELL PWELL BULK DFF_X1
X$108117 \$50721 \$50840 \$50359 \$45652 NWELL PWELL BULK DFF_X1
X$108119 \$49649 \$49664 \$49660 \$45652 NWELL PWELL BULK DFF_X1
X$108122 \$I179240 \$49113 \$49293 \$45652 NWELL PWELL BULK DFF_X1
X$108125 \$I175072 \$48184 \$48807 \$45652 NWELL PWELL BULK DFF_X1
X$108128 \$48800 \$48180 \$48799 \$45652 NWELL PWELL BULK DFF_X1
X$108150 M2_AXI_AWADDR[19] \$45662 NWELL PWELL BULK BUF_X1
X$108153 \$46642 \$46734 \$45662 \$46736 NWELL PWELL BULK MUX2_X1
X$108162 \$59391 \$45663 \$60182 \$60188 NWELL PWELL BULK MUX2_X1
X$108164 \$60548 \$45663 \$60339 \$60164 NWELL PWELL BULK MUX2_X1
X$108166 \$46642 \$45663 \$46440 \$45664 NWELL PWELL BULK MUX2_X1
X$108168 \$49485 \$45663 \$50159 \$50043 NWELL PWELL BULK MUX2_X1
X$108170 \$49121 \$45663 \$49123 \$48064 NWELL PWELL BULK MUX2_X1
X$108174 \$58401 \$45663 \$58040 \$58242 NWELL PWELL BULK MUX2_X1
X$108176 \$50343 \$45663 \$50550 \$50149 NWELL PWELL BULK MUX2_X1
X$108179 \$56602 \$45663 \$56915 \$56931 NWELL PWELL BULK MUX2_X1
X$108181 \$59384 \$45663 \$59119 \$59643 NWELL PWELL BULK MUX2_X1
X$108184 \$57887 \$45663 \$58047 \$57513 NWELL PWELL BULK MUX2_X1
X$108187 \$52342 \$45663 \$51589 \$51862 NWELL PWELL BULK MUX2_X1
X$108189 \$51585 \$45663 \$51586 \$51867 NWELL PWELL BULK MUX2_X1
X$108191 \$59655 \$45663 \$59666 \$59660 NWELL PWELL BULK MUX2_X1
X$108194 \$53169 \$45663 \$53171 \$53906 NWELL PWELL BULK MUX2_X1
X$108196 \$57879 \$45663 \$58043 \$57507 NWELL PWELL BULK MUX2_X1
X$108199 \$57254 \$45663 \$57255 \$57503 NWELL PWELL BULK MUX2_X1
X$108201 \$56055 \$45663 \$56330 \$55661 NWELL PWELL BULK MUX2_X1
X$108204 \$47160 \$45663 \$46897 \$46570 NWELL PWELL BULK MUX2_X1
X$108207 \$59685 \$45663 \$59688 \$57261 NWELL PWELL BULK MUX2_X1
X$108209 \$50157 \$45663 \$50747 \$50388 NWELL PWELL BULK MUX2_X1
X$108211 \$52864 \$45663 \$53432 \$53431 NWELL PWELL BULK MUX2_X1
X$108213 \$45663 \$53409 NWELL PWELL BULK BUF_X16
X$108216 \$48059 \$45663 \$48435 \$47866 NWELL PWELL BULK MUX2_X1
X$108218 \$47514 \$45663 \$46721 \$46561 NWELL PWELL BULK MUX2_X1
X$108220 \$59107 \$45663 \$58403 \$58405 NWELL PWELL BULK MUX2_X1
X$108222 \$61101 \$45663 \$60651 \$59383 NWELL PWELL BULK MUX2_X1
X$108224 \$54771 \$45663 \$54773 \$55033 NWELL PWELL BULK MUX2_X1
X$108226 \$56324 \$45663 \$55453 \$55651 NWELL PWELL BULK MUX2_X1
X$108228 \$56926 \$45663 \$56929 \$56607 NWELL PWELL BULK MUX2_X1
X$108230 \$54004 \$45663 \$54459 \$54006 NWELL PWELL BULK MUX2_X1
X$108232 \$58414 \$45663 \$57691 \$58272 NWELL PWELL BULK MUX2_X1
X$108234 \$55446 \$45663 \$55449 \$55253 NWELL PWELL BULK MUX2_X1
X$108236 \$54738 \$45663 \$54744 \$54274 NWELL PWELL BULK MUX2_X1
X$108239 \$49113 \$45663 \$49675 \$48185 NWELL PWELL BULK MUX2_X1
X$108241 \$51047 \$45663 \$50721 \$51049 NWELL PWELL BULK MUX2_X1
X$108243 \$48183 \$45663 \$48184 \$48186 NWELL PWELL BULK MUX2_X1
X$108245 \$58701 \$45663 \$57697 \$57696 NWELL PWELL BULK MUX2_X1
X$108247 \$55788 \$45663 \$56337 \$55791 NWELL PWELL BULK MUX2_X1
X$108250 \$55676 \$45663 \$55461 \$55680 NWELL PWELL BULK MUX2_X1
X$108252 \$61111 \$45663 \$61443 \$60931 NWELL PWELL BULK MUX2_X1
X$108311 \$47368 \$45668 NWELL PWELL BULK BUF_X4
X$108314 \$45668 \$47530 NWELL PWELL BULK BUF_X4
X$108318 \$45668 \$54021 NWELL PWELL BULK BUF_X4
X$108320 \$45668 \$53172 NWELL PWELL BULK BUF_X4
X$108323 \$45668 \$55228 NWELL PWELL BULK BUF_X4
X$108326 \$45668 \$49104 NWELL PWELL BULK BUF_X4
X$108331 \$45668 \$53692 NWELL PWELL BULK BUF_X4
X$108364 \$75686 \$75539 \$50040 \$45674 NWELL PWELL BULK MUX2_X2
X$108381 \$45678 \$45978 NWELL PWELL BULK INV_X1
X$108384 \$46059 \$45681 NWELL PWELL BULK INV_X1
X$108400 \$46069 \$45699 \$46402 NWELL PWELL BULK XNOR2_X2
X$108406 \$46070 \$45700 \$46401 NWELL PWELL BULK XNOR2_X2
X$108410 \$45701 \$47484 \$47797 NWELL PWELL BULK NAND2_X1
X$108416 \$45701 \$46469 \$46766 NWELL PWELL BULK NAND2_X1
X$108418 \$45701 \$47220 \$47145 NWELL PWELL BULK NAND2_X1
X$108421 \$45701 \$47216 \$47489 NWELL PWELL BULK NAND2_X1
X$108424 \$45701 \$47477 \$47490 NWELL PWELL BULK NAND2_X1
X$108427 \$45701 \$47218 \$47221 NWELL PWELL BULK NAND2_X1
X$108437 \$I178537 \$49169 \$48641 \$45702 NWELL PWELL BULK DFF_X1
X$108439 \$48245 \$45702 \$I245563 \$48252 NWELL PWELL BULK DFF_X2
X$108441 \$I176817 \$47112 \$46659 \$45702 NWELL PWELL BULK DFF_X1
X$108443 \$I176773 \$47574 \$47570 \$45702 NWELL PWELL BULK DFF_X1
X$108446 \$47772 \$45702 \$I245719 \$48100 NWELL PWELL BULK DFF_X2
X$108448 \$I177810 \$47226 \$47448 \$45702 NWELL PWELL BULK DFF_X1
X$108451 \$47224 \$47575 \$47452 \$45702 NWELL PWELL BULK DFF_X1
X$108453 \$I176811 \$48244 \$47772 \$45702 NWELL PWELL BULK DFF_X1
X$108456 \$51239 \$51241 \$51249 \$45702 NWELL PWELL BULK DFF_X1
X$108458 \$51985 \$45702 \$I245716 \$49529 NWELL PWELL BULK DFF_X2
X$108460 \$51342 \$50894 \$51343 \$45702 NWELL PWELL BULK DFF_X1
X$108462 \$I174774 \$53257 \$53639 \$45702 NWELL PWELL BULK DFF_X1
X$108465 \$I174848 \$50896 \$51647 \$45702 NWELL PWELL BULK DFF_X1
X$108468 \$52412 \$52415 \$52419 \$45702 NWELL PWELL BULK DFF_X1
X$108470 \$50518 \$45702 NWELL PWELL BULK BUF_X4
X$108472 \$50200 \$45702 \$I245562 \$48645 NWELL PWELL BULK DFF_X2
X$108475 \$49741 \$50504 \$50030 \$45702 NWELL PWELL BULK DFF_X1
X$108477 \$I178539 \$49871 \$50516 \$45702 NWELL PWELL BULK DFF_X1
X$108479 \$I178762 \$48243 \$48245 \$45702 NWELL PWELL BULK DFF_X1
X$108482 \$I178697 \$49527 \$49525 \$45702 NWELL PWELL BULK DFF_X1
X$108485 \$I178476 \$50581 \$51242 \$45702 NWELL PWELL BULK DFF_X1
X$108487 \$48636 \$49403 \$48634 \$45702 NWELL PWELL BULK DFF_X1
X$108489 \$I178493 \$48240 \$48236 \$45702 NWELL PWELL BULK DFF_X1
X$108492 \$I178085 \$55100 \$55515 \$45702 NWELL PWELL BULK DFF_X1
X$108494 \$I175207 \$58496 \$59266 \$45702 NWELL PWELL BULK DFF_X1
X$108496 \$I178372 \$57180 \$55855 \$45702 NWELL PWELL BULK DFF_X1
X$108498 \$I175710 \$54092 \$54324 \$45702 NWELL PWELL BULK DFF_X1
X$108500 \$I176847 \$47900 \$48121 \$45702 NWELL PWELL BULK DFF_X1
X$108503 \$I174303 \$47220 \$47568 \$45702 NWELL PWELL BULK DFF_X1
X$108505 \$45703 \$45705 \$46396 \$45702 NWELL PWELL BULK DFF_X1
X$108507 \$46770 \$45702 \$I245527 \$46070 NWELL PWELL BULK DFF_X2
X$108542 \$45710 \$45707 \$46390 \$46398 \$45705 NWELL PWELL BULK FA_X1
X$108546 \$45706 \$46398 NWELL PWELL BULK INV_X1
X$108550 \$45706 \$45707 \$45940 NWELL PWELL BULK XOR2_X1
X$108569 \$47900 \$45714 NWELL PWELL BULK INV_X2
X$108572 \$45714 \$45793 \$46481 NWELL PWELL BULK NAND2_X4
X$108580 \$47226 \$46093 \$47228 \$45715 NWELL PWELL BULK MUX2_X1
X$108583 M2_AXI_WDATA[9] \$45717 NWELL PWELL BULK CLKBUF_X2
X$108600 \$46996 \$46982 \$46092 \$45726 NWELL PWELL BULK MUX2_X2
X$108613 \$45744 \$51357 NWELL PWELL BULK BUF_X4
X$108615 \$45744 \$48250 NWELL PWELL BULK BUF_X4
X$108623 \$45744 \$53890 NWELL PWELL BULK BUF_X4
X$108626 \$45744 \$49554 NWELL PWELL BULK BUF_X4
X$108632 \$59890 \$45744 NWELL PWELL BULK BUF_X4
X$108635 \$45744 \$46882 NWELL PWELL BULK BUF_X4
X$108637 \$45744 \$54129 NWELL PWELL BULK BUF_X4
X$108656 \$45744 \$54116 NWELL PWELL BULK BUF_X4
X$108674 \$45756 S0_AXI_WDATA[16] NWELL PWELL BULK BUF_X1
X$108706 \$46108 \$46092 \$46519 \$45817 NWELL PWELL BULK MUX2_X1
X$108728 \$45841 S0_AXI_AWSIZE[2] NWELL PWELL BULK BUF_X1
X$108860 \$46644 S0_AXI_AWADDR[13] NWELL PWELL BULK BUF_X1
X$108912 \$46025 S0_AXI_AWADDR[23] NWELL PWELL BULK BUF_X1
X$108965 \$46447 \$46057 NWELL PWELL BULK INV_X1
X$109007 \$46372 \$46093 \$46071 \$46486 NWELL PWELL BULK MUX2_X1
X$109016 \$47248 \$46082 \$47249 \$47357 NWELL PWELL BULK MUX2_X1
X$109021 \$48003 \$46082 \$48295 \$48002 NWELL PWELL BULK MUX2_X1
X$109023 \$46522 \$46082 \$46116 \$46553 NWELL PWELL BULK MUX2_X1
X$109025 \$49080 \$46082 \$47905 \$48248 NWELL PWELL BULK MUX2_X1
X$109028 \$47226 \$46082 \$46777 \$47448 NWELL PWELL BULK MUX2_X1
X$109031 \$46502 \$46082 \$46095 \$46612 NWELL PWELL BULK MUX2_X1
X$109033 \$46655 \$46082 \$46851 \$47096 NWELL PWELL BULK MUX2_X1
X$109035 \$48868 \$46082 \$48283 \$48385 NWELL PWELL BULK MUX2_X1
X$109037 \$53791 \$46082 \$53790 \$54236 NWELL PWELL BULK MUX2_X1
X$109039 \$51102 \$46082 \$50923 \$50693 NWELL PWELL BULK MUX2_X1
X$109041 \$48259 \$46082 \$48437 \$48441 NWELL PWELL BULK MUX2_X1
X$109043 \$46311 \$46082 \$46083 \$46499 NWELL PWELL BULK MUX2_X1
X$109045 \$46082 \$49873 NWELL PWELL BULK BUF_X8
X$109047 \$46218 \$46082 \$46515 \$46577 NWELL PWELL BULK MUX2_X1
X$109049 \$46250 \$46082 \$46097 \$46246 NWELL PWELL BULK MUX2_X1
X$109051 \$50309 \$46082 \$48333 \$50313 NWELL PWELL BULK MUX2_X1
X$109075 M0_AXI_WDATA[6] \$46083 NWELL PWELL BULK BUF_X1
X$109078 \$46083 \$46090 \$47018 \$47025 NWELL PWELL BULK MUX2_X1
X$109080 \$46083 \$46524 \$47241 \$47240 NWELL PWELL BULK MUX2_X1
X$109083 \$46083 \$46512 \$46985 \$47384 NWELL PWELL BULK MUX2_X1
X$109094 \$46277 \$46093 \$46089 \$46274 NWELL PWELL BULK MUX2_X1
X$109097 \$69949 \$46090 \$69948 \$69712 NWELL PWELL BULK MUX2_X1
X$109099 \$47249 \$46090 \$47711 \$47591 NWELL PWELL BULK MUX2_X1
X$109102 \$71336 \$46090 \$71335 \$71334 NWELL PWELL BULK MUX2_X1
X$109104 \$46097 \$46090 \$46809 \$46939 NWELL PWELL BULK MUX2_X1
X$109106 \$46116 \$46090 \$46161 \$46822 NWELL PWELL BULK MUX2_X1
X$109109 \$48295 \$46090 \$47602 \$47671 NWELL PWELL BULK MUX2_X1
X$109112 \$46515 \$46090 \$46206 \$46219 NWELL PWELL BULK MUX2_X1
X$109115 \$71152 \$46090 \$72135 \$72131 NWELL PWELL BULK MUX2_X1
X$109117 \$69658 \$46090 \$69285 \$68665 NWELL PWELL BULK MUX2_X1
X$109120 \$55542 \$46090 \$57366 \$57826 NWELL PWELL BULK MUX2_X1
X$109122 \$62696 \$46090 \$62692 \$62701 NWELL PWELL BULK MUX2_X1
X$109124 \$49529 \$49528 \$49530 \$46090 NWELL PWELL BULK NAND3_X4
X$109126 \$50913 \$46090 \$51955 \$51650 NWELL PWELL BULK MUX2_X1
X$109129 \$58940 \$46090 \$60204 \$60509 NWELL PWELL BULK MUX2_X1
X$109131 \$63992 \$46090 \$65085 \$65225 NWELL PWELL BULK MUX2_X1
X$109134 \$48437 \$46090 \$47582 \$48077 NWELL PWELL BULK MUX2_X1
X$109136 \$46851 \$46090 \$47080 \$47084 NWELL PWELL BULK MUX2_X1
X$109138 \$46777 \$46090 \$47228 \$47434 NWELL PWELL BULK MUX2_X1
X$109143 \$66047 \$46090 \$67159 \$67163 NWELL PWELL BULK MUX2_X1
X$109146 \$48283 \$46090 \$47930 \$48383 NWELL PWELL BULK MUX2_X1
X$109148 \$48333 \$46090 \$49958 \$49956 NWELL PWELL BULK MUX2_X1
X$109151 \$50923 \$46090 \$51104 \$51090 NWELL PWELL BULK MUX2_X1
X$109154 \$69665 \$46090 \$70293 \$69926 NWELL PWELL BULK MUX2_X1
X$109156 \$69690 \$46090 \$70155 \$70153 NWELL PWELL BULK MUX2_X1
X$109158 \$59507 \$46090 \$66030 \$66129 NWELL PWELL BULK MUX2_X1
X$109160 \$70502 \$46090 \$70504 \$70624 NWELL PWELL BULK MUX2_X1
X$109162 \$67664 \$46090 \$68541 \$68544 NWELL PWELL BULK MUX2_X1
X$109164 \$68922 \$46090 \$69356 \$69316 NWELL PWELL BULK MUX2_X1
X$109166 \$67954 \$46090 \$67696 \$67699 NWELL PWELL BULK MUX2_X1
X$109169 \$71920 \$46090 \$71678 \$71922 NWELL PWELL BULK MUX2_X1
X$109171 \$71918 \$46090 \$72101 \$72384 NWELL PWELL BULK MUX2_X1
X$109173 \$71721 \$46090 \$71545 \$72122 NWELL PWELL BULK MUX2_X1
X$109176 \$53790 \$46090 \$55238 \$55246 NWELL PWELL BULK MUX2_X1
X$109178 \$47905 \$46090 \$49171 \$49172 NWELL PWELL BULK MUX2_X1
X$109181 \$57414 \$46090 \$60907 \$60905 NWELL PWELL BULK MUX2_X1
X$109184 \$55590 \$46090 \$58960 \$59131 NWELL PWELL BULK MUX2_X1
X$109186 \$53895 \$46090 \$53771 \$54300 NWELL PWELL BULK MUX2_X1
X$109188 \$46095 \$46090 \$46258 \$46260 NWELL PWELL BULK MUX2_X1
X$109191 \$60054 \$46090 \$59601 \$59611 NWELL PWELL BULK MUX2_X1
X$109265 \$47243 \$46093 \$47372 \$46091 NWELL PWELL BULK MUX2_X1
X$109274 \$64509 \$46092 \$64815 \$58146 NWELL PWELL BULK MUX2_X1
X$109280 \$48100 \$46092 NWELL PWELL BULK BUF_X16
X$109283 \$67962 \$46092 \$67992 \$67193 NWELL PWELL BULK MUX2_X1
X$109286 \$49197 \$46092 \$49903 \$50230 NWELL PWELL BULK MUX2_X1
X$109289 \$67956 \$46092 \$68086 \$66816 NWELL PWELL BULK MUX2_X1
X$109291 \$67157 \$66780 \$46092 \$58552 NWELL PWELL BULK MUX2_X2
X$109293 \$50623 \$46092 \$50624 \$50936 NWELL PWELL BULK MUX2_X1
X$109295 \$68932 \$46092 \$69314 \$64808 NWELL PWELL BULK MUX2_X1
X$109297 \$69318 \$46092 \$69700 \$62908 NWELL PWELL BULK MUX2_X1
X$109301 \$50376 \$46092 \$49997 \$50221 NWELL PWELL BULK MUX2_X1
X$109304 \$58647 \$46092 \$58133 \$58134 NWELL PWELL BULK MUX2_X1
X$109307 \$47680 \$46092 \$47683 \$47932 NWELL PWELL BULK MUX2_X1
X$109309 \$48346 \$46092 \$48298 \$47603 NWELL PWELL BULK MUX2_X1
X$109311 \$48436 \$46092 \$48261 \$47584 NWELL PWELL BULK MUX2_X1
X$109313 \$46486 \$46092 \$47421 \$46350 NWELL PWELL BULK MUX2_X1
X$109316 \$55897 \$46092 \$55998 \$54582 NWELL PWELL BULK MUX2_X1
X$109318 \$54796 \$46092 \$54789 \$53787 NWELL PWELL BULK MUX2_X1
X$109320 \$60055 \$46092 \$59586 \$56425 NWELL PWELL BULK MUX2_X1
X$109364 \$46103 \$46093 \$46818 \$47683 NWELL PWELL BULK MUX2_X1
X$109367 \$46247 \$46093 \$46508 \$46244 NWELL PWELL BULK MUX2_X1
X$109370 \$47599 \$46093 \$46814 \$47680 NWELL PWELL BULK MUX2_X1
X$109372 \$46592 \$46093 \$46100 \$46239 NWELL PWELL BULK MUX2_X1
X$109375 \$46205 \$46093 \$46204 \$46108 NWELL PWELL BULK MUX2_X1
X$109377 \$48000 \$46093 \$47938 \$48346 NWELL PWELL BULK MUX2_X1
X$109380 \$46863 \$46093 \$46825 \$46854 NWELL PWELL BULK MUX2_X1
X$109383 \$54119 \$46093 \$54775 \$54789 NWELL PWELL BULK MUX2_X1
X$109385 \$60052 \$46093 \$60119 \$60055 NWELL PWELL BULK MUX2_X1
X$109388 \$47112 \$46093 \$46780 \$46482 NWELL PWELL BULK MUX2_X1
X$109390 \$64513 \$46093 \$64819 \$64509 NWELL PWELL BULK MUX2_X1
X$109392 \$48433 \$46093 \$47918 \$48436 NWELL PWELL BULK MUX2_X1
X$109394 \$47246 \$46093 \$46803 \$46804 NWELL PWELL BULK MUX2_X1
X$109397 \$46610 \$46093 \$46094 \$46608 NWELL PWELL BULK MUX2_X1
X$109404 \$69369 \$46093 \$69313 \$69314 NWELL PWELL BULK MUX2_X1
X$109407 \$68495 \$46093 \$68547 \$67962 NWELL PWELL BULK MUX2_X1
X$109410 \$69312 \$46093 \$69379 \$68932 NWELL PWELL BULK MUX2_X1
X$109413 \$68094 \$46093 \$68098 \$67956 NWELL PWELL BULK MUX2_X1
X$109416 \$48778 \$46093 \$48297 \$48298 NWELL PWELL BULK MUX2_X1
X$109418 \$68091 \$46093 \$68079 \$68086 NWELL PWELL BULK MUX2_X1
X$109421 \$50327 \$46093 \$49908 \$50623 NWELL PWELL BULK MUX2_X1
X$109424 \$50237 \$46093 \$50238 \$50624 NWELL PWELL BULK MUX2_X1
X$109427 \$48252 \$46093 NWELL PWELL BULK BUF_X32
X$109429 \$69315 \$46093 \$69355 \$69318 NWELL PWELL BULK MUX2_X1
X$109431 \$69338 \$46093 \$69343 \$69700 NWELL PWELL BULK MUX2_X1
X$109433 \$67996 \$46093 \$67969 \$67992 NWELL PWELL BULK MUX2_X1
X$109435 \$67165 \$46093 \$67101 \$67157 NWELL PWELL BULK MUX2_X1
X$109437 \$66395 \$46093 \$67124 \$66780 NWELL PWELL BULK MUX2_X1
X$109439 \$50614 \$46093 \$51115 \$50376 NWELL PWELL BULK MUX2_X1
X$109441 \$48659 \$46093 \$48994 \$48261 NWELL PWELL BULK MUX2_X1
X$109443 \$54235 \$46093 \$54118 \$54796 NWELL PWELL BULK MUX2_X1
X$109445 \$47422 \$46093 \$47754 \$47421 NWELL PWELL BULK MUX2_X1
X$109450 \$47253 \$46093 \$47254 \$46915 NWELL PWELL BULK MUX2_X1
X$109453 \$47353 \$46093 \$47596 \$46925 NWELL PWELL BULK MUX2_X1
X$109455 \$48866 \$46093 \$48860 \$49197 NWELL PWELL BULK MUX2_X1
X$109457 \$50373 \$46093 \$50618 \$49997 NWELL PWELL BULK MUX2_X1
X$109459 \$49995 \$46093 \$49552 \$49903 NWELL PWELL BULK MUX2_X1
X$109462 \$46883 \$46093 \$46557 \$46519 NWELL PWELL BULK MUX2_X1
X$109465 \$46551 \$46093 \$46876 \$46550 NWELL PWELL BULK MUX2_X1
X$109468 \$46789 \$46093 \$47006 \$46996 NWELL PWELL BULK MUX2_X1
X$109470 \$46791 \$46093 \$46792 \$46982 NWELL PWELL BULK MUX2_X1
X$109473 \$56422 \$46093 \$56868 \$55998 NWELL PWELL BULK MUX2_X1
X$109475 \$56878 \$46093 \$56733 \$55897 NWELL PWELL BULK MUX2_X1
X$109477 \$64791 \$46093 \$64444 \$64815 NWELL PWELL BULK MUX2_X1
X$109480 \$60056 \$46093 \$59498 \$59586 NWELL PWELL BULK MUX2_X1
X$109532 \$46095 \$46524 \$46946 \$46951 NWELL PWELL BULK MUX2_X1
X$109534 M0_AXI_WDATA[22] \$46095 NWELL PWELL BULK BUF_X1
X$109539 \$46095 \$46512 \$46801 \$47362 NWELL PWELL BULK MUX2_X1
X$109545 M0_AXI_WDATA[29] \$46097 NWELL PWELL BULK BUF_X1
X$109548 \$46097 \$46524 \$46916 \$46511 NWELL PWELL BULK MUX2_X1
X$109552 \$46097 \$46512 \$46929 \$46932 NWELL PWELL BULK MUX2_X1
X$109571 \$46115 \$46114 \$46556 NWELL PWELL BULK NOR2_X2
X$109578 \$46116 \$46524 \$46526 \$46538 NWELL PWELL BULK MUX2_X1
X$109580 M0_AXI_WDATA[10] \$46116 NWELL PWELL BULK BUF_X1
X$109583 \$46116 \$46512 \$46156 \$46523 NWELL PWELL BULK MUX2_X1
X$109620 \$46863 \$46156 \$46523 \$46882 NWELL PWELL BULK DFF_X1
X$109629 \$46876 \$46161 \$46822 \$46882 NWELL PWELL BULK DFF_X1
X$109773 M0_AXI_AWLEN[5] \$46304 NWELL PWELL BULK CLKBUF_X2
X$109877 \$46466 \$46764 \$46467 \$46395 NWELL PWELL BULK OAI21_X1
X$109919 \$46418 \$51031 NWELL PWELL BULK INV_X1
X$109978 \$55661 \$55033 \$50040 \$46447 NWELL PWELL BULK MUX2_X2
X$110019 \$46763 \$46466 NWELL PWELL BULK INV_X1
X$110021 \$46764 \$46468 \$46466 \$46467 NWELL PWELL BULK NAND3_X1
X$110028 \$46764 \$46468 \$49046 \$48630 NWELL PWELL BULK NAND3_X1
X$110031 \$46764 \$46468 \$49029 \$48625 NWELL PWELL BULK NAND3_X1
X$110033 \$48509 \$48136 \$46468 NWELL PWELL BULK AND2_X1
X$110035 \$46764 \$46468 \$47828 \$47495 NWELL PWELL BULK NAND3_X1
X$110039 \$46468 \$46765 NWELL PWELL BULK INV_X1
X$110041 \$46764 \$46468 \$47821 \$47564 NWELL PWELL BULK NAND3_X1
X$110051 \$46469 \$47490 \$47139 NWELL PWELL BULK XOR2_X1
X$110064 \$46475 \$46479 NWELL PWELL BULK INV_X1
X$110077 \$46481 \$49529 \$51986 NWELL PWELL BULK NAND2_X1
X$110079 \$46481 \$50894 \$50892 NWELL PWELL BULK NAND2_X1
X$110081 \$46481 \$50896 \$51472 NWELL PWELL BULK NAND2_X1
X$110083 \$46481 \$49530 NWELL PWELL BULK INV_X4
X$110085 \$48645 \$49529 \$46481 \$49873 NWELL PWELL BULK NOR3_X4
X$110088 \$46481 \$49529 \$49528 \$46512 NWELL PWELL BULK OR3_X4
X$110090 \$46481 \$48645 \$50584 NWELL PWELL BULK NAND2_X1
X$110092 \$46481 \$49871 \$49869 NWELL PWELL BULK NAND2_X1
X$110125 \$46494 \$47054 \$47048 NWELL PWELL BULK NOR2_X4
X$110139 \$47249 \$46512 \$47706 \$47709 NWELL PWELL BULK MUX2_X1
X$110142 \$71336 \$46512 \$73156 \$73231 NWELL PWELL BULK MUX2_X1
X$110145 \$69665 \$46512 \$70268 \$70275 NWELL PWELL BULK MUX2_X1
X$110147 \$59507 \$46512 \$67062 \$67061 NWELL PWELL BULK MUX2_X1
X$110151 \$53790 \$46512 \$54229 \$54231 NWELL PWELL BULK MUX2_X1
X$110154 \$62696 \$46512 \$63471 \$64196 NWELL PWELL BULK MUX2_X1
X$110156 \$50913 \$46512 \$51241 \$51249 NWELL PWELL BULK MUX2_X1
X$110158 \$63992 \$46512 \$65209 \$65211 NWELL PWELL BULK MUX2_X1
X$110166 \$69949 \$46512 \$69368 \$69374 NWELL PWELL BULK MUX2_X1
X$110168 \$50923 \$46512 \$49999 \$50371 NWELL PWELL BULK MUX2_X1
X$110171 \$48333 \$46512 \$49205 \$49271 NWELL PWELL BULK MUX2_X1
X$110173 \$67664 \$46512 \$67997 \$68002 NWELL PWELL BULK MUX2_X1
X$110175 \$55590 \$46512 \$58238 \$58648 NWELL PWELL BULK MUX2_X1
X$110177 \$57414 \$46512 \$59202 \$59204 NWELL PWELL BULK MUX2_X1
X$110180 \$53895 \$46512 \$54891 \$54898 NWELL PWELL BULK MUX2_X1
X$110182 \$48437 \$46512 \$49327 \$49331 NWELL PWELL BULK MUX2_X1
X$110184 \$68922 \$46512 \$68914 \$69346 NWELL PWELL BULK MUX2_X1
X$110186 \$66047 \$46512 \$66053 \$66410 NWELL PWELL BULK MUX2_X1
X$110188 \$67954 \$46512 \$68568 \$68093 NWELL PWELL BULK MUX2_X1
X$110191 \$71918 \$46512 \$73158 \$73229 NWELL PWELL BULK MUX2_X1
X$110193 \$71920 \$46512 \$73754 \$73159 NWELL PWELL BULK MUX2_X1
X$110195 \$69690 \$46512 \$71292 \$71296 NWELL PWELL BULK MUX2_X1
X$110198 \$70502 \$46512 \$70852 \$71325 NWELL PWELL BULK MUX2_X1
X$110201 \$71721 \$46512 \$72310 \$72309 NWELL PWELL BULK MUX2_X1
X$110204 \$46851 \$46512 \$47763 \$47429 NWELL PWELL BULK MUX2_X1
X$110206 \$47905 \$46512 \$47907 \$47908 NWELL PWELL BULK MUX2_X1
X$110210 \$48283 \$46512 \$49994 \$49635 NWELL PWELL BULK MUX2_X1
X$110213 \$46515 \$46512 \$46566 \$46567 NWELL PWELL BULK MUX2_X1
X$110216 \$48295 \$46512 \$48781 \$48784 NWELL PWELL BULK MUX2_X1
X$110218 \$46777 \$46512 \$47112 \$46659 NWELL PWELL BULK MUX2_X1
X$110220 \$69658 \$46512 \$70334 \$69737 NWELL PWELL BULK MUX2_X1
X$110224 \$58940 \$46512 \$59789 \$59800 NWELL PWELL BULK MUX2_X1
X$110226 \$55542 \$46512 \$55614 \$56001 NWELL PWELL BULK MUX2_X1
X$110228 \$71152 \$46512 \$72128 \$72399 NWELL PWELL BULK MUX2_X1
X$110285 \$60054 \$46512 \$60111 \$60472 NWELL PWELL BULK MUX2_X1
X$110313 \$46515 \$46524 \$47318 \$47261 NWELL PWELL BULK MUX2_X1
X$110316 M0_AXI_WDATA[3] \$46515 NWELL PWELL BULK BUF_X1
X$110326 \$46551 \$46522 \$46553 \$46882 NWELL PWELL BULK DFF_X1
X$110330 \$47249 \$46524 \$47256 \$47346 NWELL PWELL BULK MUX2_X1
X$110334 \$70502 \$46524 \$70939 \$70622 NWELL PWELL BULK MUX2_X1
X$110336 \$69665 \$46524 \$70644 \$70652 NWELL PWELL BULK MUX2_X1
X$110343 \$49529 \$48645 \$49530 \$46524 NWELL PWELL BULK NAND3_X4
X$110346 \$58940 \$46524 \$59215 \$59223 NWELL PWELL BULK MUX2_X1
X$110349 \$60054 \$46524 \$60471 \$60810 NWELL PWELL BULK MUX2_X1
X$110352 \$47905 \$46524 \$48256 \$49072 NWELL PWELL BULK MUX2_X1
X$110355 \$46777 \$46524 \$46780 \$47098 NWELL PWELL BULK MUX2_X1
X$110358 \$48295 \$46524 \$48766 \$48764 NWELL PWELL BULK MUX2_X1
X$110361 \$69949 \$46524 \$69952 \$70075 NWELL PWELL BULK MUX2_X1
X$110363 \$66047 \$46524 \$67107 \$67106 NWELL PWELL BULK MUX2_X1
X$110365 \$55590 \$46524 \$59487 \$59654 NWELL PWELL BULK MUX2_X1
X$110368 \$50923 \$46524 \$51083 \$50616 NWELL PWELL BULK MUX2_X1
X$110371 \$59507 \$46524 \$67434 \$67436 NWELL PWELL BULK MUX2_X1
X$110373 \$68922 \$46524 \$69688 \$69707 NWELL PWELL BULK MUX2_X1
X$110376 \$67664 \$46524 \$67970 \$67979 NWELL PWELL BULK MUX2_X1
X$110378 \$67954 \$46524 \$67658 \$68058 NWELL PWELL BULK MUX2_X1
X$110381 \$69690 \$46524 \$71286 \$71289 NWELL PWELL BULK MUX2_X1
X$110383 \$71920 \$46524 \$73752 \$73160 NWELL PWELL BULK MUX2_X1
X$110386 \$71721 \$46524 \$73774 \$73152 NWELL PWELL BULK MUX2_X1
X$110389 \$71336 \$46524 \$72873 \$72871 NWELL PWELL BULK MUX2_X1
X$110391 \$71918 \$46524 \$72857 \$72651 NWELL PWELL BULK MUX2_X1
X$110394 \$48437 \$46524 \$49002 \$49006 NWELL PWELL BULK MUX2_X1
X$110396 \$46851 \$46524 \$47235 \$47419 NWELL PWELL BULK MUX2_X1
X$110398 \$57414 \$46524 \$59761 \$60035 NWELL PWELL BULK MUX2_X1
X$110401 \$62696 \$46524 \$63969 \$64593 NWELL PWELL BULK MUX2_X1
X$110405 \$53895 \$46524 \$55110 \$55652 NWELL PWELL BULK MUX2_X1
X$110409 \$48283 \$46524 \$49198 \$49290 NWELL PWELL BULK MUX2_X1
X$110414 \$48333 \$46524 \$50625 \$51003 NWELL PWELL BULK MUX2_X1
X$110417 \$50913 \$46524 \$51238 \$51464 NWELL PWELL BULK MUX2_X1
X$110420 \$69658 \$46524 \$70664 \$70496 NWELL PWELL BULK MUX2_X1
X$110423 \$55542 \$46524 \$55611 \$55898 NWELL PWELL BULK MUX2_X1
X$110425 \$71152 \$46524 \$70846 \$71361 NWELL PWELL BULK MUX2_X1
X$110427 \$53790 \$46524 \$54769 \$54774 NWELL PWELL BULK MUX2_X1
X$110429 \$63992 \$46524 \$64067 \$64065 NWELL PWELL BULK MUX2_X1
X$110498 M0_AXI_WLAST \$46777 NWELL PWELL BULK CLKBUF_X2
X$110503 \$47281 S0_AXI_WDATA[21] NWELL PWELL BULK BUF_X1
X$110526 \$70521 \$46556 \$76343 \$76368 NWELL PWELL BULK OAI21_X1
X$110529 \$46556 \$70514 \$76305 \$76004 NWELL PWELL BULK OAI21_X1
X$110532 \$46556 \$71173 \$76971 \$77291 NWELL PWELL BULK OAI21_X1
X$110534 \$46556 \$71156 \$77242 \$77574 NWELL PWELL BULK OAI21_X1
X$110542 \$46557 \$47318 \$47261 \$46882 NWELL PWELL BULK DFF_X1
X$110579 \$70025 \$61075 \$46572 \$70026 NWELL PWELL BULK MUX2_X1
X$110581 \$72720 \$62181 \$46572 \$72724 NWELL PWELL BULK MUX2_X1
X$110583 \$71074 \$63057 \$46572 \$71614 NWELL PWELL BULK MUX2_X1
X$110585 \$71985 \$63530 \$46572 \$72366 NWELL PWELL BULK MUX2_X1
X$110603 \$53996 \$53989 \$46590 \$54665 NWELL PWELL BULK MUX2_X1
X$110607 \$55770 \$47751 \$46590 \$55982 NWELL PWELL BULK MUX2_X1
X$110620 \$46600 S0_AXI_AWADDR[18] NWELL PWELL BULK BUF_X1
X$110660 \$46635 \$47002 \$47022 NWELL PWELL BULK NOR2_X4
X$110689 \$62258 \$46658 \$60925 \$62752 NWELL PWELL BULK MUX2_X1
X$110692 \$66355 \$46658 \$57423 \$66577 NWELL PWELL BULK MUX2_X1
X$110695 \$66365 \$46658 \$60793 \$66525 NWELL PWELL BULK MUX2_X1
X$110698 \$66644 \$46658 \$66021 \$66161 NWELL PWELL BULK MUX2_X1
X$110700 \$63467 \$46658 \$64042 \$63761 NWELL PWELL BULK MUX2_X1
X$110702 \$54095 \$46658 \$54097 \$54310 NWELL PWELL BULK MUX2_X1
X$110705 \$53285 \$46658 \$53284 \$52952 NWELL PWELL BULK MUX2_X1
X$110707 \$65656 \$46658 \$60806 \$65783 NWELL PWELL BULK MUX2_X1
X$110709 \$56722 \$46658 \$55163 \$56941 NWELL PWELL BULK MUX2_X1
X$110711 \$55866 \$46658 \$50226 \$56129 NWELL PWELL BULK MUX2_X1
X$110713 \$53598 \$46658 \$52936 \$53608 NWELL PWELL BULK MUX2_X1
X$110716 \$49193 \$46658 \$48331 \$49312 NWELL PWELL BULK MUX2_X1
X$110719 \$49177 \$46658 \$47914 \$49349 NWELL PWELL BULK MUX2_X1
X$110722 \$49532 \$46658 \$49877 \$49740 NWELL PWELL BULK MUX2_X1
X$110725 \$48662 \$46658 \$48663 \$48975 NWELL PWELL BULK MUX2_X1
X$110727 \$66534 \$46658 \$63170 \$66535 NWELL PWELL BULK MUX2_X1
X$110729 \$51872 \$46658 \$51362 \$51875 NWELL PWELL BULK MUX2_X1
X$110731 \$52404 \$46658 \$50969 \$52403 NWELL PWELL BULK MUX2_X1
X$110735 \$64220 \$46658 \$59004 \$64226 NWELL PWELL BULK MUX2_X1
X$110738 \$58119 \$46658 \$54566 \$58686 NWELL PWELL BULK MUX2_X1
X$110798 \$47107 \$46695 \$47198 \$47199 NWELL PWELL BULK HA_X1
X$110826 M0_AXI_AWLEN[6] \$46737 NWELL PWELL BULK BUF_X1
X$110844 \$60166 \$46734 \$60169 \$60170 NWELL PWELL BULK MUX2_X1
X$110846 \$49113 \$46734 \$48553 \$49293 NWELL PWELL BULK MUX2_X1
X$110849 \$56069 \$46734 \$54809 \$56065 NWELL PWELL BULK MUX2_X1
X$110852 \$57497 \$46734 \$57432 \$57688 NWELL PWELL BULK MUX2_X1
X$110855 \$59151 \$46734 \$57898 \$58853 NWELL PWELL BULK MUX2_X1
X$110857 \$50157 \$46734 \$49837 \$50156 NWELL PWELL BULK MUX2_X1
X$110859 \$57259 \$46734 \$56604 \$56918 NWELL PWELL BULK MUX2_X1
X$110861 \$51585 \$46734 \$51582 \$51583 NWELL PWELL BULK MUX2_X1
X$110863 \$52864 \$46734 \$53426 \$53421 NWELL PWELL BULK MUX2_X1
X$110865 \$53169 \$46734 \$53439 \$53443 NWELL PWELL BULK MUX2_X1
X$110869 \$48059 \$46734 \$48584 \$47865 NWELL PWELL BULK MUX2_X1
X$110871 \$47855 \$46734 \$47159 \$47667 NWELL PWELL BULK MUX2_X1
X$110873 \$60336 \$46734 \$59638 \$60649 NWELL PWELL BULK MUX2_X1
X$110875 \$59135 \$46734 \$59960 \$59650 NWELL PWELL BULK MUX2_X1
X$110877 \$55456 \$46734 \$53836 \$55454 NWELL PWELL BULK MUX2_X1
X$110879 \$54680 \$46734 NWELL PWELL BULK BUF_X8
X$110881 \$58039 \$46734 \$58845 \$58038 NWELL PWELL BULK MUX2_X1
X$110883 \$58675 \$46734 \$58397 \$57690 NWELL PWELL BULK MUX2_X1
X$110885 \$55446 \$46734 \$55582 \$55635 NWELL PWELL BULK MUX2_X1
X$110887 \$51580 \$46734 \$52512 \$52324 NWELL PWELL BULK MUX2_X1
X$110889 \$50148 \$46734 \$50544 \$50333 NWELL PWELL BULK MUX2_X1
X$110949 \$46763 \$47841 \$48527 \$47558 NWELL PWELL BULK HA_X1
X$110954 \$46763 \$47202 \$47828 \$47820 NWELL PWELL BULK HA_X1
X$110963 \$49419 \$46764 \$48630 \$49163 NWELL PWELL BULK OAI21_X1
X$110966 \$46764 \$48631 \$49165 \$48632 \$49166 NWELL PWELL BULK NAND4_X1
X$110970 \$46764 \$49057 \$49411 NWELL PWELL BULK NAND2_X1
X$110973 \$46764 \$49425 \$49426 NWELL PWELL BULK NAND2_X1
X$110976 \$49443 \$46764 \$48625 \$49026 NWELL PWELL BULK OAI21_X1
X$110978 \$47206 \$46764 \$47564 \$47204 NWELL PWELL BULK OAI21_X1
X$110985 \$46764 \$47894 \$48155 NWELL PWELL BULK NAND2_X1
X$110989 \$47491 \$46764 \$47495 \$47100 NWELL PWELL BULK OAI21_X1
X$111059 \$47946 S0_AXI_WSTRB[2] NWELL PWELL BULK BUF_X1
X$111064 M0_AXI_WDATA[9] \$46851 NWELL PWELL BULK CLKBUF_X2
X$111108 \$46857 S0_AXI_AWADDR[17] NWELL PWELL BULK BUF_X1
X$111140 \$48000 \$48003 \$48002 \$46882 NWELL PWELL BULK DFF_X1
X$111144 \$47938 \$47602 \$47671 \$46882 NWELL PWELL BULK DFF_X1
X$111146 \$48017 \$48012 \$47677 \$46882 NWELL PWELL BULK DFF_X1
X$111149 \$I178814 \$47608 \$47984 \$46882 NWELL PWELL BULK DFF_X1
X$111152 \$I175068 \$47606 \$47639 \$46882 NWELL PWELL BULK DFF_X1
X$111154 \$48292 \$48797 \$48798 \$46882 NWELL PWELL BULK DFF_X1
X$111156 \$48297 \$48766 \$48764 \$46882 NWELL PWELL BULK DFF_X1
X$111158 \$48778 \$48781 \$48784 \$46882 NWELL PWELL BULK DFF_X1
X$111160 \$I178715 \$49238 \$49938 \$46882 NWELL PWELL BULK DFF_X1
X$111164 \$I175427 \$49573 \$50262 \$46882 NWELL PWELL BULK DFF_X1
X$111167 \$50238 \$50625 \$51003 \$46882 NWELL PWELL BULK DFF_X1
X$111170 \$50237 \$49205 \$49271 \$46882 NWELL PWELL BULK DFF_X1
X$111172 \$I175882 \$49207 \$49910 \$46882 NWELL PWELL BULK DFF_X1
X$111175 \$48291 \$48810 \$48361 \$46882 NWELL PWELL BULK DFF_X1
X$111178 \$I178688 \$48319 \$48304 \$46882 NWELL PWELL BULK DFF_X1
X$111180 \$I178745 \$49558 \$49913 \$46882 NWELL PWELL BULK DFF_X1
X$111182 \$I178756 \$50627 \$50989 \$46882 NWELL PWELL BULK DFF_X1
X$111185 \$I175407 \$48303 \$48760 \$46882 NWELL PWELL BULK DFF_X1
X$111188 \$I178742 \$52968 \$53339 \$46882 NWELL PWELL BULK DFF_X1
X$111190 \$I175778 \$52185 \$52984 \$46882 NWELL PWELL BULK DFF_X1
X$111192 \$I176758 \$52179 \$52996 \$46882 NWELL PWELL BULK DFF_X1
X$111194 \$I175808 \$52605 \$52962 \$46882 NWELL PWELL BULK DFF_X1
X$111197 \$52178 \$53371 \$52998 \$46882 NWELL PWELL BULK DFF_X1
X$111200 \$I175732 \$50644 \$50972 \$46882 NWELL PWELL BULK DFF_X1
X$111202 \$I175721 \$52204 \$51688 \$46882 NWELL PWELL BULK DFF_X1
X$111204 \$I178748 \$51687 \$51740 \$46882 NWELL PWELL BULK DFF_X1
X$111314 \$47416 \$46988 \$46997 \$47530 NWELL PWELL BULK DFF_X1
X$111361 \$70521 \$47022 \$81540 \$81264 NWELL PWELL BULK OAI21_X1
X$111363 \$47022 \$71173 \$80924 \$80583 NWELL PWELL BULK OAI21_X1
X$111366 \$47022 \$70514 \$81221 \$81598 NWELL PWELL BULK OAI21_X1
X$111368 \$47022 \$71156 \$81265 \$80945 NWELL PWELL BULK OAI21_X1
X$111399 \$47048 \$71173 \$79144 \$79447 NWELL PWELL BULK OAI21_X1
X$111402 \$70521 \$47048 \$80233 \$80532 NWELL PWELL BULK OAI21_X1
X$111404 \$47048 \$70514 \$80239 \$80236 NWELL PWELL BULK OAI21_X1
X$111406 \$47048 \$71156 \$78804 \$78808 NWELL PWELL BULK OAI21_X1
X$111441 \$47073 S0_AXI_AWID[4] NWELL PWELL BULK BUF_X1
X$111511 M0_AXI_AWLEN[0] \$47187 NWELL PWELL BULK CLKBUF_X2
X$111526 M2_AXI_AWADDR[0] \$47159 NWELL PWELL BULK BUF_X1
X$111574 \$47182 \$47753 \$47181 \$47530 NWELL PWELL BULK DFF_X1
X$111596 \$47198 \$48154 NWELL PWELL BULK INV_X1
X$111598 \$47198 \$47884 \$48527 \$48516 \$47886 NWELL PWELL BULK NAND4_X1
X$111601 \$47199 \$47562 NWELL PWELL BULK INV_X1
X$111609 \$47202 \$47491 NWELL PWELL BULK INV_X1
X$111616 \$47499 \$47206 NWELL PWELL BULK INV_X1
X$111618 \$49434 \$47209 \$49441 NWELL PWELL BULK NOR2_X1
X$111620 \$49056 \$47209 \$49040 NWELL PWELL BULK NOR2_X1
X$111622 \$48506 \$47209 \$48508 NWELL PWELL BULK NOR2_X1
X$111624 \$47815 \$47209 \$48148 NWELL PWELL BULK NOR2_X1
X$111631 \$I178047 \$47213 \$47211 \$47212 NWELL PWELL BULK DFF_X1
X$111633 \$47887 \$47212 NWELL PWELL BULK BUF_X4
X$111636 \$I178741 \$56378 \$56532 \$47212 NWELL PWELL BULK DFF_X1
X$111638 \$58757 \$47212 \$54511 \$I240848 NWELL PWELL BULK DFF_X2
X$111640 \$54057 \$47212 \$53222 \$52845 NWELL PWELL BULK DFF_X2
X$111643 \$I178744 \$59447 \$59887 \$47212 NWELL PWELL BULK DFF_X1
X$111646 \$I175743 \$56675 \$57178 \$47212 NWELL PWELL BULK DFF_X1
X$111649 \$61045 \$47212 \$58458 \$60679 NWELL PWELL BULK DFF_X2
X$111651 \$53687 \$47212 \$I245700 \$54082 NWELL PWELL BULK DFF_X2
X$111653 \$I176803 \$54542 \$54541 \$47212 NWELL PWELL BULK DFF_X1
X$111655 \$54541 \$47212 \$I245649 \$55496 NWELL PWELL BULK DFF_X2
X$111657 \$53248 \$53247 \$53917 \$47212 NWELL PWELL BULK DFF_X1
X$111659 \$I176678 \$52546 \$52549 \$47212 NWELL PWELL BULK DFF_X1
X$111661 \$53594 \$47212 \$52904 \$52558 NWELL PWELL BULK DFF_X2
X$111663 \$52037 \$47212 \$I245613 \$52553 NWELL PWELL BULK DFF_X2
X$111666 \$I177012 \$51638 \$52046 \$47212 NWELL PWELL BULK DFF_X1
X$111668 \$I176228 \$52053 \$52052 \$47212 NWELL PWELL BULK DFF_X1
X$111672 \$51338 \$47212 \$I245657 \$52479 NWELL PWELL BULK DFF_X2
X$111674 \$I177030 \$52043 \$52449 \$47212 NWELL PWELL BULK DFF_X1
X$111677 \$I177031 \$52563 \$53670 \$47212 NWELL PWELL BULK DFF_X1
X$111680 \$53666 \$47212 \$53747 \$52912 NWELL PWELL BULK DFF_X2
X$111682 \$53243 \$53242 \$53239 \$47212 NWELL PWELL BULK DFF_X1
X$111684 \$I176248 \$52565 \$52135 \$47212 NWELL PWELL BULK DFF_X1
X$111687 \$50575 \$50576 \$50193 \$47212 NWELL PWELL BULK DFF_X1
X$111689 \$52125 \$47212 \$52557 \$52126 NWELL PWELL BULK DFF_X2
X$111692 \$I176243 \$52132 \$52131 \$47212 NWELL PWELL BULK DFF_X1
X$111694 \$52133 \$52817 \$52820 \$47212 NWELL PWELL BULK DFF_X1
X$111697 \$53082 \$47212 \$52467 \$52821 NWELL PWELL BULK DFF_X2
X$111700 \$I179175 \$52568 \$51642 \$47212 NWELL PWELL BULK DFF_X1
X$111703 \$53667 \$52922 \$53679 \$47212 NWELL PWELL BULK DFF_X1
X$111706 \$I174808 \$50578 \$50767 \$47212 NWELL PWELL BULK DFF_X1
X$111735 \$47213 \$47897 \$47811 NWELL PWELL BULK XNOR2_X1
X$111746 \$47218 \$47220 \$47484 \$47477 NWELL PWELL BULK HA_X1
X$111794 M0_AXI_WDATA[13] \$47249 NWELL PWELL BULK BUF_X1
X$111831 M0_AXI_WDATA[30] \$48295 NWELL PWELL BULK BUF_X1
X$111908 \$47368 \$47887 NWELL PWELL BULK BUF_X4
X$111914 \$47368 \$62164 NWELL PWELL BULK BUF_X4
X$111916 \$47368 \$68754 NWELL PWELL BULK BUF_X4
X$111945 \$47392 S0_AXI_AWADDR[12] NWELL PWELL BULK BUF_X1
X$112007 \$65572 \$61102 \$47441 \$65787 NWELL PWELL BULK MUX2_X1
X$112009 \$64976 \$62451 \$47441 \$64977 NWELL PWELL BULK MUX2_X1
X$112012 \$64973 \$61799 \$47441 \$64971 NWELL PWELL BULK MUX2_X1
X$112014 \$64906 \$62181 \$47441 \$65265 NWELL PWELL BULK MUX2_X1
X$112048 \$47478 S0_AXI_AWID[3] NWELL PWELL BULK BUF_X1
X$112051 \$47480 \$47553 \$47483 \$47478 NWELL PWELL BULK MUX2_X2
X$112062 \$55444 \$47483 \$55630 \$55435 NWELL PWELL BULK MUX2_X1
X$112065 \$56876 \$47483 \$56884 \$56783 NWELL PWELL BULK MUX2_X1
X$112067 \$62440 \$60648 \$47483 \$62445 NWELL PWELL BULK MUX2_X2
X$112069 \$60507 \$47483 \$59953 \$59941 NWELL PWELL BULK MUX2_X1
X$112071 \$61098 \$47483 \$60646 \$60876 NWELL PWELL BULK MUX2_X1
X$112073 \$59362 \$47483 \$58834 \$59528 NWELL PWELL BULK MUX2_X1
X$112076 \$57230 \$47483 \$57416 \$57386 NWELL PWELL BULK MUX2_X1
X$112079 \$56312 \$47483 \$56313 \$55920 NWELL PWELL BULK MUX2_X1
X$112083 \$53153 \$47483 \$53154 \$53146 NWELL PWELL BULK MUX2_X1
X$112085 \$59046 \$47483 \$58393 \$58384 NWELL PWELL BULK MUX2_X1
X$112088 \$59371 \$47483 \$58841 \$59360 NWELL PWELL BULK MUX2_X1
X$112090 \$57829 \$47483 \$58621 \$57670 NWELL PWELL BULK MUX2_X1
X$112095 \$63317 \$47483 \$63691 \$63695 NWELL PWELL BULK MUX2_X1
X$112098 \$55328 \$55044 \$47483 \$55332 NWELL PWELL BULK MUX2_X2
X$112100 \$52816 \$52120 \$47483 \$52818 NWELL PWELL BULK MUX2_X2
X$112104 \$56946 \$56614 \$47483 \$56952 NWELL PWELL BULK MUX2_X2
X$112106 \$56617 \$57532 \$47483 \$57926 NWELL PWELL BULK MUX2_X2
X$112108 \$54015 \$47483 \$53460 \$53462 NWELL PWELL BULK MUX2_X1
X$112110 \$55034 \$47483 \$55286 \$55279 NWELL PWELL BULK MUX2_X1
X$112113 \$57681 \$47483 \$57850 \$57666 NWELL PWELL BULK MUX2_X1
X$112116 \$54447 \$47483 \$54449 \$54601 NWELL PWELL BULK MUX2_X1
X$112119 \$61088 \$47483 \$60825 \$61299 NWELL PWELL BULK MUX2_X1
X$112121 \$61789 \$47483 \$61341 \$60836 NWELL PWELL BULK MUX2_X1
X$112123 \$53987 \$47483 \$53988 \$54196 NWELL PWELL BULK MUX2_X1
X$112125 \$61956 \$47483 \$61316 \$61294 NWELL PWELL BULK MUX2_X1
X$112127 \$57438 \$47483 \$56311 \$56779 NWELL PWELL BULK MUX2_X1
X$112129 \$54357 \$47483 \$53716 \$53707 NWELL PWELL BULK MUX2_X1
X$112131 \$63917 \$47483 \$63086 \$63673 NWELL PWELL BULK MUX2_X1
X$112134 \$63377 \$47483 \$63085 \$63666 NWELL PWELL BULK MUX2_X1
X$112137 \$60660 \$47483 \$61474 \$62043 NWELL PWELL BULK MUX2_X1
X$112202 \$47890 \$47499 \$47820 \$48628 NWELL PWELL BULK AND3_X1
X$112205 \$47499 \$47820 \$47821 \$47894 NWELL PWELL BULK HA_X1
X$112212 M0_AXI_AWLEN[4] \$48427 NWELL PWELL BULK BUF_X1
X$112227 M0_AXI_AWSIZE[0] \$47508 NWELL PWELL BULK BUF_X1
X$112261 \$50161 \$50160 \$50400 \$47530 NWELL PWELL BULK DFF_X1
X$112263 \$50560 \$51094 \$50846 \$47530 NWELL PWELL BULK DFF_X1
X$112266 \$48879 \$48877 \$49344 \$47530 NWELL PWELL BULK DFF_X1
X$112268 \$I174955 \$49123 \$49704 \$47530 NWELL PWELL BULK DFF_X1
X$112270 \$50797 \$50794 \$50790 \$47530 NWELL PWELL BULK DFF_X1
X$112273 \$48591 \$48204 \$48901 \$47530 NWELL PWELL BULK DFF_X1
X$112276 \$48593 \$48592 \$49364 \$47530 NWELL PWELL BULK DFF_X1
X$112279 \$49128 \$49715 \$49126 \$47530 NWELL PWELL BULK DFF_X1
X$112282 \$48890 \$48462 \$48882 \$47530 NWELL PWELL BULK DFF_X1
X$112285 \$51593 \$52365 \$51591 \$47530 NWELL PWELL BULK DFF_X1
X$112287 \$I174930 \$51589 \$51590 \$47530 NWELL PWELL BULK DFF_X1
X$112290 \$I178452 \$53171 \$53067 \$47530 NWELL PWELL BULK DFF_X1
X$112293 \$51885 \$51508 \$51511 \$47530 NWELL PWELL BULK DFF_X1
X$112296 \$48922 \$48919 \$48595 \$47530 NWELL PWELL BULK DFF_X1
X$112299 \$48917 \$48913 \$48205 \$47530 NWELL PWELL BULK DFF_X1
X$112302 \$I174921 \$52342 \$52518 \$47530 NWELL PWELL BULK DFF_X1
X$112304 \$48202 \$48473 \$48471 \$47530 NWELL PWELL BULK DFF_X1
X$112308 \$51160 \$51161 \$50869 \$47530 NWELL PWELL BULK DFF_X1
X$112310 \$49491 \$49730 \$49129 \$47530 NWELL PWELL BULK DFF_X1
X$112313 \$50859 \$51527 \$51309 \$47530 NWELL PWELL BULK DFF_X1
X$112317 \$50777 \$50168 \$50169 \$47530 NWELL PWELL BULK DFF_X1
X$112319 \$51133 \$51112 \$50768 \$47530 NWELL PWELL BULK DFF_X1
X$112322 \$49357 \$49352 \$49717 \$47530 NWELL PWELL BULK DFF_X1
X$112325 \$I178624 \$52522 \$52868 \$47530 NWELL PWELL BULK DFF_X1
X$112328 \$53473 \$53083 \$52871 \$47530 NWELL PWELL BULK DFF_X1
X$112331 \$52378 \$51901 \$51598 \$47530 NWELL PWELL BULK DFF_X1
X$112333 \$52370 \$51596 \$51897 \$47530 NWELL PWELL BULK DFF_X1
X$112335 \$51124 \$51119 \$50770 \$47530 NWELL PWELL BULK DFF_X1
X$112416 \$47558 \$47559 NWELL PWELL BULK INV_X1
X$112419 \$47560 \$47884 \$47559 \$47561 NWELL PWELL BULK AOI21_X1
X$112421 \$48153 \$47885 \$47884 \$47560 NWELL PWELL BULK HA_X1
X$112426 \$48154 \$47561 \$47562 \$48230 NWELL PWELL BULK OAI21_X1
X$112441 \$47575 \$47574 \$47790 \$47782 NWELL PWELL BULK HA_X1
X$112443 \$47901 \$47574 \$47793 NWELL PWELL BULK NAND2_X1
X$112454 \$47901 \$47575 \$47779 NWELL PWELL BULK NAND2_X1
X$112465 \$I177387 \$47580 \$47747 \$48250 NWELL PWELL BULK DFF_X1
X$112501 \$48340 \$47605 \$48339 NWELL PWELL BULK NOR2_X2
X$112519 M0_AXI_WDATA[4] \$48333 NWELL PWELL BULK BUF_X1
X$112524 \$48305 S0_AXI_WDATA[5] NWELL PWELL BULK BUF_X1
X$112640 \$47743 S1_AXI_WDATA[6] NWELL PWELL BULK BUF_X1
X$112665 \$57236 \$47751 \$50698 \$57444 NWELL PWELL BULK MUX2_X1
X$112667 \$55765 \$47751 \$56304 \$56454 NWELL PWELL BULK MUX2_X1
X$112672 \$53173 \$47751 \$52520 \$53455 NWELL PWELL BULK MUX2_X1
X$112675 \$60323 \$47751 \$53704 \$60324 NWELL PWELL BULK MUX2_X1
X$112686 \$54443 \$47751 \$50692 \$54653 NWELL PWELL BULK MUX2_X1
X$112688 \$59560 \$47751 \$53021 \$59365 NWELL PWELL BULK MUX2_X1
X$112690 \$60101 \$47751 \$52496 \$59942 NWELL PWELL BULK MUX2_X1
X$112693 \$59950 \$47751 \$52084 \$61359 NWELL PWELL BULK MUX2_X1
X$112697 \$54181 \$47751 \$50536 \$53984 NWELL PWELL BULK MUX2_X1
X$112699 \$58833 \$47751 \$50667 \$58831 NWELL PWELL BULK MUX2_X1
X$112701 \$60320 \$47751 \$52232 \$60811 NWELL PWELL BULK MUX2_X1
X$112798 \$57513 \$58272 \$50040 \$47807 NWELL PWELL BULK MUX2_X2
X$112806 \$47807 \$47876 NWELL PWELL BULK INV_X1
X$112822 \$48234 \$49166 \$47815 NWELL PWELL BULK XOR2_X1
X$112871 \$47955 S0_AXI_AWADDR[15] NWELL PWELL BULK BUF_X1
X$112918 \$47886 \$48158 \$48134 NWELL PWELL BULK NOR2_X1
X$112921 \$47887 \$59405 NWELL PWELL BULK BUF_X4
X$112923 \$47887 \$63375 NWELL PWELL BULK BUF_X4
X$112925 \$47887 \$48619 NWELL PWELL BULK BUF_X4
X$112931 \$47887 \$60579 NWELL PWELL BULK BUF_X4
X$112934 \$47887 \$55046 NWELL PWELL BULK BUF_X4
X$112936 \$47887 \$54343 NWELL PWELL BULK BUF_X4
X$112942 \$47887 \$65008 NWELL PWELL BULK BUF_X4
X$112945 \$47887 \$64993 NWELL PWELL BULK BUF_X4
X$112971 \$48158 \$47888 \$49160 \$48509 NWELL PWELL BULK OAI21_X1
X$112973 \$48512 \$48516 \$48230 \$47888 NWELL PWELL BULK AOI21_X1
X$112975 \$47890 \$48155 \$48506 NWELL PWELL BULK XOR2_X1
X$112983 \$50194 \$50195 \$47897 NWELL PWELL BULK NOR2_X1
X$112988 \$47900 \$48638 \$48497 NWELL PWELL BULK XNOR2_X1
X$112992 \$47901 \$49169 \$49394 NWELL PWELL BULK NAND2_X1
X$112994 \$47901 \$48243 \$48644 NWELL PWELL BULK NAND2_X1
X$112997 \$47901 \$48244 \$47903 NWELL PWELL BULK NAND2_X1
X$113000 \$49530 \$47901 \$I241051 \$49526 NWELL PWELL BULK HA_X1
X$113010 M0_AXI_WID[1] \$47905 NWELL PWELL BULK CLKBUF_X2
X$113029 \$47912 \$49891 \$49890 NWELL PWELL BULK NOR2_X1
X$113031 \$49890 \$50217 \$47912 \$49889 NWELL PWELL BULK AOI21_X1
X$113035 \$52697 \$51666 \$47912 \$53457 NWELL PWELL BULK AOI21_X1
X$113037 \$47912 \$54574 \$54255 NWELL PWELL BULK NOR2_X1
X$113040 \$54255 \$54254 \$47912 \$54259 NWELL PWELL BULK AOI21_X1
X$113042 \$47912 \$49886 \$49540 NWELL PWELL BULK NOR2_X1
X$113045 \$49540 \$49541 \$47912 \$49538 NWELL PWELL BULK AOI21_X1
X$113048 \$52729 \$51171 \$47912 \$52583 NWELL PWELL BULK AOI21_X1
X$113051 \$47912 \$52148 \$52729 NWELL PWELL BULK NOR2_X1
X$113054 \$60878 \$58952 \$47912 \$60500 NWELL PWELL BULK AOI21_X1
X$113056 \$61602 \$61227 \$47912 \$60737 NWELL PWELL BULK AOI21_X1
X$113059 \$47912 \$60430 \$60878 NWELL PWELL BULK NOR2_X1
X$113062 \$47912 \$61226 \$61602 NWELL PWELL BULK NOR2_X1
X$113064 \$47912 \$61460 \$61242 NWELL PWELL BULK NOR2_X1
X$113067 \$61242 \$62857 \$47912 \$61470 NWELL PWELL BULK AOI21_X1
X$113070 \$59679 \$58514 \$47912 \$59701 NWELL PWELL BULK AOI21_X1
X$113073 \$59669 \$59482 \$47912 \$60042 NWELL PWELL BULK AOI21_X1
X$113076 \$47912 \$60043 \$59669 NWELL PWELL BULK NOR2_X1
X$113079 \$54565 \$55297 \$47912 \$54563 NWELL PWELL BULK AOI21_X1
X$113082 \$47912 \$55320 \$54565 NWELL PWELL BULK NOR2_X1
X$113084 \$55860 \$56709 \$47912 \$55859 NWELL PWELL BULK AOI21_X1
X$113086 \$47912 \$56408 \$55860 NWELL PWELL BULK NOR2_X1
X$113088 \$47912 \$58957 \$59679 NWELL PWELL BULK NOR2_X1
X$113090 \$47912 \$52696 \$52697 NWELL PWELL BULK NOR2_X1
X$113092 \$56041 \$55885 \$47912 \$56046 NWELL PWELL BULK AOI21_X1
X$113095 \$47912 \$55893 \$56041 NWELL PWELL BULK NOR2_X1
X$113098 \$61491 \$61237 \$47912 \$62583 NWELL PWELL BULK AOI21_X1
X$113100 \$47912 \$61487 \$61491 NWELL PWELL BULK NOR2_X1
X$113102 \$61235 \$61891 \$47912 \$62001 NWELL PWELL BULK AOI21_X1
X$113105 \$47912 \$61892 \$61235 NWELL PWELL BULK NOR2_X1
X$113141 M2_AXI_WID[1] \$47914 NWELL PWELL BULK BUF_X1
X$113186 M2_AXI_WDATA[16] \$47934 NWELL PWELL BULK BUF_X1
X$113200 \$48366 \$48289 \$47942 NWELL PWELL BULK NOR2_X2
X$113207 \$48690 \$47942 \$48689 \$48304 NWELL PWELL BULK AOI21_X1
X$113353 \$71328 \$71160 \$48100 \$55531 NWELL PWELL BULK MUX2_X2
X$113355 \$69053 \$69735 \$48100 \$65631 NWELL PWELL BULK MUX2_X2
X$113357 \$71548 \$48100 \$72390 \$67054 NWELL PWELL BULK MUX2_X1
X$113359 \$71363 \$71355 \$48100 \$66612 NWELL PWELL BULK MUX2_X2
X$113361 \$71551 \$72648 \$48100 \$53777 NWELL PWELL BULK MUX2_X2
X$113364 \$70258 \$48100 \$70257 \$66751 NWELL PWELL BULK MUX2_X1
X$113367 \$65646 \$48100 \$65647 \$64138 NWELL PWELL BULK MUX2_X1
X$113369 \$60734 \$48100 \$60421 \$60735 NWELL PWELL BULK MUX2_X1
X$113371 \$69675 \$48100 \$70512 \$66825 NWELL PWELL BULK MUX2_X1
X$113374 \$58699 \$48100 \$58500 \$57740 NWELL PWELL BULK MUX2_X1
X$113376 \$54101 \$48100 \$54562 \$52145 NWELL PWELL BULK MUX2_X1
X$113379 \$49175 \$48100 \$48254 \$48258 NWELL PWELL BULK MUX2_X1
X$113383 \$70194 \$48100 \$70180 \$66760 NWELL PWELL BULK MUX2_X1
X$113387 \$52411 \$48100 \$50594 \$50737 NWELL PWELL BULK MUX2_X1
X$113389 \$63253 \$48100 \$63153 \$63155 NWELL PWELL BULK MUX2_X1
X$113461 \$49519 \$49520 \$50062 \$49446 \$48158 NWELL PWELL BULK NAND4_X1
X$113472 M0_AXI_AWLEN[3] \$48199 NWELL PWELL BULK BUF_X1
X$113477 M0_AXI_AWLEN[7] \$48582 NWELL PWELL BULK BUF_X1
X$113482 M1_AXI_AWLEN[7] \$48219 NWELL PWELL BULK CLKBUF_X2
X$113505 M0_AXI_AWADDR[4] \$48179 NWELL PWELL BULK BUF_X1
X$113585 \$48944 \$48213 NWELL PWELL BULK INV_X1
X$113616 \$48232 \$48997 \$49446 \$49445 NWELL PWELL BULK HA_X1
X$113629 \$48240 \$48489 \$48486 NWELL PWELL BULK XOR2_X1
X$113633 \$49529 \$48243 \$49386 NWELL PWELL BULK XNOR2_X2
X$113641 \$48645 \$48244 \$48646 NWELL PWELL BULK XNOR2_X2
X$113654 \$49076 \$49080 \$48248 \$48250 NWELL PWELL BULK DFF_X1
X$113658 \$I177492 \$49891 \$49889 \$48250 NWELL PWELL BULK DFF_X1
X$113660 \$I177549 \$49893 \$50915 \$48250 NWELL PWELL BULK DFF_X1
X$113662 \$48659 \$49327 \$49331 \$48250 NWELL PWELL BULK DFF_X1
X$113667 \$I177248 \$49885 \$50454 \$48250 NWELL PWELL BULK DFF_X1
X$113670 \$49045 \$49049 \$49047 \$48250 NWELL PWELL BULK DFF_X1
X$113672 \$48656 \$49027 \$49021 \$48250 NWELL PWELL BULK DFF_X1
X$113675 \$I177246 \$49184 \$49689 \$48250 NWELL PWELL BULK DFF_X1
X$113678 \$48253 \$48256 \$49072 \$48250 NWELL PWELL BULK DFF_X1
X$113681 \$48652 \$49177 \$49349 \$48250 NWELL PWELL BULK DFF_X1
X$113683 \$49881 \$50492 \$49879 \$48250 NWELL PWELL BULK DFF_X1
X$113686 \$48650 \$49171 \$49172 \$48250 NWELL PWELL BULK DFF_X1
X$113689 \$I177550 \$50213 \$49683 \$48250 NWELL PWELL BULK DFF_X1
X$113691 \$I177259 \$49886 \$49538 \$48250 NWELL PWELL BULK DFF_X1
X$113694 \$48433 \$48259 \$48441 \$48250 NWELL PWELL BULK DFF_X1
X$113698 \$I177289 \$52148 \$52583 \$48250 NWELL PWELL BULK DFF_X1
X$113700 \$I177284 \$51912 \$51916 \$48250 NWELL PWELL BULK DFF_X1
X$113703 \$50743 \$51238 \$51464 \$48250 NWELL PWELL BULK DFF_X1
X$113705 \$51926 \$51933 \$51352 \$48250 NWELL PWELL BULK DFF_X1
X$113708 \$I175294 \$50906 \$51211 \$48250 NWELL PWELL BULK DFF_X1
X$113710 \$50027 \$50024 \$50482 \$48250 NWELL PWELL BULK DFF_X1
X$113712 \$I175282 \$50208 \$50458 \$48250 NWELL PWELL BULK DFF_X1
X$113715 \$52387 \$52572 \$53061 \$48250 NWELL PWELL BULK DFF_X1
X$113718 \$I175328 \$52149 \$51904 \$48250 NWELL PWELL BULK DFF_X1
X$113721 \$52395 \$52404 \$52403 \$48250 NWELL PWELL BULK DFF_X1
X$113723 \$51651 \$51955 \$51650 \$48250 NWELL PWELL BULK DFF_X1
X$113726 \$53589 \$53598 \$53608 \$48250 NWELL PWELL BULK DFF_X1
X$113729 \$52143 \$52747 \$52141 \$48250 NWELL PWELL BULK DFF_X1
X$113733 \$49170 \$49532 \$49740 \$48250 NWELL PWELL BULK DFF_X1
X$113756 \$71333 \$48252 \$71681 \$71328 NWELL PWELL BULK MUX2_X1
X$113759 \$72653 \$48252 \$72856 \$71160 NWELL PWELL BULK MUX2_X1
X$113762 \$72655 \$48252 \$72845 \$71555 NWELL PWELL BULK MUX2_X1
X$113765 \$71159 \$48252 \$71708 \$71548 NWELL PWELL BULK MUX2_X1
X$113767 \$70207 \$48252 \$70505 \$70194 NWELL PWELL BULK MUX2_X1
X$113770 \$70507 \$48252 \$69937 \$70180 NWELL PWELL BULK MUX2_X1
X$113773 \$70850 \$48252 \$71693 \$71551 NWELL PWELL BULK MUX2_X1
X$113775 \$72645 \$48252 \$72646 \$72390 NWELL PWELL BULK MUX2_X1
X$113777 \$70302 \$48252 \$69929 \$70258 NWELL PWELL BULK MUX2_X1
X$113780 \$65845 \$48252 \$65843 \$65646 NWELL PWELL BULK MUX2_X1
X$113782 \$70261 \$48252 \$70256 \$70257 NWELL PWELL BULK MUX2_X1
X$113785 \$64200 \$48252 \$64419 \$63153 NWELL PWELL BULK MUX2_X1
X$113788 \$59475 \$48252 \$60196 \$60421 NWELL PWELL BULK MUX2_X1
X$113790 \$61665 \$48252 \$61653 \$60734 NWELL PWELL BULK MUX2_X1
X$113792 \$59237 \$48252 \$59232 \$58699 NWELL PWELL BULK MUX2_X1
X$113794 \$70609 \$48252 \$69941 \$69675 NWELL PWELL BULK MUX2_X1
X$113797 \$54561 \$48252 \$54882 \$54562 NWELL PWELL BULK MUX2_X1
X$113799 \$49076 \$48252 \$48650 \$49175 NWELL PWELL BULK MUX2_X1
X$113801 \$71729 \$48252 \$70967 \$71355 NWELL PWELL BULK MUX2_X1
X$113803 \$67460 \$48252 \$67449 \$65647 NWELL PWELL BULK MUX2_X1
X$113806 \$70929 \$48252 \$70511 \$70512 NWELL PWELL BULK MUX2_X1
X$113808 \$72839 \$48252 \$73162 \$72837 NWELL PWELL BULK MUX2_X1
X$113810 \$72880 \$48252 \$72882 \$72648 NWELL PWELL BULK MUX2_X1
X$113814 \$51239 \$48252 \$50743 \$50594 NWELL PWELL BULK MUX2_X1
X$113816 \$52412 \$48252 \$51651 \$52411 NWELL PWELL BULK MUX2_X1
X$113818 \$59790 \$48252 \$59780 \$58500 NWELL PWELL BULK MUX2_X1
X$113820 \$62986 \$48252 \$62269 \$63253 NWELL PWELL BULK MUX2_X1
X$113822 \$58961 \$48252 \$59127 \$58133 NWELL PWELL BULK MUX2_X1
X$113824 \$58240 \$48252 \$58654 \$58647 NWELL PWELL BULK MUX2_X1
X$113826 \$53899 \$48252 \$54299 \$54101 NWELL PWELL BULK MUX2_X1
X$113828 \$48477 \$48252 \$48253 \$48254 NWELL PWELL BULK MUX2_X1
X$113832 \$69734 \$48252 \$69662 \$69735 NWELL PWELL BULK MUX2_X1
X$113834 \$68859 \$48252 \$68470 \$69053 NWELL PWELL BULK MUX2_X1
X$113837 \$71378 \$48252 \$71730 \$71363 NWELL PWELL BULK MUX2_X1
X$113920 \$48411 \$48271 \$48953 NWELL PWELL BULK NOR2_X2
X$113925 \$48274 \$48275 \$48276 \$48277 NWELL PWELL BULK MUX2_X1
X$113931 \$69384 \$48275 \$69308 \$69383 NWELL PWELL BULK MUX2_X1
X$113933 \$68958 \$48275 \$68884 \$68946 NWELL PWELL BULK MUX2_X1
X$113935 \$69301 \$48275 \$68610 \$69410 NWELL PWELL BULK MUX2_X1
X$113938 \$69296 \$48275 \$68875 \$69434 NWELL PWELL BULK MUX2_X1
X$113941 \$67943 \$48275 \$67944 \$67648 NWELL PWELL BULK MUX2_X1
X$113944 \$68482 \$48275 \$69291 \$68617 NWELL PWELL BULK MUX2_X1
X$113947 \$67651 \$48275 \$67367 \$67072 NWELL PWELL BULK MUX2_X1
X$113950 \$57364 \$48275 \$57761 \$56729 NWELL PWELL BULK MUX2_X1
X$113952 \$58537 \$48275 \$58538 \$58539 NWELL PWELL BULK MUX2_X1
X$113954 \$58967 \$48275 \$59493 \$59074 NWELL PWELL BULK MUX2_X1
X$113956 \$58525 \$48275 \$59629 \$59104 NWELL PWELL BULK MUX2_X1
X$113958 \$60751 \$48275 \$60436 \$60845 NWELL PWELL BULK MUX2_X1
X$113961 \$64151 \$48275 \$63975 \$63976 NWELL PWELL BULK MUX2_X1
X$113963 \$64532 \$48275 \$64786 \$64088 NWELL PWELL BULK MUX2_X1
X$113966 \$60130 \$48275 \$60440 \$60759 NWELL PWELL BULK MUX2_X1
X$113969 \$62284 \$48275 \$61907 \$62286 NWELL PWELL BULK MUX2_X1
X$113971 \$56890 \$48275 \$55895 \$56459 NWELL PWELL BULK MUX2_X1
X$113973 \$60490 \$48275 \$61411 \$60829 NWELL PWELL BULK MUX2_X1
X$113977 \$67086 \$48275 \$67256 \$66820 NWELL PWELL BULK MUX2_X1
X$113979 \$51671 \$48275 \$51674 \$52164 NWELL PWELL BULK MUX2_X1
X$113981 \$65798 \$48275 \$66372 \$66373 NWELL PWELL BULK MUX2_X1
X$113984 \$69414 \$48275 \$69672 \$69673 NWELL PWELL BULK MUX2_X1
X$113986 \$68873 \$48275 \$68189 \$68619 NWELL PWELL BULK MUX2_X1
X$113989 \$66040 \$48275 \$65663 \$66041 NWELL PWELL BULK MUX2_X1
X$113991 \$67076 \$48275 \$67078 \$66767 NWELL PWELL BULK MUX2_X1
X$113994 \$68881 \$48275 \$68491 \$69390 NWELL PWELL BULK MUX2_X1
X$113996 \$67948 \$48275 \$68133 \$67707 NWELL PWELL BULK MUX2_X1
X$113998 \$69717 \$48275 \$69677 \$69678 NWELL PWELL BULK MUX2_X1
X$114000 \$49200 \$48275 \$48678 \$49281 NWELL PWELL BULK MUX2_X1
X$114002 \$50364 \$48275 \$50927 \$51675 NWELL PWELL BULK MUX2_X1
X$114005 \$52957 \$48275 \$53383 \$52959 NWELL PWELL BULK MUX2_X1
X$114007 \$51817 \$48275 \$51374 \$52595 NWELL PWELL BULK MUX2_X1
X$114009 \$48851 \$48275 \$48375 \$48838 NWELL PWELL BULK MUX2_X1
X$114012 \$48395 \$48275 \$48278 \$48671 NWELL PWELL BULK MUX2_X1
X$114017 \$58528 \$48275 \$58139 \$58228 NWELL PWELL BULK MUX2_X1
X$114019 \$64431 \$48275 \$64110 \$64841 NWELL PWELL BULK MUX2_X1
X$114021 \$64778 \$48275 \$63981 \$64429 NWELL PWELL BULK MUX2_X1
X$114023 \$65068 \$48275 \$64774 \$64421 NWELL PWELL BULK MUX2_X1
X$114025 \$64785 \$48275 \$64434 \$65266 NWELL PWELL BULK MUX2_X1
X$114027 \$64105 \$48275 \$64436 \$65081 NWELL PWELL BULK MUX2_X1
X$114029 \$64441 \$48275 \$65239 \$64442 NWELL PWELL BULK MUX2_X1
X$114031 \$63490 \$48275 \$62868 \$62481 NWELL PWELL BULK MUX2_X1
X$114033 \$60140 \$48275 \$60754 \$60756 NWELL PWELL BULK MUX2_X1
X$114036 \$63172 \$48275 \$62864 \$63173 NWELL PWELL BULK MUX2_X1
X$114038 \$62281 \$48275 \$61903 \$62283 NWELL PWELL BULK MUX2_X1
X$114109 M0_AXI_WDATA[5] \$48283 NWELL PWELL BULK BUF_X1
X$114123 \$48287 \$48368 \$48369 NWELL PWELL BULK NOR2_X2
X$114153 \$48708 S0_AXI_WDATA[17] NWELL PWELL BULK BUF_X1
X$114158 M2_AXI_WDATA[14] \$48331 NWELL PWELL BULK BUF_X1
X$114174 \$48689 \$48319 \$48690 NWELL PWELL BULK NOR2_X1
X$114219 \$70521 \$48339 \$73189 \$73590 NWELL PWELL BULK OAI21_X1
X$114221 \$48339 \$71173 \$73546 \$72681 NWELL PWELL BULK OAI21_X1
X$114224 \$48339 \$71156 \$73586 \$73532 NWELL PWELL BULK OAI21_X1
X$114235 \$48339 \$70514 \$71949 \$72348 NWELL PWELL BULK OAI21_X1
X$114273 \$48369 \$70514 \$71559 \$72053 NWELL PWELL BULK OAI21_X1
X$114275 \$48369 \$71156 \$72360 \$72362 NWELL PWELL BULK OAI21_X1
X$114277 \$48369 \$71173 \$71639 \$71170 NWELL PWELL BULK OAI21_X1
X$114279 \$70521 \$48369 \$71561 \$72810 NWELL PWELL BULK OAI21_X1
X$114369 M0_AXI_WDATA[27] \$48437 NWELL PWELL BULK BUF_X1
X$114441 \$48510 \$49003 \$48516 \$48512 NWELL PWELL BULK HA_X1
X$114463 \$48531 S0_AXI_AWLEN[2] NWELL PWELL BULK BUF_X1
X$114472 \$48534 \$48613 NWELL PWELL BULK INV_X1
X$114510 M2_AXI_AWADDR[23] \$48553 NWELL PWELL BULK BUF_X1
X$114527 \$48556 \$48557 NWELL PWELL BULK INV_X1
X$114572 M2_AXI_AWADDR[31] \$48584 NWELL PWELL BULK BUF_X1
X$114607 \$49135 \$48605 NWELL PWELL BULK INV_X1
X$114622 \$I175174 \$50192 \$50495 \$48619 NWELL PWELL BULK DFF_X1
X$114624 \$I175043 \$48997 \$49000 \$48619 NWELL PWELL BULK DFF_X1
X$114626 \$I177508 \$49517 \$50078 \$48619 NWELL PWELL BULK DFF_X1
X$114629 \$I177499 \$49003 \$49435 \$48619 NWELL PWELL BULK DFF_X1
X$114631 \$I175173 \$49157 \$49812 \$48619 NWELL PWELL BULK DFF_X1
X$114634 \$I177500 \$52809 \$52891 \$48619 NWELL PWELL BULK DFF_X1
X$114636 \$I175030 \$50886 \$51485 \$48619 NWELL PWELL BULK DFF_X1
X$114638 \$I177507 \$51633 \$51630 \$48619 NWELL PWELL BULK DFF_X1
X$114641 \$53128 \$48619 \$53720 \$53201 NWELL PWELL BULK DFF_X2
X$114643 \$I177229 \$56621 \$55799 \$48619 NWELL PWELL BULK DFF_X1
X$114646 \$53721 \$48619 \$53719 \$53194 NWELL PWELL BULK DFF_X2
X$114649 \$I174366 \$58058 \$57923 \$48619 NWELL PWELL BULK DFF_X1
X$114652 \$56977 \$56618 \$57264 \$48619 NWELL PWELL BULK DFF_X1
X$114655 \$I177264 \$55325 \$55465 \$48619 NWELL PWELL BULK DFF_X1
X$114658 \$I174408 \$56086 \$56085 \$48619 NWELL PWELL BULK DFF_X1
X$114661 \$I176867 \$54039 \$54038 \$48619 NWELL PWELL BULK DFF_X1
X$114663 \$50090 \$50091 \$50094 \$48619 NWELL PWELL BULK DFF_X1
X$114666 \$50572 \$50490 \$50488 \$48619 NWELL PWELL BULK DFF_X1
X$114668 \$I177504 \$52801 \$52471 \$48619 NWELL PWELL BULK DFF_X1
X$114670 \$I177524 \$53190 \$52889 \$48619 NWELL PWELL BULK DFF_X1
X$114673 \$52018 \$52017 \$52015 \$48619 NWELL PWELL BULK DFF_X1
X$114676 \$I177383 \$58057 \$58292 \$48619 NWELL PWELL BULK DFF_X1
X$114678 \$I177384 \$56956 \$57263 \$48619 NWELL PWELL BULK DFF_X1
X$114680 \$I174636 \$56964 \$56965 \$48619 NWELL PWELL BULK DFF_X1
X$114683 \$I177250 \$55796 \$55685 \$48619 NWELL PWELL BULK DFF_X1
X$114686 \$I177253 \$54031 \$54029 \$48619 NWELL PWELL BULK DFF_X1
X$114689 \$I177252 \$54480 \$54825 \$48619 NWELL PWELL BULK DFF_X1
X$114691 \$I177256 \$55042 \$55690 \$48619 NWELL PWELL BULK DFF_X1
X$114694 \$I177318 \$55795 \$55462 \$48619 NWELL PWELL BULK DFF_X1
X$114697 \$I174601 \$54036 \$54829 \$48619 NWELL PWELL BULK DFF_X1
X$114728 \$49162 \$48627 \$48628 \$48631 NWELL PWELL BULK AND3_X1
X$114730 \$48627 \$48628 \$49029 \$49425 NWELL PWELL BULK HA_X1
X$114734 \$48627 \$49443 NWELL PWELL BULK INV_X1
X$114745 \$49165 \$48631 \$49046 \$49057 NWELL PWELL BULK HA_X1
X$114751 \$48632 \$49411 \$49056 NWELL PWELL BULK XOR2_X1
X$114759 \$48636 \$48637 \$49403 \$49078 NWELL PWELL BULK MUX2_X1
X$114764 \$49772 \$48637 \$48638 NWELL PWELL BULK NOR2_X1
X$114767 \$49400 \$49527 \$48637 \$49762 NWELL PWELL BULK AOI21_X1
X$114770 \$48637 \$49399 \$49400 NWELL PWELL BULK NOR2_X1
X$114788 \$48645 \$49528 NWELL PWELL BULK INV_X1
X$114818 M2_AXI_WDATA[27] \$48663 NWELL PWELL BULK BUF_X1
X$114841 \$I178865 \$49200 \$48677 \$49554 NWELL PWELL BULK DFF_X1
X$114846 \$I176647 \$48678 \$49277 \$49554 NWELL PWELL BULK DFF_X1
X$114854 \$53505 \$54254 \$48689 \$54257 NWELL PWELL BULK AOI21_X1
X$114857 \$48689 \$54112 \$53505 NWELL PWELL BULK NOR2_X1
X$114860 \$48689 \$53023 \$52951 NWELL PWELL BULK NOR2_X1
X$114862 \$52951 \$51666 \$48689 \$53280 NWELL PWELL BULK AOI21_X1
X$114864 \$48689 \$49573 \$50240 NWELL PWELL BULK NOR2_X1
X$114867 \$50240 \$49911 \$48689 \$50262 NWELL PWELL BULK AOI21_X1
X$114874 \$52171 \$52597 \$48689 \$52658 NWELL PWELL BULK AOI21_X1
X$114877 \$48689 \$52601 \$52171 NWELL PWELL BULK NOR2_X1
X$114879 \$48689 \$52204 \$52181 NWELL PWELL BULK NOR2_X1
X$114882 \$52966 \$52607 \$48689 \$52996 NWELL PWELL BULK AOI21_X1
X$114884 \$48689 \$52179 \$52966 NWELL PWELL BULK NOR2_X1
X$114886 \$52181 \$50941 \$48689 \$51688 NWELL PWELL BULK AOI21_X1
X$114888 \$57402 \$57380 \$48689 \$56773 NWELL PWELL BULK AOI21_X1
X$114891 \$48689 \$56750 \$57402 NWELL PWELL BULK NOR2_X1
X$114893 \$55891 \$55885 \$48689 \$55889 NWELL PWELL BULK AOI21_X1
X$114895 \$48689 \$55131 \$55891 NWELL PWELL BULK NOR2_X1
X$114897 \$55145 \$54135 \$48689 \$55144 NWELL PWELL BULK AOI21_X1
X$114899 \$48689 \$55550 \$55145 NWELL PWELL BULK NOR2_X1
X$114901 \$48689 \$55552 \$55908 NWELL PWELL BULK NOR2_X1
X$114904 \$55908 \$54142 \$48689 \$55149 NWELL PWELL BULK AOI21_X1
X$114907 \$62289 \$62475 \$48689 \$62471 NWELL PWELL BULK AOI21_X1
X$114909 \$48689 \$62468 \$62289 NWELL PWELL BULK NOR2_X1
X$114912 \$61970 \$62292 \$48689 \$60762 NWELL PWELL BULK AOI21_X1
X$114914 \$48689 \$61253 \$61970 NWELL PWELL BULK NOR2_X1
X$114916 \$59558 \$59499 \$48689 \$59501 NWELL PWELL BULK AOI21_X1
X$114919 \$48689 \$60769 \$60805 NWELL PWELL BULK NOR2_X1
X$114922 \$48689 \$59502 \$59558 NWELL PWELL BULK NOR2_X1
X$114925 \$60805 \$61351 \$48689 \$61342 NWELL PWELL BULK AOI21_X1
X$114954 M2_AXI_RREADY \$49203 NWELL PWELL BULK BUF_X2
X$114959 \$48751 S1_AXI_WDATA[27] NWELL PWELL BULK BUF_X1
X$114964 \$48719 S1_AXI_WDATA[16] NWELL PWELL BULK BUF_X1
X$114969 \$49263 M2_AXI_RVALID NWELL PWELL BULK BUF_X1
X$115035 \$48780 \$48775 \$48772 \$49104 NWELL PWELL BULK DFF_X1
X$115083 \$48808 \$49204 \$49274 \$49554 NWELL PWELL BULK DFF_X1
X$115106 \$48843 S0_AXI_AWADDR[19] NWELL PWELL BULK BUF_X1
X$115202 \$57261 \$57696 \$50040 \$48944 NWELL PWELL BULK MUX2_X2
X$115219 \$48953 \$70514 \$77238 \$77587 NWELL PWELL BULK OAI21_X1
X$115222 \$48953 \$71173 \$78158 \$77793 NWELL PWELL BULK OAI21_X1
X$115225 \$70521 \$48953 \$78082 \$78181 NWELL PWELL BULK OAI21_X1
X$115227 \$48953 \$71156 \$77541 \$77583 NWELL PWELL BULK OAI21_X1
X$115309 \$49025 \$49157 \$49519 \$49158 NWELL PWELL BULK HA_X1
X$115372 M1_AXI_AWADDR[8] \$49819 NWELL PWELL BULK BUF_X1
X$115386 \$49467 \$49611 \$49101 \$49104 NWELL PWELL BULK DFF_X1
X$115388 \$I179303 \$53152 \$53150 \$49104 NWELL PWELL BULK DFF_X1
X$115390 \$51828 \$51826 \$51825 \$49104 NWELL PWELL BULK DFF_X1
X$115393 \$53160 \$53867 \$53157 \$49104 NWELL PWELL BULK DFF_X1
X$115396 \$53862 \$53375 \$53376 \$49104 NWELL PWELL BULK DFF_X1
X$115399 \$49106 \$49266 \$49272 \$49104 NWELL PWELL BULK DFF_X1
X$115401 \$49110 \$49646 \$49289 \$49104 NWELL PWELL BULK DFF_X1
X$115403 \$49831 \$49990 \$49625 \$49104 NWELL PWELL BULK DFF_X1
X$115405 \$50343 \$50148 \$50333 \$49104 NWELL PWELL BULK DFF_X1
X$115408 \$50550 \$50709 \$50711 \$49104 NWELL PWELL BULK DFF_X1
X$115410 \$I175181 \$53996 \$54665 \$49104 NWELL PWELL BULK DFF_X1
X$115414 \$I175161 \$55021 \$55216 \$49104 NWELL PWELL BULK DFF_X1
X$115417 \$I175164 \$54698 \$55023 \$49104 NWELL PWELL BULK DFF_X1
X$115420 \$I178955 \$57236 \$57444 \$49104 NWELL PWELL BULK DFF_X1
X$115422 \$I175171 \$56821 \$56824 \$49104 NWELL PWELL BULK DFF_X1
X$115425 \$I175168 \$54660 \$55199 \$49104 NWELL PWELL BULK DFF_X1
X$115428 \$I178961 \$53700 \$54214 \$49104 NWELL PWELL BULK DFF_X1
X$115430 \$I175182 \$54446 \$55207 \$49104 NWELL PWELL BULK DFF_X1
X$115433 \$I175109 \$55770 \$55982 \$49104 NWELL PWELL BULK DFF_X1
X$115435 \$54232 \$53875 \$53162 \$49104 NWELL PWELL BULK DFF_X1
X$115437 \$51579 \$52090 \$52318 \$49104 NWELL PWELL BULK DFF_X1
X$115440 \$I179232 \$53165 \$53404 \$49104 NWELL PWELL BULK DFF_X1
X$115442 \$I176368 \$53413 \$53403 \$49104 NWELL PWELL BULK DFF_X1
X$115444 \$52861 \$53390 \$53161 \$49104 NWELL PWELL BULK DFF_X1
X$115447 \$52313 \$52694 \$52311 \$49104 NWELL PWELL BULK DFF_X1
X$115449 \$I175160 \$54679 \$54693 \$49104 NWELL PWELL BULK DFF_X1
X$115451 \$52207 \$52620 \$52065 \$49104 NWELL PWELL BULK DFF_X1
X$115456 \$I178957 \$58392 \$58204 \$49104 NWELL PWELL BULK DFF_X1
X$115458 \$I179000 \$55975 \$56823 \$49104 NWELL PWELL BULK DFF_X1
X$115531 \$60188 \$60931 \$50040 \$49135 NWELL PWELL BULK MUX2_X2
X$115560 \$49782 \$49158 \$49520 \$49522 NWELL PWELL BULK AOI21_X1
X$115562 \$50069 \$49522 \$49866 \$49159 NWELL PWELL BULK OAI21_X1
X$115564 \$49445 \$49446 \$49159 \$49160 NWELL PWELL BULK AOI21_X1
X$115568 \$49162 \$49426 \$49434 NWELL PWELL BULK XOR2_X1
X$115577 \$49165 \$49419 NWELL PWELL BULK INV_X1
X$115584 \$49871 \$49169 \$49754 NWELL PWELL BULK XNOR2_X2
X$115600 \$49695 \$49181 \$49696 NWELL PWELL BULK NOR2_X2
X$115621 \$49263 \$49203 \$55512 NWELL PWELL BULK NAND2_X2
X$115681 \$56694 \$57907 \$57906 \$49263 NWELL PWELL BULK NAND3_X4
X$115836 \$49527 \$49766 \$49399 \$49765 \$49403 NWELL PWELL BULK FA_X1
X$115908 \$49457 S0_AXI_AWADDR[21] NWELL PWELL BULK BUF_X1
X$115923 \$49463 \$49945 NWELL PWELL BULK INV_X1
X$115959 \$49489 \$49492 NWELL PWELL BULK INV_X1
X$115964 \$58242 \$58405 \$50040 \$49489 NWELL PWELL BULK MUX2_X2
X$115983 \$50175 \$49498 NWELL PWELL BULK INV_X1
X$116014 \$49793 \$49513 NWELL PWELL BULK INV_X1
X$116019 \$49791 \$49517 \$49520 \$49782 NWELL PWELL BULK HA_X1
X$116040 \$49526 \$49766 \$49772 NWELL PWELL BULK XOR2_X1
X$116043 \$49526 \$49765 NWELL PWELL BULK INV_X1
X$116070 \$49530 \$50896 \$51348 NWELL PWELL BULK NAND2_X1
X$116072 \$49530 \$50581 \$50515 NWELL PWELL BULK NAND2_X1
X$116074 \$49530 \$51342 \$50891 NWELL PWELL BULK NAND2_X1
X$116076 \$49530 \$50893 \$51345 NWELL PWELL BULK NAND2_X1
X$116078 \$49530 \$50894 \$50760 NWELL PWELL BULK NAND2_X1
X$116082 \$49530 \$50895 \$50762 NWELL PWELL BULK NAND2_X1
X$116115 \$53557 \$51178 \$49541 NWELL PWELL BULK NOR2_X1
X$116135 \$I177376 \$52696 \$53457 \$49554 NWELL PWELL BULK DFF_X1
X$116137 \$I174320 \$53023 \$53280 \$49554 NWELL PWELL BULK DFF_X1
X$116140 \$52954 \$53407 \$53405 \$49554 NWELL PWELL BULK DFF_X1
X$116143 \$53417 \$53285 \$52952 \$49554 NWELL PWELL BULK DFF_X1
X$116145 \$I175607 \$50927 \$51080 \$49554 NWELL PWELL BULK DFF_X1
X$116148 \$I176652 \$51817 \$51818 \$49554 NWELL PWELL BULK DFF_X1
X$116151 \$I176694 \$51374 \$51679 \$49554 NWELL PWELL BULK DFF_X1
X$116154 \$I176598 \$51671 \$51669 \$49554 NWELL PWELL BULK DFF_X1
X$116156 \$I178727 \$51674 \$51371 \$49554 NWELL PWELL BULK DFF_X1
X$116159 \$51377 \$51416 \$51418 \$49554 NWELL PWELL BULK DFF_X1
X$116161 \$49907 \$49969 \$49973 \$49554 NWELL PWELL BULK DFF_X1
X$116163 \$50336 \$50934 \$50661 \$49554 NWELL PWELL BULK DFF_X1
X$116168 \$50339 \$50340 \$49985 \$49554 NWELL PWELL BULK DFF_X1
X$116171 \$I176561 \$52957 \$52682 \$49554 NWELL PWELL BULK DFF_X1
X$116174 \$49908 \$49958 \$49956 \$49554 NWELL PWELL BULK DFF_X1
X$116176 \$50327 \$50309 \$50313 \$49554 NWELL PWELL BULK DFF_X1
X$116179 \$I178677 \$52170 \$52169 \$49554 NWELL PWELL BULK DFF_X1
X$116181 \$52244 \$52174 \$52259 \$49554 NWELL PWELL BULK DFF_X1
X$116183 \$51792 \$51684 \$52260 \$49554 NWELL PWELL BULK DFF_X1
X$116185 \$I175934 \$52601 \$52658 \$49554 NWELL PWELL BULK DFF_X1
X$116187 \$50935 \$51033 \$51035 \$49554 NWELL PWELL BULK DFF_X1
X$116189 \$54775 \$54769 \$54774 \$49554 NWELL PWELL BULK DFF_X1
X$116192 \$I177052 \$53383 \$53794 \$49554 NWELL PWELL BULK DFF_X1
X$116195 \$54122 \$54747 \$54223 \$49554 NWELL PWELL BULK DFF_X1
X$116198 \$I177128 \$55895 \$55616 \$49554 NWELL PWELL BULK DFF_X1
X$116200 \$54580 \$54754 \$54577 \$49554 NWELL PWELL BULK DFF_X1
X$116203 \$54119 \$54229 \$54231 \$49554 NWELL PWELL BULK DFF_X1
X$116236 M2_AXI_WDATA[5] \$49905 NWELL PWELL BULK BUF_X1
X$116241 M2_AXI_WDATA[18] \$50226 NWELL PWELL BULK CLKBUF_X2
X$116246 \$49596 S0_AXI_WDATA[14] NWELL PWELL BULK BUF_X1
X$116251 M1_AXI_AWLEN[0] \$49569 NWELL PWELL BULK CLKBUF_X2
X$116291 \$54627 \$55015 \$50040 \$49587 NWELL PWELL BULK MUX2_X2
X$116372 \$49696 \$71156 \$79070 \$78730 NWELL PWELL BULK OAI21_X1
X$116374 \$49696 \$70514 \$80252 \$79904 NWELL PWELL BULK OAI21_X1
X$116376 \$70521 \$49696 \$80180 \$80178 NWELL PWELL BULK OAI21_X1
X$116380 \$49696 \$71173 \$79822 \$79445 NWELL PWELL BULK OAI21_X1
X$116408 \$50172 \$49737 NWELL PWELL BULK INV_X1
X$116428 \$67585 \$61799 \$49755 \$67756 NWELL PWELL BULK MUX2_X1
X$116431 \$66971 \$62451 \$49755 \$67244 NWELL PWELL BULK MUX2_X1
X$116434 \$66970 \$62181 \$49755 \$67767 NWELL PWELL BULK MUX2_X1
X$116437 \$67588 \$61102 \$49755 \$67587 NWELL PWELL BULK MUX2_X1
X$116481 \$55791 \$55680 \$50040 \$49793 NWELL PWELL BULK MUX2_X2
X$116500 M1_AXI_AWADDR[1] \$50552 NWELL PWELL BULK BUF_X1
X$116529 M2_AXI_AWADDR[30] \$49837 NWELL PWELL BULK BUF_X1
X$116551 \$64970 \$61799 \$49844 \$64968 NWELL PWELL BULK MUX2_X1
X$116553 \$64360 \$61102 \$49844 \$64700 NWELL PWELL BULK MUX2_X1
X$116556 \$63371 \$62451 \$49844 \$63902 NWELL PWELL BULK MUX2_X1
X$116558 \$63638 \$62181 \$49844 \$64126 NWELL PWELL BULK MUX2_X1
X$116585 \$50427 \$49849 NWELL PWELL BULK INV_X1
X$116611 \$50060 \$49866 NWELL PWELL BULK INV_X1
X$116618 \$71339 \$49873 \$71336 \$70849 NWELL PWELL BULK MUX2_X1
X$116620 \$71699 \$49873 \$71721 \$71157 NWELL PWELL BULK MUX2_X1
X$116623 \$70501 \$49873 \$70502 \$70500 NWELL PWELL BULK MUX2_X1
X$116625 \$70844 \$49873 \$71152 \$71373 NWELL PWELL BULK MUX2_X1
X$116627 \$69062 \$49873 \$69658 \$69472 NWELL PWELL BULK MUX2_X1
X$116629 \$52415 \$49873 \$50913 \$52419 NWELL PWELL BULK MUX2_X1
X$116631 \$59240 \$49873 \$58940 \$58704 NWELL PWELL BULK MUX2_X1
X$116633 \$53258 \$49873 \$53895 \$53623 NWELL PWELL BULK MUX2_X1
X$116635 \$70304 \$49873 \$69665 \$70305 NWELL PWELL BULK MUX2_X1
X$116637 \$70605 \$49873 \$69690 \$69939 NWELL PWELL BULK MUX2_X1
X$116639 \$72377 \$49873 \$71920 \$72380 NWELL PWELL BULK MUX2_X1
X$116641 \$72110 \$49873 \$71918 \$71689 NWELL PWELL BULK MUX2_X1
X$116647 \$58123 \$49873 NWELL PWELL BULK BUF_X8
X$116673 M2_AXI_WSTRB[3] \$49877 NWELL PWELL BULK CLKBUF_X2
X$116732 \$50683 \$50354 \$49911 NWELL PWELL BULK NOR2_X2
X$116745 \$49927 M2_AXI_RID[2] NWELL PWELL BULK BUF_X1
X$116750 \$50241 S0_AXI_WDATA[4] NWELL PWELL BULK BUF_X1
X$116757 \$60520 \$60030 \$58937 \$49927 NWELL PWELL BULK MUX2_X2
X$116856 \$59383 \$59643 \$50040 \$50175 NWELL PWELL BULK MUX2_X2
X$116868 \$74969 \$75163 \$50040 \$50181 NWELL PWELL BULK MUX2_X2
X$116876 \$60794 \$60464 \$50040 \$51549 NWELL PWELL BULK MUX2_X2
X$116888 \$59660 \$60164 \$50040 \$50427 NWELL PWELL BULK MUX2_X2
X$116890 \$57503 \$57507 \$50040 \$50172 NWELL PWELL BULK MUX2_X2
X$116895 \$75287 \$75531 \$50040 \$51298 NWELL PWELL BULK MUX2_X2
X$116899 \$73604 \$73608 \$50040 \$51291 NWELL PWELL BULK MUX2_X2
X$116904 \$73589 \$73598 \$50040 \$51561 NWELL PWELL BULK MUX2_X2
X$116910 \$74369 \$74371 \$50040 \$52209 NWELL PWELL BULK MUX2_X2
X$116912 \$75525 \$75821 \$50040 \$50695 NWELL PWELL BULK MUX2_X2
X$116915 \$75643 \$75818 \$50040 \$52075 NWELL PWELL BULK MUX2_X2
X$116918 \$72699 \$72703 \$50040 \$50271 NWELL PWELL BULK MUX2_X2
X$116965 \$50055 \$50192 \$50062 \$50060 NWELL PWELL BULK HA_X1
X$116979 \$50062 \$50069 NWELL PWELL BULK INV_X1
X$117025 \$50181 \$50117 NWELL PWELL BULK INV_X1
X$117028 M1_AXI_AWLEN[6] \$50163 NWELL PWELL BULK BUF_X1
X$117033 M1_AXI_AWADDR[9] \$51270 NWELL PWELL BULK BUF_X1
X$117122 M1_AXI_AWID[2] \$50178 NWELL PWELL BULK CLKBUF_X2
X$117162 \$50888 \$51226 \$50194 NWELL PWELL BULK XOR2_X1
X$117165 \$50575 \$50195 \$50576 \$50507 NWELL PWELL BULK MUX2_X1
X$117169 \$50195 \$50889 \$50890 NWELL PWELL BULK NOR2_X1
X$117172 \$50890 \$50578 \$50195 \$51235 NWELL PWELL BULK AOI21_X1
X$117198 \$50399 \$50403 \$50217 NWELL PWELL BULK NOR2_X1
X$117203 \$50707 \$50219 \$51132 NWELL PWELL BULK NOR2_X2
X$117267 S0_AXI_RID[1] \$50962 NWELL PWELL BULK CLKBUF_X3
X$117357 \$50348 \$51056 \$51059 NWELL PWELL BULK NOR2_X2
X$117376 \$70923 \$63530 \$50365 \$70422 NWELL PWELL BULK MUX2_X1
X$117379 \$72370 \$61075 \$50365 \$72741 NWELL PWELL BULK MUX2_X1
X$117382 \$71479 \$62181 \$50365 \$71633 NWELL PWELL BULK MUX2_X1
X$117384 \$71827 \$63057 \$50365 \$72215 NWELL PWELL BULK MUX2_X1
X$117502 \$50518 \$65065 NWELL PWELL BULK BUF_X4
X$117504 \$50518 \$65028 NWELL PWELL BULK BUF_X4
X$117506 \$50518 \$65931 NWELL PWELL BULK BUF_X4
X$117509 \$59890 \$50518 NWELL PWELL BULK BUF_X4
X$117512 \$50518 \$52924 NWELL PWELL BULK BUF_X4
X$117515 \$50518 \$65049 NWELL PWELL BULK BUF_X4
X$117520 \$50518 \$54313 NWELL PWELL BULK BUF_X4
X$117522 \$50518 \$55096 NWELL PWELL BULK BUF_X4
X$117525 \$50518 \$59450 NWELL PWELL BULK BUF_X4
X$117527 \$50518 \$60031 NWELL PWELL BULK BUF_X4
X$117549 M2_AXI_AWADDR[10] \$50544 NWELL PWELL BULK BUF_X1
X$117559 \$54439 \$53989 \$50536 \$55183 NWELL PWELL BULK MUX2_X1
X$117621 \$50873 \$50565 NWELL PWELL BULK INV_X1
X$117636 \$50578 \$51226 \$50889 \$51232 \$50576 NWELL PWELL BULK FA_X1
X$117648 \$50581 \$50762 \$50764 NWELL PWELL BULK XOR2_X1
X$117661 \$I177557 \$50599 \$50598 \$51357 NWELL PWELL BULK DFF_X1
X$117672 \$I175350 \$50605 \$51157 \$51357 NWELL PWELL BULK DFF_X1
X$117704 M0_AXI_WSTRB[3] \$50913 NWELL PWELL BULK CLKBUF_X2
X$117709 M2_AXI_WDATA[26] \$50969 NWELL PWELL BULK CLKBUF_X2
X$117737 \$63545 \$63530 \$50662 \$64336 NWELL PWELL BULK MUX2_X1
X$117739 \$63059 \$61075 \$50662 \$64008 NWELL PWELL BULK MUX2_X1
X$117742 \$63513 \$63057 \$50662 \$63511 NWELL PWELL BULK MUX2_X1
X$117744 \$63532 \$63210 \$50662 \$63535 NWELL PWELL BULK MUX2_X1
X$117759 \$58829 \$53989 \$50667 \$59011 NWELL PWELL BULK MUX2_X1
X$117785 \$53152 \$53989 \$50692 \$53150 NWELL PWELL BULK MUX2_X1
X$117814 \$55975 \$53989 \$50698 \$56823 NWELL PWELL BULK MUX2_X1
X$117838 \$66961 \$63210 \$50728 \$67188 NWELL PWELL BULK MUX2_X1
X$117842 \$67840 \$61075 \$50728 \$68046 NWELL PWELL BULK MUX2_X1
X$117844 \$67718 \$62350 \$50728 \$67720 NWELL PWELL BULK MUX2_X1
X$117846 \$66960 \$63530 \$50728 \$67201 NWELL PWELL BULK MUX2_X1
X$117894 M1_AXI_AWID[0] \$50755 NWELL PWELL BULK BUF_X1
X$117939 \$50861 \$50779 NWELL PWELL BULK INV_X1
X$117943 \$50780 \$51203 NWELL PWELL BULK INV_X1
X$117982 \$50814 \$50986 NWELL PWELL BULK INV_X1
X$118001 \$50848 \$51111 NWELL PWELL BULK INV_X1
X$118054 \$51209 \$50879 NWELL PWELL BULK INV_X1
X$118076 \$51641 \$52433 \$I241010 \$50888 NWELL PWELL BULK HA_X1
X$118078 \$50888 \$51232 NWELL PWELL BULK INV_X1
X$118090 \$50894 \$50896 \$50893 \$50895 NWELL PWELL BULK HA_X1
X$118111 \$50901 \$50903 \$51223 NWELL PWELL BULK NOR2_X2
X$118136 \$50914 S1_AXI_WDATA[26] NWELL PWELL BULK BUF_X1
X$118147 M0_AXI_WDATA[14] \$50923 NWELL PWELL BULK BUF_X1
X$118184 \$51017 \$50940 \$50941 NWELL PWELL BULK NOR2_X1
X$118207 \$52186 S0_AXI_WDATA[19] NWELL PWELL BULK BUF_X1
X$118222 \$50962 \$55498 \$58925 \$59917 NWELL PWELL BULK MUX2_X1
X$118225 \$50962 \$54550 \$60283 \$60286 NWELL PWELL BULK MUX2_X1
X$118228 \$50962 \$56680 \$60018 \$60020 NWELL PWELL BULK MUX2_X1
X$118231 \$59919 \$58102 \$50962 \$60291 NWELL PWELL BULK MUX2_X1
X$118323 \$51059 \$70514 \$70515 \$70513 NWELL PWELL BULK OAI21_X1
X$118325 \$51059 \$71173 \$71258 \$71275 NWELL PWELL BULK OAI21_X1
X$118327 \$51059 \$71156 \$71939 \$71938 NWELL PWELL BULK OAI21_X1
X$118329 \$70521 \$51059 \$70520 \$70518 NWELL PWELL BULK OAI21_X1
X$118399 \$51132 \$71156 \$76393 \$76695 NWELL PWELL BULK OAI21_X1
X$118402 \$51132 \$71173 \$76597 \$76948 NWELL PWELL BULK OAI21_X1
X$118404 \$70521 \$51132 \$75914 \$76284 NWELL PWELL BULK OAI21_X1
X$118406 \$51132 \$70514 \$77235 \$76705 NWELL PWELL BULK OAI21_X1
X$118453 \$52733 \$51656 \$51171 NWELL PWELL BULK NOR2_X1
X$118504 \$51223 \$71156 \$76407 \$76272 NWELL PWELL BULK OAI21_X1
X$118507 \$51223 \$71173 \$76279 \$76281 NWELL PWELL BULK OAI21_X1
X$118510 \$70521 \$51223 \$77312 \$77531 NWELL PWELL BULK OAI21_X1
X$118513 \$51223 \$70514 \$77528 \$77318 NWELL PWELL BULK OAI21_X1
X$118554 M1_AXI_AWLEN[1] \$51336 NWELL PWELL BULK CLKBUF_X2
X$118578 \$51280 \$51743 NWELL PWELL BULK INV_X1
X$118616 M1_AXI_AWLEN[4] \$51308 NWELL PWELL BULK BUF_X1
X$118666 \$51340 \$51639 \$52434 \$52449 NWELL PWELL BULK MUX2_X1
X$118684 \$I177551 \$51358 \$51356 \$51357 NWELL PWELL BULK DFF_X1
X$118687 \$52338 \$51872 \$51875 \$51357 NWELL PWELL BULK DFF_X1
X$118691 \$I174278 \$51359 \$51659 \$51357 NWELL PWELL BULK DFF_X1
X$118693 \$I174735 \$52586 \$53520 \$51357 NWELL PWELL BULK DFF_X1
X$118695 \$I174343 \$52716 \$53041 \$51357 NWELL PWELL BULK DFF_X1
X$118697 \$I174261 \$52152 \$52584 \$51357 NWELL PWELL BULK DFF_X1
X$118700 \$I177417 \$53786 \$53865 \$51357 NWELL PWELL BULK DFF_X1
X$118703 \$I175411 \$54108 \$53782 \$51357 NWELL PWELL BULK DFF_X1
X$118708 \$I177147 \$53784 \$54569 \$51357 NWELL PWELL BULK DFF_X1
X$118710 \$I177560 \$54112 \$54257 \$51357 NWELL PWELL BULK DFF_X1
X$118713 \$I174645 \$54261 \$55269 \$51357 NWELL PWELL BULK DFF_X1
X$118715 \$56114 \$55866 \$56129 \$51357 NWELL PWELL BULK DFF_X1
X$118718 \$55868 \$55116 \$55530 \$51357 NWELL PWELL BULK DFF_X1
X$118720 \$52155 \$52331 \$52330 \$51357 NWELL PWELL BULK DFF_X1
X$118722 \$52159 \$52708 \$52709 \$51357 NWELL PWELL BULK DFF_X1
X$118724 \$I174399 \$54574 \$54259 \$51357 NWELL PWELL BULK DFF_X1
X$118728 \$I174256 \$52938 \$52725 \$51357 NWELL PWELL BULK DFF_X1
X$118731 \$53775 \$53565 \$53050 \$51357 NWELL PWELL BULK DFF_X1
X$118733 \$I176986 \$56408 \$55859 \$51357 NWELL PWELL BULK DFF_X1
X$118735 \$56972 \$56719 \$56969 \$51357 NWELL PWELL BULK DFF_X1
X$118738 \$I176314 \$55527 \$55306 \$51357 NWELL PWELL BULK DFF_X1
X$118740 \$I176318 \$55526 \$55862 \$51357 NWELL PWELL BULK DFF_X1
X$118743 \$I177443 \$55307 \$55649 \$51357 NWELL PWELL BULK DFF_X1
X$118746 \$56715 \$56986 \$56411 \$51357 NWELL PWELL BULK DFF_X1
X$118748 \$I177421 \$57352 \$57856 \$51357 NWELL PWELL BULK DFF_X1
X$118750 \$I176984 \$57027 \$57037 \$51357 NWELL PWELL BULK DFF_X1
X$118752 \$I176406 \$57350 \$57751 \$51357 NWELL PWELL BULK DFF_X1
X$118754 \$I176980 \$59161 \$58122 \$51357 NWELL PWELL BULK DFF_X1
X$118794 M2_AXI_WDATA[25] \$51362 NWELL PWELL BULK BUF_X1
X$118839 M2_AXI_WDATA[4] \$51685 NWELL PWELL BULK BUF_X1
X$118844 \$51733 M2_AXI_RID[1] NWELL PWELL BULK BUF_X1
X$118881 \$52563 \$51477 \$52807 \$52804 NWELL PWELL BULK MUX2_X1
X$118883 \$55089 \$51477 \$53247 \$55706 NWELL PWELL BULK MUX2_X1
X$118885 \$51477 \$55475 \$57312 \$56533 NWELL PWELL BULK AOI21_X4
X$118887 \$54542 \$51477 \$52563 \$54990 NWELL PWELL BULK MUX2_X1
X$118889 \$51477 \$52433 NWELL PWELL BULK INV_X1
X$118892 \$51477 \$52134 \$51639 NWELL PWELL BULK NAND2_X1
X$118895 \$53247 \$51477 \$53248 \$53669 NWELL PWELL BULK MUX2_X1
X$118897 \$51477 \$52439 \$52136 \$52135 NWELL PWELL BULK OAI21_X1
X$118899 \$52434 \$51477 \$52136 NWELL PWELL BULK NAND2_X1
X$118912 \$53210 \$52479 \$51480 \$58454 \$59414 NWELL PWELL BULK NOR4_X2
X$118915 \$51480 \$52479 \$53210 \$58882 NWELL PWELL BULK NOR3_X4
X$118917 \$53579 \$59270 \$52479 \$51480 \$59772 NWELL PWELL BULK NOR4_X1
X$118919 \$53210 \$52479 \$51480 \$59978 \$59778 NWELL PWELL BULK NOR4_X2
X$118925 \$52553 \$51480 NWELL PWELL BULK INV_X4
X$118969 \$62789 \$61799 \$51526 \$62958 NWELL PWELL BULK MUX2_X1
X$118971 \$63075 \$61102 \$51526 \$63632 NWELL PWELL BULK MUX2_X1
X$118973 \$62179 \$62181 \$51526 \$61796 NWELL PWELL BULK MUX2_X1
X$118976 \$62180 \$62451 \$51526 \$62791 NWELL PWELL BULK MUX2_X1
X$118988 M2_AXI_AWADDR[25] \$51582 NWELL PWELL BULK BUF_X1
X$118993 M1_AXI_AWADDR[4] \$52071 NWELL PWELL BULK BUF_X1
X$119029 \$51564 \$51791 NWELL PWELL BULK INV_X1
X$119037 \$51576 \$51813 NWELL PWELL BULK INV_X1
X$119049 \$51580 \$53409 \$52515 \$52327 NWELL PWELL BULK MUX2_X1
X$119101 \$52736 \$51600 NWELL PWELL BULK INV_X1
X$119149 \$52123 \$51638 \$52047 NWELL PWELL BULK NAND2_X1
X$119153 \$51638 \$52053 \$52841 NWELL PWELL BULK NOR2_X1
X$119158 \$51641 \$52922 \$53680 NWELL PWELL BULK NAND2_X1
X$119160 \$51641 \$52925 \$52926 NWELL PWELL BULK NAND2_X1
X$119162 \$51641 \$51645 \$52026 NWELL PWELL BULK NAND2_X1
X$119165 \$51641 \$53658 \$53253 NWELL PWELL BULK NAND2_X1
X$119167 \$51641 \$53667 \$52774 NWELL PWELL BULK NAND2_X1
X$119170 \$54084 \$54082 \$51641 \$56680 NWELL PWELL BULK NAND3_X4
X$119172 \$51641 \$53254 \$53913 NWELL PWELL BULK NAND2_X1
X$119174 \$54547 \$54082 \$51641 \$54550 NWELL PWELL BULK NAND3_X4
X$119189 \$I179187 \$51645 \$52772 \$52924 NWELL PWELL BULK DFF_X1
X$119192 \$51645 \$52926 \$52769 NWELL PWELL BULK XOR2_X1
X$119208 \$53034 \$52948 \$51666 NWELL PWELL BULK NOR2_X1
X$119267 S0_AXI_RID[2] \$52215 NWELL PWELL BULK CLKBUF_X3
X$119296 \$60930 \$60414 \$58937 \$51733 NWELL PWELL BULK MUX2_X2
X$119318 \$51759 \$51755 \$51766 NWELL PWELL BULK NOR2_X2
X$119324 \$51766 \$71173 \$74525 \$74501 NWELL PWELL BULK OAI21_X1
X$119327 \$51766 \$71156 \$74498 \$74955 NWELL PWELL BULK OAI21_X1
X$119330 \$51766 \$70514 \$72716 \$73183 NWELL PWELL BULK OAI21_X1
X$119334 \$70521 \$51766 \$73527 \$73622 NWELL PWELL BULK OAI21_X1
X$119414 \$53165 \$53409 \$53413 \$51847 NWELL PWELL BULK MUX2_X1
X$119545 \$52053 \$52128 \$52560 \$52129 NWELL PWELL BULK OAI21_X1
X$119556 M1_AXI_AWSIZE[0] \$52849 NWELL PWELL BULK BUF_X1
X$119614 \$59581 \$53989 \$52084 \$59948 NWELL PWELL BULK MUX2_X1
X$119652 \$62463 \$62181 \$52113 \$62183 NWELL PWELL BULK MUX2_X1
X$119655 \$60652 \$61102 \$52113 \$61104 NWELL PWELL BULK MUX2_X1
X$119658 \$61797 \$61799 \$52113 \$61406 NWELL PWELL BULK MUX2_X1
X$119661 \$62185 \$62451 \$52113 \$62186 NWELL PWELL BULK MUX2_X1
X$119669 \$52121 \$52546 \$52896 NWELL PWELL BULK NOR2_X1
X$119672 \$52121 \$52482 NWELL PWELL BULK INV_X1
X$119674 \$52545 \$52121 \$52546 \$52895 NWELL PWELL BULK NOR3_X1
X$119676 \$53214 \$52908 \$52123 NWELL PWELL BULK NOR2_X1
X$119678 \$52123 \$52126 \$52124 NWELL PWELL BULK NAND2_X1
X$119682 \$52834 \$52124 \$52125 NWELL PWELL BULK NAND2_X1
X$119686 \$52126 \$52912 \$54068 NWELL PWELL BULK OR2_X1
X$119688 \$53748 \$52128 \$52126 \$54390 NWELL PWELL BULK NAND3_X1
X$119690 \$52126 \$52558 \$52845 \$54913 NWELL PWELL BULK OR3_X1
X$119692 \$52126 \$53743 \$53230 \$54415 NWELL PWELL BULK OAI21_X1
X$119695 \$52126 \$54900 \$53230 \$54512 NWELL PWELL BULK OAI21_X1
X$119700 \$52558 \$52126 \$53226 NWELL PWELL BULK NOR2_X1
X$119702 \$53230 \$53747 \$52126 \$53754 NWELL PWELL BULK NAND3_X1
X$119704 \$52126 \$52561 \$52128 \$52472 NWELL PWELL BULK OAI21_X1
X$119721 \$54920 \$52128 \$54913 \$54522 NWELL PWELL BULK AOI21_X1
X$119723 \$52902 \$52128 \$52845 \$52843 NWELL PWELL BULK NOR3_X1
X$119725 \$52902 \$52128 \$52841 \$53217 NWELL PWELL BULK AOI21_X1
X$119727 \$52913 \$52128 \$53226 \$53641 NWELL PWELL BULK AND3_X1
X$119732 \$53096 \$52128 \$53086 NWELL PWELL BULK NAND2_X1
X$119750 \$52916 \$53086 \$52918 \$52917 \$52131 NWELL PWELL BULK OAI22_X1
X$119755 \$52132 \$52918 NWELL PWELL BULK INV_X1
X$119759 \$52133 \$54073 NWELL PWELL BULK INV_X1
X$119761 \$53247 \$52563 \$52807 \$52134 NWELL PWELL BULK HA_X1
X$119802 \$52161 S0_AXI_WDATA[26] NWELL PWELL BULK BUF_X1
X$119849 \$52994 S1_AXI_WDATA[18] NWELL PWELL BULK BUF_X1
X$119854 M2_AXI_WSTRB[2] \$52631 NWELL PWELL BULK BUF_X1
X$119884 \$52215 \$55498 \$59300 \$59303 NWELL PWELL BULK MUX2_X1
X$119888 \$59926 \$55501 \$52215 \$59307 NWELL PWELL BULK MUX2_X1
X$119890 \$52215 \$56680 \$60718 \$61758 NWELL PWELL BULK MUX2_X1
X$119892 \$52215 \$54550 \$60717 \$61748 NWELL PWELL BULK MUX2_X1
X$119913 \$61304 \$53989 \$52232 \$61943 NWELL PWELL BULK MUX2_X1
X$119930 \$52241 S1_AXI_WDATA[14] NWELL PWELL BULK BUF_X1
X$119976 \$68037 \$63210 \$52290 \$68032 NWELL PWELL BULK MUX2_X1
X$119978 \$68396 \$63530 \$52290 \$68395 NWELL PWELL BULK MUX2_X1
X$119980 \$69360 \$63057 \$52290 \$68771 NWELL PWELL BULK MUX2_X1
X$119982 \$69190 \$61075 \$52290 \$69191 NWELL PWELL BULK MUX2_X1
X$120064 \$63071 \$61799 \$52352 \$62175 NWELL PWELL BULK MUX2_X1
X$120067 \$63897 \$63355 \$52352 \$64533 NWELL PWELL BULK MUX2_X1
X$120069 \$63364 \$61102 \$52352 \$63624 NWELL PWELL BULK MUX2_X1
X$120071 \$63899 \$62784 \$52352 \$64351 NWELL PWELL BULK MUX2_X1
X$120087 \$63901 \$63355 \$52364 \$63621 NWELL PWELL BULK MUX2_X1
X$120090 \$64554 \$61102 \$52364 \$64887 NWELL PWELL BULK MUX2_X1
X$120094 \$64357 \$61799 \$52364 \$64356 NWELL PWELL BULK MUX2_X1
X$120097 \$64872 \$62784 \$52364 \$64540 NWELL PWELL BULK MUX2_X1
X$120189 \$56178 \$53107 \$52467 \$55485 \$52913 NWELL PWELL BULK OAI22_X4
X$120192 \$52467 \$52913 \$54058 \$55825 NWELL PWELL BULK OAI21_X1
X$120195 \$55075 \$52902 \$52913 \$52467 \$54058 \$55830 NWELL PWELL BULK
+ OAI221_X2
X$120197 \$52467 \$52913 \$55828 NWELL PWELL BULK NOR2_X1
X$120233 \$52479 \$52551 NWELL PWELL BULK INV_X1
X$120244 \$53202 \$52480 \$53728 \$53976 NWELL PWELL BULK OAI21_X1
X$120247 \$53724 \$52480 \$53722 \$53721 NWELL PWELL BULK OAI21_X1
X$120250 \$52898 \$53564 \$53581 \$53572 \$52480 \$52549 NWELL PWELL BULK
+ OAI221_X1
X$120254 \$52893 \$52480 \$53558 \$53128 NWELL PWELL BULK OAI21_X1
X$120263 M1_AXI_AWLEN[3] \$53166 NWELL PWELL BULK CLKBUF_X2
X$120268 M1_AXI_AWLEN[5] \$52862 NWELL PWELL BULK CLKBUF_X2
X$120284 \$61086 \$53989 \$52496 \$60816 NWELL PWELL BULK MUX2_X1
X$120295 M2_AXI_AWADDR[22] \$52512 NWELL PWELL BULK BUF_X1
X$120315 \$69197 \$61102 \$52519 \$68977 NWELL PWELL BULK MUX2_X1
X$120318 \$68402 \$63355 \$52519 \$68603 NWELL PWELL BULK MUX2_X1
X$120321 \$69196 \$62350 \$52519 \$69392 NWELL PWELL BULK MUX2_X1
X$120323 \$67846 \$62784 \$52519 \$68083 NWELL PWELL BULK MUX2_X1
X$120336 \$54013 \$53989 \$52520 \$54284 NWELL PWELL BULK MUX2_X1
X$120342 \$53173 \$53151 \$52522 \$53460 NWELL PWELL BULK MUX2_X1
X$120375 \$54031 \$53989 \$52540 \$54029 NWELL PWELL BULK MUX2_X1
X$120383 \$52547 \$53724 \$53548 \$52545 NWELL PWELL BULK AOI21_X1
X$120386 \$52546 \$53572 NWELL PWELL BULK INV_X1
X$120395 \$54493 \$55060 \$52547 \$55066 NWELL PWELL BULK AOI21_X1
X$120398 \$55047 \$52547 \$54507 \$56115 NWELL PWELL BULK NAND3_X1
X$120400 \$55049 \$53194 \$52547 \$55348 NWELL PWELL BULK AOI21_X1
X$120403 \$52547 \$54507 \$55063 NWELL PWELL BULK NAND2_X1
X$120405 \$52553 \$52551 \$53210 \$52547 NWELL PWELL BULK NOR3_X4
X$120409 \$52547 \$52548 \$52896 \$52897 NWELL PWELL BULK OAI21_X1
X$120411 \$52896 \$52547 \$53200 NWELL PWELL BULK NAND2_X1
X$120424 \$53194 \$53203 \$53208 \$52548 NWELL PWELL BULK AOI21_X1
X$120430 \$53579 \$52551 \$52553 \$53575 NWELL PWELL BULK NOR3_X1
X$120450 \$53221 \$52843 \$52555 \$52905 NWELL PWELL BULK AOI21_X1
X$120452 \$52556 \$52904 \$52558 \$52557 \$52555 NWELL PWELL BULK OAI22_X1
X$120454 \$55811 \$55820 \$56357 \$55470 \$52556 NWELL PWELL BULK AND4_X4
X$120456 \$54529 \$54071 \$52556 \$54957 NWELL PWELL BULK NAND3_X2
X$120458 \$53224 \$52556 \$54525 \$52906 \$52845 \$55486 NWELL PWELL BULK
+ AOI221_X2
X$120460 \$52556 \$54071 \$54529 \$54531 NWELL PWELL BULK AND3_X1
X$120463 \$52556 \$53216 \$52906 \$54900 NWELL PWELL BULK AOI21_X1
X$120467 \$52556 \$52907 \$52557 \$53224 \$53620 NWELL PWELL BULK OAI22_X1
X$120471 \$53748 \$53230 \$52556 \$52912 \$53651 NWELL PWELL BULK NOR4_X1
X$120474 \$53235 \$52556 \$53646 \$52819 NWELL PWELL BULK NAND3_X1
X$120478 \$52902 \$52556 \$52906 \$52560 NWELL PWELL BULK NOR3_X1
X$120481 \$52559 \$52556 \$52561 NWELL PWELL BULK NOR2_X1
X$120498 \$52845 \$52558 \$53748 NWELL PWELL BULK NOR2_X1
X$120501 \$54058 \$52558 \$54065 NWELL PWELL BULK NAND2_X1
X$120503 \$52558 \$52845 \$53224 NWELL PWELL BULK OR2_X2
X$120506 \$52558 \$53216 NWELL PWELL BULK INV_X1
X$120510 \$52558 \$53107 \$52845 \$52559 NWELL PWELL BULK AOI21_X1
X$120525 \$52560 \$53641 \$53929 \$53646 \$53651 \$53756 NWELL PWELL BULK
+ AOI221_X2
X$120545 \$52568 \$52565 \$54347 NWELL PWELL BULK XNOR2_X2
X$120579 \$52594 S0_AXI_WDATA[25] NWELL PWELL BULK BUF_X1
X$120586 \$54720 \$54584 \$52597 NWELL PWELL BULK NOR2_X1
X$120612 \$55141 \$55198 \$52607 NWELL PWELL BULK NOR2_X1
X$120626 \$54636 S0_AXI_WDATA[8] NWELL PWELL BULK BUF_X1
X$120631 \$54153 S0_AXI_WDATA[23] NWELL PWELL BULK BUF_X1
X$120669 \$52640 S1_AXI_WDATA[24] NWELL PWELL BULK BUF_X1
X$120760 \$54469 \$53989 \$52749 \$55270 NWELL PWELL BULK MUX2_X1
X$120831 \$52817 \$53076 NWELL PWELL BULK INV_X1
X$120835 \$52818 S0_AXI_AWLEN[1] NWELL PWELL BULK BUF_X1
X$120843 \$53076 \$52917 \$52916 \$52819 \$52820 NWELL PWELL BULK OAI22_X1
X$120849 \$52821 \$52822 NWELL PWELL BULK INV_X1
X$120854 \$52916 \$52824 \$52822 \$52917 \$53082 NWELL PWELL BULK OAI22_X1
X$120857 \$52914 \$52906 \$52824 NWELL PWELL BULK NAND2_X1
X$120864 \$53604 \$53216 \$52840 NWELL PWELL BULK NAND2_X1
X$120870 \$52902 \$54415 \$52841 \$53954 NWELL PWELL BULK AOI21_X1
X$120873 \$52841 \$54512 \$54902 NWELL PWELL BULK AND2_X1
X$120885 \$53226 \$53230 \$52845 \$54417 NWELL PWELL BULK NOR3_X1
X$120892 \$52845 \$54058 NWELL PWELL BULK INV_X1
X$120898 \$53954 \$52845 \$53601 NWELL PWELL BULK NOR2_X1
X$120900 \$52845 \$53217 \$53107 \$53604 NWELL PWELL BULK OAI21_X1
X$120904 \$52906 \$52845 \$53646 NWELL PWELL BULK NAND2_X1
X$120919 M2_AXI_AWADDR[26] \$53439 NWELL PWELL BULK BUF_X1
X$120928 \$53146 S0_AXI_AWBURST[1] NWELL PWELL BULK BUF_X1
X$120968 \$I176360 \$52864 \$53421 \$53172 NWELL PWELL BULK DFF_X1
X$120976 \$52872 \$53468 \$53466 \$53172 NWELL PWELL BULK DFF_X1
X$120978 \$52875 \$52873 NWELL PWELL BULK INV_X1
X$121002 \$61108 \$61102 \$52879 \$61107 NWELL PWELL BULK MUX2_X1
X$121004 \$62188 \$62451 \$52879 \$62795 NWELL PWELL BULK MUX2_X1
X$121006 \$61800 \$61799 \$52879 \$62472 NWELL PWELL BULK MUX2_X1
X$121008 \$63082 \$62181 \$52879 \$63285 NWELL PWELL BULK MUX2_X1
X$121018 \$53187 \$52884 NWELL PWELL BULK INV_X1
X$121029 \$52888 \$53151 \$53190 \$53716 NWELL PWELL BULK MUX2_X1
X$121039 \$54502 \$52893 \$56350 NWELL PWELL BULK NAND2_X1
X$121041 \$52893 \$54041 \$55062 NWELL PWELL BULK NAND2_X1
X$121043 \$52893 \$54502 \$54489 \$55358 NWELL PWELL BULK AND3_X1
X$121046 \$54379 \$53729 \$54045 \$52893 \$54490 NWELL PWELL BULK NAND4_X1
X$121048 \$53201 \$52893 NWELL PWELL BULK INV_X1
X$121052 \$52895 \$53551 \$52893 \$53196 NWELL PWELL BULK OAI21_X1
X$121076 \$54408 \$53750 \$52902 \$53238 NWELL PWELL BULK OAI21_X1
X$121079 \$55476 \$55070 \$54526 \$54502 \$52902 NWELL PWELL BULK AND4_X2
X$121088 \$52902 \$52906 \$53751 NWELL PWELL BULK NOR2_X1
X$121090 \$52902 \$53625 \$52912 \$52905 \$52914 NWELL PWELL BULK OAI22_X1
X$121103 \$52904 \$53221 \$52906 \$52907 NWELL PWELL BULK MUX2_X1
X$121111 \$55828 \$52906 \$56182 \$55829 NWELL PWELL BULK AOI21_X2
X$121113 \$53222 \$52906 \$54065 \$54066 NWELL PWELL BULK OAI21_X1
X$121115 \$54065 \$52906 \$54954 NWELL PWELL BULK NAND2_X1
X$121117 \$52906 \$54065 \$54533 NWELL PWELL BULK AND2_X1
X$121122 \$60364 \$62819 \$58891 \$62817 \$52906 NWELL PWELL BULK AND4_X4
X$121148 \$53751 \$53743 \$52908 NWELL PWELL BULK NAND2_X1
X$121154 \$52908 \$53625 \$53229 \$53096 NWELL PWELL BULK OAI21_X1
X$121161 \$54071 \$52912 \$52918 \$53929 NWELL PWELL BULK AOI21_X1
X$121164 \$54511 \$52912 \$54920 NWELL PWELL BULK OR2_X1
X$121167 \$54073 \$52912 \$54534 NWELL PWELL BULK NAND2_X1
X$121170 \$54531 \$54954 \$54073 \$52912 \$54961 NWELL PWELL BULK AOI22_X2
X$121173 \$52912 \$52913 NWELL PWELL BULK INV_X2
X$121176 \$52912 \$55489 \$55490 NWELL PWELL BULK NAND2_X2
X$121178 \$55830 \$55485 \$55486 \$52912 \$55489 \$56218 NWELL PWELL BULK
+ AOI221_X2
X$121180 \$54417 \$52912 \$56182 NWELL PWELL BULK NOR2_X1
X$121182 \$52912 \$54417 \$56178 NWELL PWELL BULK OR2_X1
X$121185 \$54079 \$52912 \$54360 NWELL PWELL BULK NAND2_X1
X$121187 \$54536 \$54076 \$52912 \$54077 \$54965 NWELL PWELL BULK OAI22_X1
X$121207 \$52913 \$53243 \$56663 NWELL PWELL BULK NOR2_X1
X$121210 \$52913 \$54390 \$54071 NWELL PWELL BULK AND2_X1
X$121212 \$53620 \$52913 \$53229 NWELL PWELL BULK NAND2_X1
X$121233 \$52916 \$53238 \$53657 \$52917 \$53239 NWELL PWELL BULK OAI22_X1
X$121259 \$52922 \$53254 \$53658 \$52925 NWELL PWELL BULK HA_X1
X$121263 \$I174777 \$53254 \$53255 \$52924 NWELL PWELL BULK DFF_X1
X$121266 \$56686 \$52924 \$I245561 \$54970 NWELL PWELL BULK DFF_X2
X$121269 \$I174260 \$58105 \$58479 \$52924 NWELL PWELL BULK DFF_X1
X$121271 \$I177762 \$57326 \$57583 \$52924 NWELL PWELL BULK DFF_X1
X$121273 \$I178106 \$57617 \$57619 \$52924 NWELL PWELL BULK DFF_X1
X$121275 \$I179275 \$57605 \$57615 \$52924 NWELL PWELL BULK DFF_X1
X$121277 \$I178976 \$58103 \$58745 \$52924 NWELL PWELL BULK DFF_X1
X$121280 \$I175023 \$58924 \$58101 \$52924 NWELL PWELL BULK DFF_X1
X$121282 \$I178998 \$59300 \$59303 \$52924 NWELL PWELL BULK DFF_X1
X$121285 \$I178921 \$56379 \$56530 \$52924 NWELL PWELL BULK DFF_X1
X$121287 \$I175135 \$57324 \$57930 \$52924 NWELL PWELL BULK DFF_X1
X$121290 \$I174297 \$56383 \$57212 \$52924 NWELL PWELL BULK DFF_X1
X$121294 \$I178894 \$57318 \$57320 \$52924 NWELL PWELL BULK DFF_X1
X$121296 \$I174267 \$55500 \$56261 \$52924 NWELL PWELL BULK DFF_X1
X$121299 \$I175358 \$55687 \$56269 \$52924 NWELL PWELL BULK DFF_X1
X$121301 \$I175308 \$55382 \$55381 \$52924 NWELL PWELL BULK DFF_X1
X$121303 \$I176527 \$54554 \$54087 \$52924 NWELL PWELL BULK DFF_X1
X$121305 \$I179153 \$55095 \$55380 \$52924 NWELL PWELL BULK DFF_X1
X$121308 \$I178055 \$55089 \$55497 \$52924 NWELL PWELL BULK DFF_X1
X$121310 \$I175292 \$55091 \$55699 \$52924 NWELL PWELL BULK DFF_X1
X$121312 \$I175150 \$57317 \$57601 \$52924 NWELL PWELL BULK DFF_X1
X$121315 \$54997 \$52924 \$I245540 \$54084 NWELL PWELL BULK DFF_X2
X$121317 \$I178911 \$54982 \$54987 \$52924 NWELL PWELL BULK DFF_X1
X$121320 \$55497 \$52924 \$I245570 \$55692 NWELL PWELL BULK DFF_X2
X$121322 \$I179070 \$60283 \$60286 \$52924 NWELL PWELL BULK DFF_X1
X$121325 \$I178910 \$56684 \$56384 \$52924 NWELL PWELL BULK DFF_X1
X$121327 \$I178906 \$60717 \$61748 \$52924 NWELL PWELL BULK DFF_X1
X$121329 \$I178905 \$60018 \$60020 \$52924 NWELL PWELL BULK DFF_X1
X$121332 \$I176737 \$59926 \$59307 \$52924 NWELL PWELL BULK DFF_X1
X$121365 \$I174799 \$52929 \$52928 \$54313 NWELL PWELL BULK DFF_X1
X$121375 \$52934 \$53586 \$53054 \$53890 NWELL PWELL BULK DFF_X1
X$121377 \$53052 \$52935 \$53585 NWELL PWELL BULK NOR2_X2
X$121380 M2_AXI_WDATA[11] \$52936 NWELL PWELL BULK BUF_X1
X$121445 \$53355 S0_AXI_WDATA[24] NWELL PWELL BULK BUF_X1
X$121480 \$63879 \$63210 \$53000 \$64338 NWELL PWELL BULK MUX2_X1
X$121482 \$63883 \$62784 \$53000 \$64475 NWELL PWELL BULK MUX2_X1
X$121484 \$63063 \$61075 \$53000 \$63548 NWELL PWELL BULK MUX2_X1
X$121486 \$62159 \$62350 \$53000 \$62344 NWELL PWELL BULK MUX2_X1
X$121498 \$64943 \$63530 \$53004 \$64944 NWELL PWELL BULK MUX2_X1
X$121500 \$64687 \$63210 \$53004 \$65127 NWELL PWELL BULK MUX2_X1
X$121502 \$64938 \$63057 \$53004 \$65115 NWELL PWELL BULK MUX2_X1
X$121504 \$64940 \$61075 \$53004 \$65116 NWELL PWELL BULK MUX2_X1
X$121516 \$63066 \$63355 \$53013 \$63563 NWELL PWELL BULK MUX2_X1
X$121518 \$62162 \$62784 \$53013 \$62776 NWELL PWELL BULK MUX2_X1
X$121522 \$63887 \$61075 \$53013 \$64057 NWELL PWELL BULK MUX2_X1
X$121524 \$64481 \$62350 \$53013 \$64826 NWELL PWELL BULK MUX2_X1
X$121532 \$70408 \$61075 \$53014 \$70406 NWELL PWELL BULK MUX2_X1
X$121534 \$69813 \$62181 \$53014 \$70410 NWELL PWELL BULK MUX2_X1
X$121536 \$69981 \$63530 \$53014 \$69814 NWELL PWELL BULK MUX2_X1
X$121538 \$69967 \$63057 \$53014 \$69964 NWELL PWELL BULK MUX2_X1
X$121551 \$58615 \$53989 \$53021 \$58211 NWELL PWELL BULK MUX2_X1
X$121633 \$69398 \$61102 \$53092 \$69767 NWELL PWELL BULK MUX2_X1
X$121635 \$68982 \$61799 \$53092 \$68611 NWELL PWELL BULK MUX2_X1
X$121637 \$68405 \$62451 \$53092 \$68615 NWELL PWELL BULK MUX2_X1
X$121639 \$69205 \$62181 \$53092 \$69203 NWELL PWELL BULK MUX2_X1
X$121658 \$62819 \$60364 \$62817 \$58891 \$53107 NWELL PWELL BULK NAND4_X4
X$121661 \$53107 \$54058 \$53748 \$53743 \$55747 \$55833 NWELL PWELL BULK
+ OAI221_X2
X$121680 \$66271 \$62451 \$53110 \$66273 NWELL PWELL BULK MUX2_X1
X$121682 \$66972 \$62181 \$53110 \$67260 NWELL PWELL BULK MUX2_X1
X$121684 \$66152 \$61102 \$53110 \$66493 NWELL PWELL BULK MUX2_X1
X$121686 \$66698 \$61799 \$53110 \$67255 NWELL PWELL BULK MUX2_X1
X$121713 M2_AXI_AWADDR[28] \$53426 NWELL PWELL BULK BUF_X1
X$121718 \$53462 S0_AXI_AWID[0] NWELL PWELL BULK BUF_X1
X$121723 M2_AXI_AWADDR[3] \$54432 NWELL PWELL BULK BUF_X1
X$121734 \$55778 \$53151 \$55779 \$55630 NWELL PWELL BULK MUX2_X1
X$121736 \$57248 \$53151 \$57250 \$56876 NWELL PWELL BULK MUX2_X1
X$121738 \$61096 \$53151 \$61097 \$61098 NWELL PWELL BULK MUX2_X1
X$121741 \$62433 \$53151 \$62177 \$62440 NWELL PWELL BULK MUX2_X1
X$121743 \$59374 \$53151 \$59378 \$59953 NWELL PWELL BULK MUX2_X1
X$121746 \$58833 \$53151 \$58391 \$58834 NWELL PWELL BULK MUX2_X1
X$121748 \$61304 \$53151 \$61081 \$61956 NWELL PWELL BULK MUX2_X1
X$121750 \$60320 \$53151 \$61315 \$61316 NWELL PWELL BULK MUX2_X1
X$121752 \$53152 \$53151 \$53700 \$53153 NWELL PWELL BULK MUX2_X1
X$121754 \$55975 \$53151 \$56821 \$56312 NWELL PWELL BULK MUX2_X1
X$121757 \$54439 \$53151 \$54441 \$53987 NWELL PWELL BULK MUX2_X1
X$121759 \$56308 \$53151 \$55604 \$56311 NWELL PWELL BULK MUX2_X1
X$121761 \$58615 \$53151 \$58839 \$59046 NWELL PWELL BULK MUX2_X1
X$121763 \$59560 \$53151 \$58392 \$58393 NWELL PWELL BULK MUX2_X1
X$121765 \$54473 \$53151 \$55037 \$55286 NWELL PWELL BULK MUX2_X1
X$121769 \$60101 \$53151 \$60322 \$60825 NWELL PWELL BULK MUX2_X1
X$121771 \$62778 \$53151 \$61791 \$61789 NWELL PWELL BULK MUX2_X1
X$121773 \$59950 \$53151 \$60327 \$58841 NWELL PWELL BULK MUX2_X1
X$121775 \$60323 \$53151 \$61090 \$61341 NWELL PWELL BULK MUX2_X1
X$121780 \$59951 \$53151 \$60329 \$60507 NWELL PWELL BULK MUX2_X1
X$121783 \$59958 \$53151 \$60889 \$60648 NWELL PWELL BULK MUX2_X1
X$121786 \$60877 \$53151 \$59627 \$60646 NWELL PWELL BULK MUX2_X1
X$121789 \$54013 \$53151 \$53709 \$54015 NWELL PWELL BULK MUX2_X1
X$121791 \$54469 \$53151 \$54471 \$55034 NWELL PWELL BULK MUX2_X1
X$121793 \$58645 \$53151 \$57246 \$57850 NWELL PWELL BULK MUX2_X1
X$121795 \$55625 \$53151 \$55442 \$55444 NWELL PWELL BULK MUX2_X1
X$121797 \$56886 \$53151 \$56600 \$56884 NWELL PWELL BULK MUX2_X1
X$121799 \$58037 \$53151 \$57243 \$57681 NWELL PWELL BULK MUX2_X1
X$121802 \$53996 \$53151 \$54446 \$54447 NWELL PWELL BULK MUX2_X1
X$121804 \$54443 \$53151 \$54660 \$53154 NWELL PWELL BULK MUX2_X1
X$121807 \$57236 \$53151 \$56840 \$56313 NWELL PWELL BULK MUX2_X1
X$121809 \$57233 \$53151 \$57426 \$57438 NWELL PWELL BULK MUX2_X1
X$121811 \$55770 \$53151 \$55021 \$54449 NWELL PWELL BULK MUX2_X1
X$121814 \$61086 \$53151 \$60633 \$61088 NWELL PWELL BULK MUX2_X1
X$121816 \$59581 \$53151 \$59580 \$59371 NWELL PWELL BULK MUX2_X1
X$121818 \$57678 \$53151 \$57680 \$57829 NWELL PWELL BULK MUX2_X1
X$121820 \$54181 \$53151 \$54192 \$53988 NWELL PWELL BULK MUX2_X1
X$121822 \$58396 \$53151 \$59594 \$58621 NWELL PWELL BULK MUX2_X1
X$121824 \$57669 \$53151 \$57668 \$57230 NWELL PWELL BULK MUX2_X1
X$121826 \$58829 \$53151 \$59540 \$59362 NWELL PWELL BULK MUX2_X1
X$121828 \$55765 \$53151 \$56307 \$57416 NWELL PWELL BULK MUX2_X1
X$121832 \$55308 \$53151 \$55795 \$56614 NWELL PWELL BULK MUX2_X1
X$121834 \$54031 \$53151 \$54480 \$54357 NWELL PWELL BULK MUX2_X1
X$121923 \$I176359 \$53169 \$53443 \$53172 NWELL PWELL BULK DFF_X1
X$121934 \$I176387 \$53173 \$53455 \$53172 NWELL PWELL BULK DFF_X1
X$121937 \$53481 \$53177 \$53476 \$53172 NWELL PWELL BULK DFF_X1
X$121939 \$I177885 \$56886 \$56888 \$53172 NWELL PWELL BULK DFF_X1
X$121941 \$56055 \$55456 \$55454 \$53172 NWELL PWELL BULK DFF_X1
X$121945 \$54771 \$54768 \$54761 \$53172 NWELL PWELL BULK DFF_X1
X$121948 \$I174620 \$55453 \$56043 \$53172 NWELL PWELL BULK DFF_X1
X$121951 \$I179058 \$53709 \$54294 \$53172 NWELL PWELL BULK DFF_X1
X$121954 \$57255 \$58041 \$58247 \$53172 NWELL PWELL BULK DFF_X1
X$121957 \$59119 \$59117 \$59115 \$53172 NWELL PWELL BULK DFF_X1
X$121959 \$57254 \$57497 \$57688 \$53172 NWELL PWELL BULK DFF_X1
X$121961 \$54773 \$54759 \$54762 \$53172 NWELL PWELL BULK DFF_X1
X$121963 \$I174358 \$54469 \$55270 \$53172 NWELL PWELL BULK DFF_X1
X$121966 \$I179012 \$54473 \$54803 \$53172 NWELL PWELL BULK DFF_X1
X$121968 \$I179014 \$54471 \$55459 \$53172 NWELL PWELL BULK DFF_X1
X$121970 \$54316 \$54307 \$54309 \$53172 NWELL PWELL BULK DFF_X1
X$121972 \$54023 \$54472 \$54024 \$53172 NWELL PWELL BULK DFF_X1
X$121975 \$I174457 \$54459 \$55027 \$53172 NWELL PWELL BULK DFF_X1
X$121977 \$I174491 \$54004 \$54719 \$53172 NWELL PWELL BULK DFF_X1
X$121979 \$I177853 \$53432 \$53892 \$53172 NWELL PWELL BULK DFF_X1
X$121982 \$I174516 \$56600 \$57252 \$53172 NWELL PWELL BULK DFF_X1
X$121984 \$I174394 \$55449 \$55782 \$53172 NWELL PWELL BULK DFF_X1
X$121987 \$I177854 \$55446 \$55635 \$53172 NWELL PWELL BULK DFF_X1
X$121989 \$I174393 \$54744 \$54463 \$53172 NWELL PWELL BULK DFF_X1
X$121991 \$56330 \$56902 \$56904 \$53172 NWELL PWELL BULK DFF_X1
X$121993 \$I177862 \$56324 \$56898 \$53172 NWELL PWELL BULK DFF_X1
X$121995 \$I177869 \$54738 \$54460 \$53172 NWELL PWELL BULK DFF_X1
X$121997 \$I176435 \$54013 \$54284 \$53172 NWELL PWELL BULK DFF_X1
X$122035 \$53513 \$53185 \$53496 \$54021 NWELL PWELL BULK DFF_X1
X$122045 \$53522 \$53950 \$53188 \$54343 NWELL PWELL BULK DFF_X1
X$122053 \$54041 \$53194 \$54489 NWELL PWELL BULK NOR2_X1
X$122055 \$53194 \$54041 \$53201 \$54405 NWELL PWELL BULK OR3_X1
X$122061 \$53194 \$53732 \$53201 \$53564 NWELL PWELL BULK AOI21_X1
X$122063 \$53194 \$53724 NWELL PWELL BULK INV_X1
X$122071 \$53197 \$55066 \$55363 \$56350 \$56569 NWELL PWELL BULK OAI211_X2
X$122074 \$53197 \$55066 \$55067 NWELL PWELL BULK AND2_X1
X$122076 \$55051 \$55052 \$53197 \$55050 NWELL PWELL BULK OAI21_X1
X$122078 \$53197 \$53548 \$53732 NWELL PWELL BULK NOR2_X2
X$122080 \$53197 \$53720 \$54845 \$54840 NWELL PWELL BULK AOI21_X1
X$122082 \$57054 \$53197 NWELL PWELL BULK BUF_X4
X$122085 \$54885 \$55363 \$53197 \$53201 \$54883 NWELL PWELL BULK AOI211_X2
X$122087 \$53551 \$53197 \$53202 \$53577 NWELL PWELL BULK OAI21_X1
X$122089 \$53197 \$53202 \$53203 NWELL PWELL BULK NAND2_X1
X$122092 \$53554 \$53197 \$53202 \$53723 NWELL PWELL BULK OAI21_X1
X$122109 \$53201 \$53200 \$53729 \$53554 NWELL PWELL BULK AOI21_X1
X$122111 \$54489 \$53201 \$55060 NWELL PWELL BULK NOR2_X1
X$122114 \$54041 \$53201 \$55049 NWELL PWELL BULK OR2_X1
X$122117 \$53201 \$53202 \$54878 NWELL PWELL BULK NOR2_X1
X$122120 \$54869 \$53201 \$53732 \$54860 NWELL PWELL BULK AOI21_X1
X$122124 \$55474 \$53201 \$55741 NWELL PWELL BULK NOR2_X1
X$122143 \$54041 \$53202 NWELL PWELL BULK INV_X1
X$122158 \$56347 \$57042 \$55470 \$53208 NWELL PWELL BULK NAND3_X2
X$122160 \$55474 \$55067 \$55068 \$53208 \$55373 \$56354 NWELL PWELL BULK
+ OAI221_X2
X$122163 \$53575 \$53577 \$53208 \$53581 NWELL PWELL BULK NAND3_X1
X$122177 \$55475 \$56370 \$57134 \$53756 \$53210 \$56548 NWELL PWELL BULK
+ OAI221_X1
X$122200 \$53216 \$55471 \$55822 NWELL PWELL BULK NOR2_X1
X$122211 \$53222 \$53221 NWELL PWELL BULK INV_X1
X$122220 \$53226 \$53222 \$53747 \$53625 NWELL PWELL BULK NAND3_X1
X$122224 \$53224 \$54068 \$53754 \$53750 NWELL PWELL BULK AOI21_X1
X$122227 \$53750 \$53751 \$53747 \$53224 \$53934 NWELL PWELL BULK AOI22_X1
X$122230 \$53224 \$54511 \$55078 NWELL PWELL BULK NOR2_X1
X$122253 \$53747 \$53743 \$53230 \$54066 \$54408 NWELL PWELL BULK AND4_X1
X$122269 \$53934 \$53235 NWELL PWELL BULK INV_X1
X$122278 \$53242 \$53657 NWELL PWELL BULK INV_X1
X$122282 \$53243 \$55489 NWELL PWELL BULK INV_X1
X$122287 \$53244 \$56196 \$54537 \$57291 NWELL PWELL BULK NAND3_X2
X$122290 \$53244 \$54537 \$54536 NWELL PWELL BULK NAND2_X2
X$122293 \$53244 \$55716 \$54537 \$56533 NWELL PWELL BULK NAND3_X2
X$122295 \$54537 \$53244 \$54539 NWELL PWELL BULK AND2_X1
X$122325 \$53899 \$53258 \$53623 \$53890 NWELL PWELL BULK DFF_X1
X$122340 M2_AXI_WDATA[24] \$53284 NWELL PWELL BULK BUF_X1
X$122360 \$I177051 \$53292 \$54706 \$54129 NWELL PWELL BULK DFF_X1
X$122368 \$53319 S1_AXI_WDATA[11] NWELL PWELL BULK BUF_X1
X$122373 \$54149 S0_AXI_WDATA[18] NWELL PWELL BULK BUF_X1
X$122395 \$53321 \$53817 \$53813 \$53692 NWELL PWELL BULK DFF_X1
X$122416 \$I176392 \$54192 \$53359 \$53692 NWELL PWELL BULK DFF_X1
X$122426 \$54212 \$53374 \$53839 \$54129 NWELL PWELL BULK DFF_X1
X$122470 \$74383 \$53409 \$73369 \$73370 NWELL PWELL BULK MUX2_X1
X$122472 \$59359 \$53409 \$58828 \$58827 NWELL PWELL BULK MUX2_X1
X$122475 \$61281 \$53409 \$60318 \$60794 NWELL PWELL BULK MUX2_X1
X$122480 \$74108 \$53409 \$73971 \$73604 NWELL PWELL BULK MUX2_X1
X$122483 \$75532 \$53409 \$75963 \$75533 NWELL PWELL BULK MUX2_X1
X$122485 \$74810 \$53409 \$74811 \$75296 NWELL PWELL BULK MUX2_X1
X$122487 \$72730 \$53409 \$73361 \$72734 NWELL PWELL BULK MUX2_X1
X$122489 \$73075 \$53409 \$73076 \$72703 NWELL PWELL BULK MUX2_X1
X$122492 \$74947 \$53409 \$74807 \$73598 NWELL PWELL BULK MUX2_X1
X$122494 \$74936 \$53409 \$74935 \$74369 NWELL PWELL BULK MUX2_X1
X$122497 \$74800 \$53409 \$74520 \$74371 NWELL PWELL BULK MUX2_X1
X$122501 \$75986 \$53409 \$75166 \$75539 NWELL PWELL BULK MUX2_X1
X$122503 \$75678 \$53409 \$75826 \$75163 NWELL PWELL BULK MUX2_X1
X$122506 \$75681 \$53409 \$75980 \$75686 NWELL PWELL BULK MUX2_X1
X$122508 \$74384 \$53409 \$74386 \$73377 NWELL PWELL BULK MUX2_X1
X$122510 \$73084 \$53409 \$73643 \$73660 NWELL PWELL BULK MUX2_X1
X$122514 \$54455 \$53409 \$55026 \$54703 NWELL PWELL BULK MUX2_X1
X$122516 \$54679 \$53409 \$54698 \$53999 NWELL PWELL BULK MUX2_X1
X$122518 \$61300 \$53409 \$60088 \$60464 NWELL PWELL BULK MUX2_X1
X$122520 \$55177 \$53409 \$55179 \$55015 NWELL PWELL BULK MUX2_X1
X$122523 \$54606 \$53409 \$55011 \$54627 NWELL PWELL BULK MUX2_X1
X$122525 \$56319 \$53409 \$56850 \$55773 NWELL PWELL BULK MUX2_X1
X$122528 \$56315 \$53409 \$57462 \$55438 NWELL PWELL BULK MUX2_X1
X$122531 \$57399 \$53409 \$56587 \$56774 NWELL PWELL BULK MUX2_X1
X$122533 \$55922 \$53409 \$56768 \$55921 NWELL PWELL BULK MUX2_X1
X$122535 \$58571 \$53409 \$57663 \$58172 NWELL PWELL BULK MUX2_X1
X$122537 \$73592 \$53409 \$73591 \$73589 NWELL PWELL BULK MUX2_X1
X$122539 \$75639 \$53409 \$75519 \$75643 NWELL PWELL BULK MUX2_X1
X$122541 \$76182 \$53409 \$76331 \$75821 NWELL PWELL BULK MUX2_X1
X$122543 \$75278 \$53409 \$75524 \$75525 NWELL PWELL BULK MUX2_X1
X$122545 \$76178 \$53409 \$75946 \$75818 NWELL PWELL BULK MUX2_X1
X$122547 \$72524 \$53409 \$73073 \$72699 NWELL PWELL BULK MUX2_X1
X$122550 \$75958 \$53409 \$76501 \$75531 NWELL PWELL BULK MUX2_X1
X$122552 \$75284 \$53409 \$75155 \$75287 NWELL PWELL BULK MUX2_X1
X$122555 \$74970 \$53409 \$75162 \$74969 NWELL PWELL BULK MUX2_X1
X$122557 \$73631 \$53409 \$72534 \$73640 NWELL PWELL BULK MUX2_X1
X$122559 \$74128 \$53409 \$73080 \$72533 NWELL PWELL BULK MUX2_X1
X$122561 \$73610 \$53409 \$73357 \$73608 NWELL PWELL BULK MUX2_X1
X$122704 \$67856 \$62181 \$53495 \$68114 NWELL PWELL BULK MUX2_X1
X$122706 \$69781 \$61102 \$53495 \$69213 NWELL PWELL BULK MUX2_X1
X$122708 \$69214 \$62451 \$53495 \$70115 NWELL PWELL BULK MUX2_X1
X$122710 \$69426 \$61799 \$53495 \$69431 NWELL PWELL BULK MUX2_X1
X$122735 \$53516 \$54333 \$54335 \$54343 NWELL PWELL BULK DFF_X1
X$122752 \$55471 \$55811 \$55731 \$53548 NWELL PWELL BULK NOR3_X4
X$122754 \$55338 \$53548 \$53719 \$55049 \$55047 NWELL PWELL BULK OAI22_X1
X$122756 \$55061 \$54041 \$53548 \$54869 NWELL PWELL BULK AOI21_X1
X$122761 \$53548 \$54487 \$54041 \$53719 \$54379 NWELL PWELL BULK OAI22_X1
X$122773 \$53729 \$53551 NWELL PWELL BULK INV_X1
X$122775 \$54494 \$53551 \$54385 NWELL PWELL BULK NAND2_X1
X$122829 \$53585 \$71173 \$76591 \$76719 NWELL PWELL BULK OAI21_X1
X$122832 \$53585 \$71156 \$76941 \$77014 NWELL PWELL BULK OAI21_X1
X$122835 \$53585 \$70514 \$77786 \$77597 NWELL PWELL BULK OAI21_X1
X$122838 \$70521 \$53585 \$77589 \$77594 NWELL PWELL BULK OAI21_X1
X$122941 M2_AXI_AWLEN[2] \$53836 NWELL PWELL BULK BUF_X1
X$122946 \$54196 S0_AXI_AWADDR[3] NWELL PWELL BULK BUF_X1
X$122951 \$I174605 \$57233 \$57672 \$53692 NWELL PWELL BULK DFF_X1
X$122954 \$I179022 \$54443 \$54653 \$53692 NWELL PWELL BULK DFF_X1
X$122958 \$I174608 \$55604 \$55601 \$53692 NWELL PWELL BULK DFF_X1
X$122960 \$I175134 \$54441 \$54440 \$53692 NWELL PWELL BULK DFF_X1
X$122963 \$I175139 \$56308 \$55597 \$53692 NWELL PWELL BULK DFF_X1
X$122965 \$54170 \$53694 \$53818 \$53692 NWELL PWELL BULK DFF_X1
X$122968 \$54177 \$54173 \$53983 \$53692 NWELL PWELL BULK DFF_X1
X$122971 \$I175136 \$54181 \$53984 \$53692 NWELL PWELL BULK DFF_X1
X$122974 \$I175133 \$54439 \$55183 \$53692 NWELL PWELL BULK DFF_X1
X$122976 \$I174356 \$55765 \$56454 \$53692 NWELL PWELL BULK DFF_X1
X$122979 \$55011 \$55563 \$55559 \$53692 NWELL PWELL BULK DFF_X1
X$122982 \$54606 \$54604 \$54431 \$53692 NWELL PWELL BULK DFF_X1
X$122984 \$I174600 \$58391 \$59029 \$53692 NWELL PWELL BULK DFF_X1
X$122986 \$I174280 \$56307 \$56790 \$53692 NWELL PWELL BULK DFF_X1
X$122989 \$I178943 \$57669 \$58193 \$53692 NWELL PWELL BULK DFF_X1
X$122991 \$I178945 \$58829 \$59011 \$53692 NWELL PWELL BULK DFF_X1
X$122993 \$55922 \$56434 \$56435 \$53692 NWELL PWELL BULK DFF_X1
X$122996 \$56768 \$56440 \$56441 \$53692 NWELL PWELL BULK DFF_X1
X$122999 \$57663 \$58165 \$57784 \$53692 NWELL PWELL BULK DFF_X1
X$123001 \$57399 \$57225 \$57387 \$53692 NWELL PWELL BULK DFF_X1
X$123003 \$55177 \$55172 \$55165 \$53692 NWELL PWELL BULK DFF_X1
X$123006 \$55179 \$55577 \$54436 \$53692 NWELL PWELL BULK DFF_X1
X$123008 \$56587 \$57396 \$57394 \$53692 NWELL PWELL BULK DFF_X1
X$123010 \$I174281 \$57668 \$57665 \$53692 NWELL PWELL BULK DFF_X1
X$123013 \$I174258 \$57426 \$57425 \$53692 NWELL PWELL BULK DFF_X1
X$123016 \$58828 \$58586 \$58385 \$53692 NWELL PWELL BULK DFF_X1
X$123019 \$58571 \$58824 \$58583 \$53692 NWELL PWELL BULK DFF_X1
X$123022 \$59359 \$58998 \$59518 \$53692 NWELL PWELL BULK DFF_X1
X$123057 \$62778 \$53989 \$53704 \$63228 NWELL PWELL BULK MUX2_X1
X$123068 \$53707 S0_AXI_AWLEN[4] NWELL PWELL BULK BUF_X1
X$123088 \$54493 \$54490 \$53720 \$55051 NWELL PWELL BULK AOI21_X1
X$123091 \$54848 \$53720 \$54489 \$53729 \$55052 NWELL PWELL BULK AND4_X1
X$123096 \$54840 \$53720 \$54841 \$55338 NWELL PWELL BULK AOI21_X1
X$123113 \$53724 \$55049 \$55809 NWELL PWELL BULK OR2_X1
X$123116 \$53724 \$55049 \$55470 \$55810 NWELL PWELL BULK OAI21_X1
X$123127 \$54502 \$55064 \$53729 NWELL PWELL BULK NAND2_X2
X$123134 \$53729 \$54489 \$54845 NWELL PWELL BULK NAND2_X1
X$123148 \$55820 \$55811 \$55470 \$56357 \$53743 NWELL PWELL BULK NAND4_X4
X$123165 \$54077 \$53747 \$54076 NWELL PWELL BULK NAND2_X1
X$123168 \$53747 \$54532 \$54539 \$54365 NWELL PWELL BULK AOI21_X1
X$123199 \$56197 \$53756 \$55832 \$55492 NWELL PWELL BULK MUX2_X1
X$123202 \$53756 \$54970 \$57303 NWELL PWELL BULK NOR2_X1
X$123205 \$56163 \$53756 \$55086 \$56218 \$57732 NWELL PWELL BULK AND4_X1
X$123208 \$55086 \$53756 \$56218 \$58005 NWELL PWELL BULK NAND3_X4
X$123210 \$53756 \$56218 \$55082 \$55494 NWELL PWELL BULK AND3_X1
X$123213 \$54526 \$53756 \$54961 \$56224 \$55495 NWELL PWELL BULK AND4_X1
X$123215 \$53756 \$55086 \$56196 \$55716 \$56673 NWELL PWELL BULK NOR4_X4
X$123218 \$53756 \$54961 \$56375 NWELL PWELL BULK AND2_X2
X$123221 \$53756 \$55086 \$56218 \$58095 NWELL PWELL BULK AND3_X2
X$123237 \$54299 \$53771 \$54300 \$53890 NWELL PWELL BULK DFF_X1
X$123279 M0_AXI_WDATA[25] \$53790 NWELL PWELL BULK BUF_X1
X$123297 \$54235 \$53791 \$54236 \$54116 NWELL PWELL BULK DFF_X1
X$123305 \$I177044 \$53797 \$53796 \$54129 NWELL PWELL BULK DFF_X1
X$123314 \$I174637 \$53800 \$53798 \$54129 NWELL PWELL BULK DFF_X1
X$123325 \$54148 S0_AXI_WDATA[20] NWELL PWELL BULK BUF_X1
X$123363 \$53855 \$54115 \$54247 NWELL PWELL BULK NOR2_X2
X$123396 \$62719 \$62720 \$62718 \$53890 NWELL PWELL BULK DFF_X1
X$123398 \$62262 \$62729 \$62733 \$53890 NWELL PWELL BULK DFF_X1
X$123400 \$61653 \$60907 \$60905 \$53890 NWELL PWELL BULK DFF_X1
X$123403 \$61665 \$60919 \$60731 \$53890 NWELL PWELL BULK DFF_X1
X$123406 \$60196 \$59761 \$60035 \$53890 NWELL PWELL BULK DFF_X1
X$123409 \$58950 \$59715 \$59719 \$53890 NWELL PWELL BULK DFF_X1
X$123411 \$I176971 \$61226 \$60737 \$53890 NWELL PWELL BULK DFF_X1
X$123414 \$I176076 \$61231 \$60740 \$53890 NWELL PWELL BULK DFF_X1
X$123416 \$59735 \$59737 \$59743 \$53890 NWELL PWELL BULK DFF_X1
X$123418 \$I176996 \$56406 \$57056 \$53890 NWELL PWELL BULK DFF_X1
X$123420 \$I175040 \$55320 \$54563 \$53890 NWELL PWELL BULK DFF_X1
X$123423 \$54291 \$54292 \$54295 \$53890 NWELL PWELL BULK DFF_X1
X$123425 \$I176979 \$56711 \$57514 \$53890 NWELL PWELL BULK DFF_X1
X$123430 \$59190 \$58119 \$58686 \$53890 NWELL PWELL BULK DFF_X1
X$123432 \$59475 \$59202 \$59204 \$53890 NWELL PWELL BULK DFF_X1
X$123435 \$59720 \$58509 \$58673 \$53890 NWELL PWELL BULK DFF_X1
X$123437 \$55518 \$54909 \$55334 \$53890 NWELL PWELL BULK DFF_X1
X$123440 \$54561 \$54891 \$54898 \$53890 NWELL PWELL BULK DFF_X1
X$123442 \$I176093 \$57085 \$57091 \$53890 NWELL PWELL BULK DFF_X1
X$123445 \$I176992 \$57343 \$57526 \$53890 NWELL PWELL BULK DFF_X1
X$123448 \$59780 \$59215 \$59223 \$53890 NWELL PWELL BULK DFF_X1
X$123451 \$I176292 \$56707 \$57060 \$53890 NWELL PWELL BULK DFF_X1
X$123454 \$I176339 \$55655 \$56200 \$53890 NWELL PWELL BULK DFF_X1
X$123456 \$54882 \$55110 \$55652 \$53890 NWELL PWELL BULK DFF_X1
X$123459 \$59790 \$59789 \$59800 \$53890 NWELL PWELL BULK DFF_X1
X$123461 \$I179050 \$57895 \$58114 \$53890 NWELL PWELL BULK DFF_X1
X$123463 \$54304 \$54931 \$54311 \$53890 NWELL PWELL BULK DFF_X1
X$123499 M0_AXI_WDATA[26] \$53895 NWELL PWELL BULK CLKBUF_X2
X$123556 \$53976 \$55046 \$54487 \$54041 NWELL PWELL BULK DFF_X2
X$123563 \$54601 S0_AXI_AWADDR[10] NWELL PWELL BULK BUF_X1
X$123568 S2_AXI_RID[4] \$54434 NWELL PWELL BULK BUF_X2
X$123609 \$57669 \$53989 \$56304 \$58193 NWELL PWELL BULK MUX2_X1
X$123657 \$I176358 \$54455 \$54000 \$55228 NWELL PWELL BULK DFF_X1
X$123675 \$60548 \$60160 \$60903 \$54021 NWELL PWELL BULK DFF_X1
X$123677 \$61443 \$61436 \$60927 \$54021 NWELL PWELL BULK DFF_X1
X$123679 \$59391 \$60166 \$60170 \$54021 NWELL PWELL BULK DFF_X1
X$123682 \$60182 \$60926 \$60558 \$54021 NWELL PWELL BULK DFF_X1
X$123686 \$59666 \$59664 \$59663 \$54021 NWELL PWELL BULK DFF_X1
X$123689 \$60339 \$60338 \$60910 \$54021 NWELL PWELL BULK DFF_X1
X$123692 \$I176341 \$61108 \$61107 \$54021 NWELL PWELL BULK DFF_X1
X$123694 \$I177965 \$61800 \$62472 \$54021 NWELL PWELL BULK DFF_X1
X$123696 \$57879 \$57877 \$57873 \$54021 NWELL PWELL BULK DFF_X1
X$123699 \$59655 \$59135 \$59650 \$54021 NWELL PWELL BULK DFF_X1
X$123701 \$58043 \$58255 \$58252 \$54021 NWELL PWELL BULK DFF_X1
X$123703 \$57691 \$58050 \$58049 \$54021 NWELL PWELL BULK DFF_X1
X$123705 \$59384 \$59120 \$59959 \$54021 NWELL PWELL BULK DFF_X1
X$123708 \$56929 \$56549 \$56547 \$54021 NWELL PWELL BULK DFF_X1
X$123710 \$I178622 \$55037 \$55673 \$54021 NWELL PWELL BULK DFF_X1
X$123713 \$54325 \$54327 \$54317 \$54021 NWELL PWELL BULK DFF_X1
X$123715 \$56602 \$57259 \$56918 \$54021 NWELL PWELL BULK DFF_X1
X$123717 \$58414 \$59676 \$59140 \$54021 NWELL PWELL BULK DFF_X1
X$123719 \$58047 \$58408 \$58683 \$54021 NWELL PWELL BULK DFF_X1
X$123721 \$57887 \$58675 \$57690 \$54021 NWELL PWELL BULK DFF_X1
X$123723 \$56915 \$56542 \$56910 \$54021 NWELL PWELL BULK DFF_X1
X$123725 \$56926 \$56923 \$56922 \$54021 NWELL PWELL BULK DFF_X1
X$123727 \$I177814 \$64149 \$63910 \$54021 NWELL PWELL BULK DFF_X1
X$123729 \$I178652 \$62188 \$62795 \$54021 NWELL PWELL BULK DFF_X1
X$123732 \$I174759 \$63911 \$64161 \$54021 NWELL PWELL BULK DFF_X1
X$123735 \$I177952 \$63082 \$63285 \$54021 NWELL PWELL BULK DFF_X1
X$123739 \$59685 \$59151 \$58853 \$54021 NWELL PWELL BULK DFF_X1
X$123741 \$I177305 \$64166 \$63664 \$54021 NWELL PWELL BULK DFF_X1
X$123743 \$61111 \$61435 \$61434 \$54021 NWELL PWELL BULK DFF_X1
X$123781 \$63911 \$62451 \$54026 \$64161 NWELL PWELL BULK MUX2_X1
X$123783 \$64149 \$62181 \$54026 \$63910 NWELL PWELL BULK MUX2_X1
X$123785 \$63647 \$61799 \$54026 \$63904 NWELL PWELL BULK MUX2_X1
X$123788 \$63907 \$61102 \$54026 \$63374 NWELL PWELL BULK MUX2_X1
X$123799 \$54027 \$54345 \$54342 \$54343 NWELL PWELL BULK DFF_X1
X$123845 \$55809 \$54045 \$57975 \$58068 \$58322 \$57279 NWELL PWELL BULK
+ OAI221_X2
X$123848 \$54045 \$54848 \$54492 NWELL PWELL BULK NAND2_X1
X$123896 \$54539 \$54076 \$54354 NWELL PWELL BULK OR2_X1
X$123899 \$56375 \$56218 \$54077 NWELL PWELL BULK NAND2_X1
X$123911 \$54532 \$54539 \$54079 NWELL PWELL BULK NAND2_X1
X$123915 \$54082 \$55089 \$54544 NWELL PWELL BULK XNOR2_X2
X$123924 \$54084 \$54547 NWELL PWELL BULK INV_X1
X$123927 \$54084 \$54542 \$54543 NWELL PWELL BULK XNOR2_X2
X$123950 \$I176706 \$54094 \$54948 \$54313 NWELL PWELL BULK DFF_X1
X$123958 \$54308 \$54095 \$54310 \$54313 NWELL PWELL BULK DFF_X1
X$123969 M2_AXI_WDATA[8] \$54097 NWELL PWELL BULK CLKBUF_X2
X$123980 \$54104 \$54107 \$55291 NWELL PWELL BULK NOR2_X2
X$123999 \$I174319 \$54811 \$55874 \$54116 NWELL PWELL BULK DFF_X1
X$124001 \$55881 \$55623 \$55536 \$54116 NWELL PWELL BULK DFF_X1
X$124003 \$I174346 \$55124 \$55122 \$54116 NWELL PWELL BULK DFF_X1
X$124006 \$54118 \$55238 \$55246 \$54116 NWELL PWELL BULK DFF_X1
X$124008 \$I176910 \$59674 \$60162 \$54116 NWELL PWELL BULK DFF_X1
X$124010 \$I176487 \$60435 \$60431 \$54116 NWELL PWELL BULK DFF_X1
X$124012 \$56721 \$56722 \$56941 \$54116 NWELL PWELL BULK DFF_X1
X$124015 \$I174279 \$58525 \$58629 \$54116 NWELL PWELL BULK DFF_X1
X$124018 \$58240 \$58520 \$58653 \$54116 NWELL PWELL BULK DFF_X1
X$124021 \$I177391 \$58957 \$59701 \$54116 NWELL PWELL BULK DFF_X1
X$124023 \$58654 \$58960 \$59131 \$54116 NWELL PWELL BULK DFF_X1
X$124026 \$I174624 \$58127 \$57754 \$54116 NWELL PWELL BULK DFF_X1
X$124028 \$I174628 \$58517 \$58668 \$54116 NWELL PWELL BULK DFF_X1
X$124030 \$59127 \$59487 \$59654 \$54116 NWELL PWELL BULK DFF_X1
X$124032 \$56924 \$56916 \$56917 \$54116 NWELL PWELL BULK DFF_X1
X$124034 \$58961 \$58238 \$58648 \$54116 NWELL PWELL BULK DFF_X1
X$124036 \$57496 \$56948 \$56947 \$54116 NWELL PWELL BULK DFF_X1
X$124038 \$I177198 \$58513 \$58953 \$54116 NWELL PWELL BULK DFF_X1
X$124040 \$I177232 \$56727 \$56472 \$54116 NWELL PWELL BULK DFF_X1
X$124043 \$I176067 \$56890 \$56461 \$54116 NWELL PWELL BULK DFF_X1
X$124046 \$I177258 \$55893 \$56046 \$54116 NWELL PWELL BULK DFF_X1
X$124048 \$I176069 \$55131 \$55889 \$54116 NWELL PWELL BULK DFF_X1
X$124050 \$I175830 \$58967 \$59089 \$54116 NWELL PWELL BULK DFF_X1
X$124052 \$I177100 \$57761 \$58225 \$54116 NWELL PWELL BULK DFF_X1
X$124055 \$I177059 \$56896 \$57361 \$54116 NWELL PWELL BULK DFF_X1
X$124057 \$I176057 \$58528 \$57759 \$54116 NWELL PWELL BULK DFF_X1
X$124059 \$I175998 \$57364 \$57835 \$54116 NWELL PWELL BULK DFF_X1
X$124061 \$I177063 \$58139 \$58963 \$54116 NWELL PWELL BULK DFF_X1
X$124063 \$I176908 \$61487 \$62583 \$54116 NWELL PWELL BULK DFF_X1
X$124110 \$I177077 \$56750 \$56773 \$54129 NWELL PWELL BULK DFF_X1
X$124113 \$56422 \$55614 \$56001 \$54129 NWELL PWELL BULK DFF_X1
X$124116 \$56868 \$55611 \$55898 \$54129 NWELL PWELL BULK DFF_X1
X$124119 \$56807 \$57376 \$57445 \$54129 NWELL PWELL BULK DFF_X1
X$124122 \$I177073 \$58573 \$58581 \$54129 NWELL PWELL BULK DFF_X1
X$124125 \$I177083 \$59502 \$59501 \$54129 NWELL PWELL BULK DFF_X1
X$124127 \$I175978 \$56749 \$56789 \$54129 NWELL PWELL BULK DFF_X1
X$124130 \$I177065 \$57773 \$57768 \$54129 NWELL PWELL BULK DFF_X1
X$124133 \$58219 \$58606 \$58218 \$54129 NWELL PWELL BULK DFF_X1
X$124135 \$56878 \$56730 \$56879 \$54129 NWELL PWELL BULK DFF_X1
X$124137 \$56733 \$57366 \$57826 \$54129 NWELL PWELL BULK DFF_X1
X$124140 \$57368 \$57369 \$57470 \$54129 NWELL PWELL BULK DFF_X1
X$124144 \$I177084 \$55550 \$55144 \$54129 NWELL PWELL BULK DFF_X1
X$124147 \$55203 \$55138 \$55206 \$54129 NWELL PWELL BULK DFF_X1
X$124149 \$55970 \$55901 \$55988 \$54129 NWELL PWELL BULK DFF_X1
X$124153 \$54211 \$54686 \$54688 \$54129 NWELL PWELL BULK DFF_X1
X$124156 \$I177173 \$54138 \$54209 \$54129 NWELL PWELL BULK DFF_X1
X$124158 \$I175473 \$54649 \$55193 \$54129 NWELL PWELL BULK DFF_X1
X$124161 \$56820 \$57452 \$57454 \$54129 NWELL PWELL BULK DFF_X1
X$124164 \$57466 \$56839 \$56738 \$54129 NWELL PWELL BULK DFF_X1
X$124167 \$56852 \$56853 \$56864 \$54129 NWELL PWELL BULK DFF_X1
X$124170 \$I177209 \$55551 \$55176 \$54129 NWELL PWELL BULK DFF_X1
X$124173 \$56448 \$55907 \$55941 \$54129 NWELL PWELL BULK DFF_X1
X$124175 \$I175391 \$54143 \$54140 \$54129 NWELL PWELL BULK DFF_X1
X$124178 \$I175369 \$55552 \$55149 \$54129 NWELL PWELL BULK DFF_X1
X$124180 \$I177207 \$54147 \$54634 \$54129 NWELL PWELL BULK DFF_X1
X$124205 \$55905 \$55961 \$54135 NWELL PWELL BULK NOR2_X1
X$124225 \$55953 \$55906 \$54142 NWELL PWELL BULK NOR2_X1
X$124349 \$54247 \$70514 \$82984 \$82675 NWELL PWELL BULK OAI21_X1
X$124351 \$70521 \$54247 \$82989 \$83233 NWELL PWELL BULK OAI21_X1
X$124353 \$54247 \$71156 \$81918 \$82283 NWELL PWELL BULK OAI21_X1
X$124356 \$54247 \$71173 \$82287 \$82286 NWELL PWELL BULK OAI21_X1
X$124366 \$55629 \$55532 \$54254 NWELL PWELL BULK NOR2_X1
X$124453 \$64223 \$63774 \$63775 \$54313 NWELL PWELL BULK DFF_X1
X$124455 \$64613 \$64863 \$64614 \$54313 NWELL PWELL BULK DFF_X1
X$124457 \$64766 \$65412 \$64860 \$54313 NWELL PWELL BULK DFF_X1
X$124459 \$I179135 \$62762 \$62255 \$54313 NWELL PWELL BULK DFF_X1
X$124462 \$I175248 \$59468 \$60211 \$54313 NWELL PWELL BULK DFF_X1
X$124464 \$59232 \$60204 \$60509 \$54313 NWELL PWELL BULK DFF_X1
X$124467 \$61218 \$60730 \$61681 \$54313 NWELL PWELL BULK DFF_X1
X$124471 \$I178245 \$59466 \$58936 \$54313 NWELL PWELL BULK DFF_X1
X$124474 \$I178305 \$56698 \$57129 \$54313 NWELL PWELL BULK DFF_X1
X$124476 \$I178271 \$57339 \$57553 \$54313 NWELL PWELL BULK DFF_X1
X$124478 \$61219 \$62258 \$62752 \$54313 NWELL PWELL BULK DFF_X1
X$124480 \$I177726 \$58935 \$59862 \$54313 NWELL PWELL BULK DFF_X1
X$124483 \$I175711 \$56697 \$57153 \$54313 NWELL PWELL BULK DFF_X1
X$124488 \$I179137 \$59262 \$59877 \$54313 NWELL PWELL BULK DFF_X1
X$124491 \$59237 \$59240 \$58704 \$54313 NWELL PWELL BULK DFF_X1
X$124493 \$I178248 \$56703 \$56511 \$54313 NWELL PWELL BULK DFF_X1
X$124495 \$I179310 \$61879 \$61712 \$54313 NWELL PWELL BULK DFF_X1
X$124497 \$I176554 \$61216 \$61215 \$54313 NWELL PWELL BULK DFF_X1
X$124500 \$I174247 \$61876 \$62036 \$54313 NWELL PWELL BULK DFF_X1
X$124502 \$64221 \$64220 \$64226 \$54313 NWELL PWELL BULK DFF_X1
X$124504 \$I179307 \$60217 \$59463 \$54313 NWELL PWELL BULK DFF_X1
X$124506 \$55657 \$55107 \$56223 \$54313 NWELL PWELL BULK DFF_X1
X$124509 \$I176731 \$58497 \$59257 \$54313 NWELL PWELL BULK DFF_X1
X$124513 \$I174572 \$60411 \$60936 \$54313 NWELL PWELL BULK DFF_X1
X$124517 \$I176596 \$55104 \$56235 \$54313 NWELL PWELL BULK DFF_X1
X$124519 \$I178254 \$55103 \$55663 \$54313 NWELL PWELL BULK DFF_X1
X$124576 \$I176825 \$58866 \$59710 \$54343 NWELL PWELL BULK DFF_X1
X$124580 \$I177316 \$58418 \$58283 \$54343 NWELL PWELL BULK DFF_X1
X$124583 \$I177362 \$59393 \$59691 \$54343 NWELL PWELL BULK DFF_X1
X$124585 \$I174944 \$58417 \$58708 \$54343 NWELL PWELL BULK DFF_X1
X$124588 \$I177367 \$56613 \$57521 \$54343 NWELL PWELL BULK DFF_X1
X$124590 \$58701 \$58054 \$58052 \$54343 NWELL PWELL BULK DFF_X1
X$124592 \$57697 \$57901 \$57903 \$54343 NWELL PWELL BULK DFF_X1
X$124594 \$I177388 \$59183 \$59699 \$54343 NWELL PWELL BULK DFF_X1
X$124596 \$I177385 \$58864 \$58861 \$54343 NWELL PWELL BULK DFF_X1
X$124599 \$I174697 \$58056 \$57914 \$54343 NWELL PWELL BULK DFF_X1
X$124601 \$55676 \$55298 \$54474 \$54343 NWELL PWELL BULK DFF_X1
X$124604 \$55788 \$56069 \$56065 \$54343 NWELL PWELL BULK DFF_X1
X$124606 \$55461 \$55300 \$54475 \$54343 NWELL PWELL BULK DFF_X1
X$124609 \$I174744 \$55308 \$55310 \$54343 NWELL PWELL BULK DFF_X1
X$124615 \$I174933 \$62190 \$62798 \$54343 NWELL PWELL BULK DFF_X1
X$124617 \$I174994 \$61453 \$61113 \$54343 NWELL PWELL BULK DFF_X1
X$124619 \$59688 \$59686 \$59684 \$54343 NWELL PWELL BULK DFF_X1
X$124621 \$I177338 \$62189 \$62499 \$54343 NWELL PWELL BULK DFF_X1
X$124624 \$I174917 \$61805 \$62031 \$54343 NWELL PWELL BULK DFF_X1
X$124626 \$I174924 \$62494 \$61803 \$54343 NWELL PWELL BULK DFF_X1
X$124629 \$I174879 \$62797 \$63294 \$54343 NWELL PWELL BULK DFF_X1
X$124631 \$I177315 \$59703 \$60198 \$54343 NWELL PWELL BULK DFF_X1
X$124634 \$56337 \$56938 \$56609 \$54343 NWELL PWELL BULK DFF_X1
X$124637 \$I177319 \$56612 \$56611 \$54343 NWELL PWELL BULK DFF_X1
X$124640 \$I176759 \$59395 \$60194 \$54343 NWELL PWELL BULK DFF_X1
X$124643 \$I174997 \$61114 \$60656 \$54343 NWELL PWELL BULK DFF_X1
X$124645 \$I177310 \$60659 \$60951 \$54343 NWELL PWELL BULK DFF_X1
X$124675 \$54347 \$54544 \$54543 \$54526 NWELL PWELL BULK NAND3_X4
X$124678 \$54543 \$54347 \$54544 \$55475 NWELL PWELL BULK AND3_X4
X$124701 \$54385 \$55804 \$56116 \$55708 \$55701 NWELL PWELL BULK OAI22_X1
X$124712 \$54492 \$54860 \$54493 \$54405 \$54494 NWELL PWELL BULK OAI22_X1
X$124732 S2_AXI_RID[2] \$56439 NWELL PWELL BULK BUF_X2
X$124737 S2_AXI_RID[5] \$55167 NWELL PWELL BULK BUF_X2
X$124742 M2_AXI_AWADDR[20] \$54450 NWELL PWELL BULK BUF_X1
X$124747 \$54604 \$54680 \$54432 \$54431 NWELL PWELL BULK MUX2_X1
X$124761 \$58418 \$57931 \$54434 \$58283 NWELL PWELL BULK MUX2_X1
X$124764 \$54434 \$58426 \$59183 \$59699 NWELL PWELL BULK MUX2_X1
X$124766 \$54434 \$58860 \$58417 \$58708 NWELL PWELL BULK MUX2_X1
X$124769 \$58056 \$57920 \$54434 \$57914 NWELL PWELL BULK MUX2_X1
X$124820 \$54679 \$54680 \$54450 \$54693 NWELL PWELL BULK MUX2_X1
X$124845 \$67852 \$61102 \$54467 \$68408 NWELL PWELL BULK MUX2_X1
X$124848 \$69207 \$62451 \$54467 \$69415 NWELL PWELL BULK MUX2_X1
X$124851 \$69209 \$62181 \$54467 \$69772 NWELL PWELL BULK MUX2_X1
X$124853 \$68108 \$61799 \$54467 \$68628 NWELL PWELL BULK MUX2_X1
X$124889 \$54487 \$54841 NWELL PWELL BULK INV_X1
X$124905 \$54493 \$54507 NWELL PWELL BULK INV_X4
X$124907 \$57281 \$57280 \$54493 \$57575 NWELL PWELL BULK MUX2_X1
X$124913 \$57960 \$55046 \$54848 \$54493 NWELL PWELL BULK DFF_X2
X$124916 \$54493 \$55471 \$58322 NWELL PWELL BULK NOR2_X1
X$124927 \$55693 \$56256 \$55692 \$54502 NWELL PWELL BULK MUX2_X2
X$124930 \$54502 \$58473 \$57733 \$58894 NWELL PWELL BULK OR3_X4
X$124937 \$54526 \$55070 \$55476 \$54502 \$55374 NWELL PWELL BULK NAND4_X2
X$124941 \$54502 \$54526 \$55070 \$55078 \$54529 NWELL PWELL BULK NAND4_X2
X$124944 \$54522 \$54502 \$54526 \$55070 \$54525 NWELL PWELL BULK NAND4_X1
X$124946 \$55070 \$54526 \$54502 \$54522 \$55747 NWELL PWELL BULK AND4_X1
X$124949 \$54886 \$54502 \$54507 \$54885 NWELL PWELL BULK NAND3_X1
X$124952 \$55741 \$54502 \$55064 \$55373 NWELL PWELL BULK NAND3_X1
X$124955 \$57733 \$58473 \$54502 \$59430 NWELL PWELL BULK NOR3_X4
X$124958 \$58097 \$54502 \$55475 \$55070 \$58756 NWELL PWELL BULK NOR4_X1
X$124974 \$54507 \$55703 \$55726 NWELL PWELL BULK NOR2_X1
X$124976 \$56629 \$54507 \$57715 NWELL PWELL BULK NOR2_X1
X$124978 \$56632 \$54507 \$56636 NWELL PWELL BULK NOR2_X1
X$124980 \$56629 \$54507 \$57987 \$56631 \$57585 \$55823 NWELL PWELL BULK
+ OAI221_X2
X$124983 \$54507 \$56632 \$56629 \$56633 NWELL PWELL BULK AOI21_X1
X$124988 \$55818 \$54507 \$55474 NWELL PWELL BULK NOR2_X1
X$124991 \$57278 \$54507 \$57274 NWELL PWELL BULK NOR2_X1
X$124995 \$57274 \$54507 \$57273 \$57958 NWELL PWELL BULK AOI21_X1
X$124997 \$56569 \$56137 \$55818 \$57289 \$54507 NWELL PWELL BULK OAI22_X4
X$125015 \$54511 \$55476 NWELL PWELL BULK INV_X1
X$125017 \$58449 \$54511 \$58889 NWELL PWELL BULK NOR2_X1
X$125025 \$54511 \$55070 \$55475 \$55363 NWELL PWELL BULK OR3_X2
X$125027 \$55475 \$55070 \$54511 \$55064 NWELL PWELL BULK NOR3_X2
X$125030 \$55475 \$54511 \$59994 NWELL PWELL BULK NOR2_X2
X$125059 \$54526 \$58454 \$58889 \$58890 NWELL PWELL BULK AND3_X1
X$125062 \$58889 \$54526 \$59428 NWELL PWELL BULK NAND2_X1
X$125065 \$58889 \$58454 \$54526 \$59305 NWELL PWELL BULK NAND3_X2
X$125068 \$54526 \$55476 \$60366 NWELL PWELL BULK NAND2_X1
X$125077 \$59999 \$54526 \$60379 NWELL PWELL BULK NAND2_X1
X$125099 \$55832 \$56548 \$54532 NWELL PWELL BULK OR2_X1
X$125108 \$54534 \$54957 \$54533 \$55086 NWELL PWELL BULK OAI21_X4
X$125110 \$54957 \$54533 \$55410 \$54534 \$55082 NWELL PWELL BULK OAI22_X1
X$125120 \$58078 \$58077 \$54536 \$57134 \$58089 \$58023 NWELL PWELL BULK
+ OAI221_X2
X$125126 \$54970 \$54537 NWELL PWELL BULK INV_X1
X$125166 \$77679 \$54550 \$77686 \$77681 NWELL PWELL BULK MUX2_X1
X$125168 \$77139 \$54550 \$76482 \$76553 NWELL PWELL BULK MUX2_X1
X$125171 \$79780 \$54550 \$80405 \$80029 NWELL PWELL BULK MUX2_X1
X$125174 \$77481 \$54550 \$77483 \$77661 NWELL PWELL BULK MUX2_X1
X$125178 \$80079 \$54550 \$80258 \$80081 NWELL PWELL BULK MUX2_X1
X$125180 \$79146 \$54550 \$79151 \$79145 NWELL PWELL BULK MUX2_X1
X$125182 \$78920 \$54550 \$78570 \$78563 NWELL PWELL BULK MUX2_X1
X$125185 \$74436 \$54550 \$75782 \$76144 NWELL PWELL BULK MUX2_X1
X$125187 \$75187 \$54550 \$76713 \$76712 NWELL PWELL BULK MUX2_X1
X$125189 \$71133 \$54550 \$73045 \$73036 NWELL PWELL BULK MUX2_X1
X$125200 \$69149 \$54550 \$69150 \$68440 NWELL PWELL BULK MUX2_X1
X$125203 \$76910 \$54550 \$77129 \$77135 NWELL PWELL BULK MUX2_X1
X$125206 \$80137 \$54550 \$79405 \$80025 NWELL PWELL BULK MUX2_X1
X$125209 \$78342 \$54550 \$78610 \$78612 NWELL PWELL BULK MUX2_X1
X$125211 \$77142 \$54550 \$77198 \$77430 NWELL PWELL BULK MUX2_X1
X$125219 \$75774 \$54550 \$74874 \$75511 NWELL PWELL BULK MUX2_X1
X$125222 \$73889 \$54550 \$75143 \$75503 NWELL PWELL BULK MUX2_X1
X$125225 \$63126 \$54550 \$64681 \$64678 NWELL PWELL BULK MUX2_X1
X$125228 \$63419 \$54550 \$64666 \$64668 NWELL PWELL BULK MUX2_X1
X$125233 \$66992 \$54550 \$67382 \$67380 NWELL PWELL BULK MUX2_X1
X$125235 \$74300 \$54550 \$74747 \$75118 NWELL PWELL BULK MUX2_X1
X$125238 \$71521 \$54550 \$73127 \$72959 NWELL PWELL BULK MUX2_X1
X$125240 \$75199 \$54550 \$75791 \$75795 NWELL PWELL BULK MUX2_X1
X$125242 \$70217 \$54550 \$71057 \$71396 NWELL PWELL BULK MUX2_X1
X$125244 \$70244 \$54550 \$70466 \$70741 NWELL PWELL BULK MUX2_X1
X$125246 \$75858 \$54550 \$76224 \$76223 NWELL PWELL BULK MUX2_X1
X$125248 \$77175 \$54550 \$77181 \$77637 NWELL PWELL BULK MUX2_X1
X$125250 \$79771 \$54550 \$79977 \$80332 NWELL PWELL BULK MUX2_X1
X$125252 \$69035 \$54550 \$70453 \$70677 NWELL PWELL BULK MUX2_X1
X$125254 \$76198 \$54550 \$76026 \$76197 NWELL PWELL BULK MUX2_X1
X$125256 \$80385 \$54550 \$80032 \$80380 NWELL PWELL BULK MUX2_X1
X$125258 \$79157 \$54550 \$79910 \$79908 NWELL PWELL BULK MUX2_X1
X$125260 \$77712 \$54550 \$77841 \$77840 NWELL PWELL BULK MUX2_X1
X$125263 \$76686 \$54550 \$76210 \$76694 NWELL PWELL BULK MUX2_X1
X$125266 \$80093 \$54550 \$80311 \$80308 NWELL PWELL BULK MUX2_X1
X$125342 \$54554 \$55095 \$56277 NWELL PWELL BULK NOR2_X1
X$125348 \$55848 \$55678 \$55504 \$54555 NWELL PWELL BULK AOI21_X1
X$125351 \$I175245 \$55678 \$54556 \$55096 NWELL PWELL BULK DFF_X1
X$125369 M2_AXI_WDATA[2] \$54566 NWELL PWELL BULK CLKBUF_X2
X$125399 \$55543 \$54585 \$55214 NWELL PWELL BULK NOR2_X2
X$125411 \$54650 M1_AXI_RID[0] NWELL PWELL BULK BUF_X1
X$125420 M2_AXI_WDATA[20] \$55163 NWELL PWELL BULK BUF_X1
X$125464 \$63851 \$63134 \$63955 \$54650 NWELL PWELL BULK MUX2_X2
X$125495 \$74384 \$54680 \$72706 \$74814 NWELL PWELL BULK MUX2_X1
X$125498 \$58824 \$54680 \$58380 \$58583 NWELL PWELL BULK MUX2_X1
X$125503 \$56315 \$54680 \$55763 \$56596 NWELL PWELL BULK MUX2_X1
X$125507 \$61290 \$54680 \$59358 \$61278 NWELL PWELL BULK MUX2_X1
X$125510 \$74965 \$54680 \$72530 \$74967 NWELL PWELL BULK MUX2_X1
X$125513 \$73631 \$54680 \$71595 \$74132 NWELL PWELL BULK MUX2_X1
X$125515 \$72730 \$54680 \$72207 \$73614 NWELL PWELL BULK MUX2_X1
X$125517 \$75975 \$54680 \$75274 \$75680 NWELL PWELL BULK MUX2_X1
X$125519 \$56434 \$54680 \$55757 \$56435 NWELL PWELL BULK MUX2_X1
X$125521 \$73350 \$54680 \$73199 \$73207 NWELL PWELL BULK MUX2_X1
X$125523 \$74103 \$54680 \$72353 \$74106 NWELL PWELL BULK MUX2_X1
X$125526 \$74938 \$54680 \$72689 \$75265 NWELL PWELL BULK MUX2_X1
X$125529 \$75939 \$54680 \$75636 \$75937 NWELL PWELL BULK MUX2_X1
X$125531 \$76320 \$54680 \$74798 \$76179 NWELL PWELL BULK MUX2_X1
X$125533 \$73072 \$54680 \$72204 \$72520 NWELL PWELL BULK MUX2_X1
X$125535 \$75153 \$54680 \$72521 \$75659 NWELL PWELL BULK MUX2_X1
X$125538 \$74810 \$54680 \$74121 \$74960 NWELL PWELL BULK MUX2_X1
X$125676 M2_AXI_AWLEN[1] \$54809 NWELL PWELL BULK CLKBUF_X2
X$125712 \$54848 \$57278 \$57575 \$57276 NWELL PWELL BULK OAI21_X1
X$125719 \$54848 \$58069 \$57281 NWELL PWELL BULK NAND2_X1
X$125746 \$57570 \$54878 \$57715 \$57716 \$57589 \$57082 NWELL PWELL BULK
+ AOI221_X2
X$125756 \$55824 \$55726 \$54883 \$56132 NWELL PWELL BULK AOI21_X4
X$125819 \$56218 \$54961 \$56664 \$57308 \$57307 NWELL PWELL BULK NAND4_X1
X$125844 \$54970 \$55682 \$57220 NWELL PWELL BULK XNOR2_X1
X$125857 \$54982 \$55496 \$55500 \$56256 NWELL PWELL BULK MUX2_X1
X$125872 \$55920 S0_AXI_AWADDR[11] NWELL PWELL BULK BUF_X1
X$125877 \$55279 S0_AXI_AWLEN[6] NWELL PWELL BULK BUF_X1
X$125895 \$I176371 \$55026 \$55232 \$55228 NWELL PWELL BULK DFF_X1
X$125921 \$56632 \$56123 \$56576 \$55046 NWELL PWELL BULK DFF_X1
X$125925 \$I178774 \$59754 \$59248 \$55046 NWELL PWELL BULK DFF_X1
X$125928 \$61522 \$55046 \$55471 \$I240830 NWELL PWELL BULK DFF_X2
X$125930 \$56629 \$57015 \$57006 \$55046 NWELL PWELL BULK DFF_X1
X$125933 \$I177234 \$57707 \$57272 \$55046 NWELL PWELL BULK DFF_X1
X$125935 \$58064 \$55046 \$I245667 \$58420 NWELL PWELL BULK DFF_X2
X$125938 \$I177285 \$57708 \$58875 \$55046 NWELL PWELL BULK DFF_X1
X$125941 \$I177237 \$58065 \$58064 \$55046 NWELL PWELL BULK DFF_X1
X$125943 \$I175227 \$56625 \$56622 \$55046 NWELL PWELL BULK DFF_X1
X$125946 \$I177228 \$58871 \$59400 \$55046 NWELL PWELL BULK DFF_X1
X$125949 \$I175093 \$55802 \$56103 \$55046 NWELL PWELL BULK DFF_X1
X$125952 \$55703 \$55466 \$55701 \$55046 NWELL PWELL BULK DFF_X1
X$125954 \$55467 \$55046 \$55818 \$55468 NWELL PWELL BULK DFF_X2
X$125956 \$56995 \$55046 \$I245668 \$57269 NWELL PWELL BULK DFF_X2
X$125958 \$57929 \$55046 \$I245666 \$58433 NWELL PWELL BULK DFF_X2
X$125960 \$59400 \$55046 \$I245617 \$58422 NWELL PWELL BULK DFF_X2
X$125963 \$I174416 \$59716 \$59717 \$55046 NWELL PWELL BULK DFF_X1
X$125965 \$I174736 \$62208 \$62541 \$55046 NWELL PWELL BULK DFF_X1
X$125967 \$I175033 \$64377 \$63925 \$55046 NWELL PWELL BULK DFF_X1
X$125970 \$I176812 \$61504 \$60666 \$55046 NWELL PWELL BULK DFF_X1
X$125973 \$60220 \$59402 \$59401 \$55046 NWELL PWELL BULK DFF_X1
X$125976 \$I174606 \$58874 \$60594 \$55046 NWELL PWELL BULK DFF_X1
X$125979 \$61127 \$55046 \$I245645 \$58077 NWELL PWELL BULK DFF_X2
X$125982 \$I175114 \$63093 \$63713 \$55046 NWELL PWELL BULK DFF_X1
X$125985 \$I176866 \$63706 \$63383 \$55046 NWELL PWELL BULK DFF_X1
X$125987 \$I174526 \$63387 \$64928 \$55046 NWELL PWELL BULK DFF_X1
X$125989 \$63011 \$62205 \$62204 \$55046 NWELL PWELL BULK DFF_X1
X$125991 \$63383 \$55046 \$I245630 \$63098 NWELL PWELL BULK DFF_X2
X$126034 \$55050 \$55804 \$55469 \$55708 \$55467 NWELL PWELL BULK OAI22_X1
X$126046 \$55060 \$55061 NWELL PWELL BULK INV_X1
X$126054 \$56347 \$57028 \$56571 \$55061 \$57054 NWELL PWELL BULK AOI22_X4
X$126058 \$55731 \$55811 \$55471 \$55062 \$56137 NWELL PWELL BULK NOR4_X2
X$126062 \$57054 \$56631 \$55062 \$57710 NWELL PWELL BULK OAI21_X1
X$126065 \$55731 \$57279 \$55062 \$57585 NWELL PWELL BULK OR3_X1
X$126068 \$55062 \$55474 \$55068 NWELL PWELL BULK OR2_X1
X$126072 \$55063 \$55064 \$55358 \$55727 NWELL PWELL BULK AOI21_X2
X$126091 \$57953 \$58099 \$55692 \$55070 NWELL PWELL BULK MUX2_X2
X$126109 \$56357 \$55820 \$55811 \$55822 \$55075 NWELL PWELL BULK AND4_X1
X$126119 \$55082 \$57134 NWELL PWELL BULK INV_X1
X$126133 \$55716 \$55086 \$56228 NWELL PWELL BULK NOR2_X1
X$126146 \$56379 \$55496 \$55091 \$55693 NWELL PWELL BULK MUX2_X1
X$126158 \$56687 \$57329 \$57213 \$55096 NWELL PWELL BULK DFF_X1
X$126162 \$55502 \$56287 \$55847 \$55096 NWELL PWELL BULK DFF_X1
X$126164 \$I174837 \$57739 \$58723 \$55096 NWELL PWELL BULK DFF_X1
X$126166 \$I175523 \$56693 \$57204 \$55096 NWELL PWELL BULK DFF_X1
X$126168 \$I178239 \$55099 \$55097 \$55096 NWELL PWELL BULK DFF_X1
X$126171 \$58491 \$55096 \$I245554 \$59253 NWELL PWELL BULK DFF_X2
X$126173 \$I178360 \$58113 \$58491 \$55096 NWELL PWELL BULK DFF_X1
X$126176 \$57913 \$55096 \$I245528 \$57909 NWELL PWELL BULK DFF_X2
X$126178 \$55365 \$55510 \$55509 \$55096 NWELL PWELL BULK DFF_X1
X$126181 \$I175378 \$63961 \$64404 \$55096 NWELL PWELL BULK DFF_X1
X$126184 \$I174831 \$63027 \$63280 \$55096 NWELL PWELL BULK DFF_X1
X$126187 \$61769 \$60721 \$61763 \$55096 NWELL PWELL BULK DFF_X1
X$126189 \$63858 \$55096 \$I245550 \$63442 NWELL PWELL BULK DFF_X2
X$126191 \$I178127 \$64283 \$64402 \$55096 NWELL PWELL BULK DFF_X1
X$126193 \$I178128 \$63958 \$63862 \$55096 NWELL PWELL BULK DFF_X1
X$126195 \$64404 \$55096 \$I245703 \$63955 NWELL PWELL BULK DFF_X2
X$126198 \$I178082 \$59889 \$60027 \$55096 NWELL PWELL BULK DFF_X1
X$126201 \$I175947 \$60521 \$60945 \$55096 NWELL PWELL BULK DFF_X1
X$126204 \$I178375 \$56296 \$55849 \$55096 NWELL PWELL BULK DFF_X1
X$126207 \$57334 \$55096 \$I245695 \$58937 NWELL PWELL BULK DFF_X2
X$126210 \$I178373 \$57559 \$57334 \$55096 NWELL PWELL BULK DFF_X1
X$126212 \$I178077 \$60405 \$60022 \$55096 NWELL PWELL BULK DFF_X1
X$126215 \$I175986 \$62244 \$63031 \$55096 NWELL PWELL BULK DFF_X1
X$126218 \$60251 \$55096 \$I245558 \$58279 NWELL PWELL BULK DFF_X2
X$126220 \$I175958 \$61774 \$61207 \$55096 NWELL PWELL BULK DFF_X1
X$126222 \$I178442 \$60236 \$60026 \$55096 NWELL PWELL BULK DFF_X1
X$126225 \$I178071 \$64756 \$64753 \$55096 NWELL PWELL BULK DFF_X1
X$126229 \$I174781 \$61867 \$62242 \$55096 NWELL PWELL BULK DFF_X1
X$126232 \$60021 \$55096 \$I245730 \$58094 NWELL PWELL BULK DFF_X2
X$126261 \$55512 \$55099 \$55361 NWELL PWELL BULK NAND2_X1
X$126263 \$55510 \$55099 \$56264 \$56244 NWELL PWELL BULK HA_X1
X$126265 \$55853 \$55099 \$57333 NWELL PWELL BULK NAND2_X1
X$126267 \$55853 \$55100 \$56242 NWELL PWELL BULK NAND2_X1
X$126270 \$55100 \$55669 \$55101 NWELL PWELL BULK XNOR2_X1
X$126322 M0_AXI_WDATA[20] \$55590 NWELL PWELL BULK BUF_X1
X$126350 \$55167 \$58860 \$58864 \$58861 NWELL PWELL BULK MUX2_X1
X$126353 \$55167 \$58426 \$58866 \$59710 NWELL PWELL BULK MUX2_X1
X$126356 \$58057 \$57931 \$55167 \$58292 NWELL PWELL BULK MUX2_X1
X$126359 \$58058 \$57920 \$55167 \$57923 NWELL PWELL BULK MUX2_X1
X$126387 \$68011 \$63530 \$55185 \$67832 NWELL PWELL BULK MUX2_X1
X$126391 \$69184 \$61075 \$55185 \$70001 NWELL PWELL BULK MUX2_X1
X$126393 \$69182 \$63057 \$55185 \$69344 NWELL PWELL BULK MUX2_X1
X$126396 \$68767 \$63210 \$55185 \$69185 NWELL PWELL BULK MUX2_X1
X$126427 \$70521 \$55214 \$73174 \$72784 NWELL PWELL BULK OAI21_X1
X$126429 \$55214 \$70514 \$73656 \$73214 NWELL PWELL BULK OAI21_X1
X$126431 \$55214 \$71156 \$73519 \$74147 NWELL PWELL BULK OAI21_X1
X$126433 \$55214 \$71173 \$74080 \$74142 NWELL PWELL BULK OAI21_X1
X$126444 \$I176432 \$59378 \$59615 \$55228 NWELL PWELL BULK DFF_X1
X$126446 \$I177881 \$55442 \$56870 \$55228 NWELL PWELL BULK DFF_X1
X$126448 \$I177882 \$55778 \$56514 \$55228 NWELL PWELL BULK DFF_X1
X$126450 \$58401 \$58039 \$58038 \$55228 NWELL PWELL BULK DFF_X1
X$126452 \$58403 \$59381 \$59631 \$55228 NWELL PWELL BULK DFF_X1
X$126454 \$59107 \$58243 \$59099 \$55228 NWELL PWELL BULK DFF_X1
X$126457 \$I177873 \$60889 \$60647 \$55228 NWELL PWELL BULK DFF_X1
X$126460 \$I174477 \$62433 \$61992 \$55228 NWELL PWELL BULK DFF_X1
X$126463 \$I177872 \$59958 \$60145 \$55228 NWELL PWELL BULK DFF_X1
X$126465 \$I176433 \$59627 \$59379 \$55228 NWELL PWELL BULK DFF_X1
X$126467 \$I177848 \$55779 \$55445 \$55228 NWELL PWELL BULK DFF_X1
X$126469 \$I177843 \$57246 \$57852 \$55228 NWELL PWELL BULK DFF_X1
X$126471 \$I174503 \$57248 \$56873 \$55228 NWELL PWELL BULK DFF_X1
X$126475 \$I174383 \$55625 \$56007 \$55228 NWELL PWELL BULK DFF_X1
X$126477 \$58040 \$59095 \$59091 \$55228 NWELL PWELL BULK DFF_X1
X$126480 \$I174514 \$57250 \$57484 \$55228 NWELL PWELL BULK DFF_X1
X$126483 \$I177842 \$59374 \$59602 \$55228 NWELL PWELL BULK DFF_X1
X$126485 \$I177895 \$58037 \$58635 \$55228 NWELL PWELL BULK DFF_X1
X$126488 \$I174481 \$57243 \$57840 \$55228 NWELL PWELL BULK DFF_X1
X$126490 \$I174454 \$58645 \$58646 \$55228 NWELL PWELL BULK DFF_X1
X$126496 \$I175165 \$56319 \$56501 \$55228 NWELL PWELL BULK DFF_X1
X$126498 \$I175111 \$56840 \$57676 \$55228 NWELL PWELL BULK DFF_X1
X$126501 \$I176419 \$56850 \$56858 \$55228 NWELL PWELL BULK DFF_X1
X$126504 \$I179001 \$57678 \$58215 \$55228 NWELL PWELL BULK DFF_X1
X$126507 \$I175105 \$56315 \$56596 \$55228 NWELL PWELL BULK DFF_X1
X$126510 \$I179004 \$57462 \$57461 \$55228 NWELL PWELL BULK DFF_X1
X$126512 \$I178005 \$57680 \$58223 \$55228 NWELL PWELL BULK DFF_X1
X$126515 \$I177955 \$58396 \$59071 \$55228 NWELL PWELL BULK DFF_X1
X$126576 \$70521 \$55291 \$83546 \$83524 NWELL PWELL BULK OAI21_X1
X$126579 \$55291 \$71173 \$82684 \$82280 NWELL PWELL BULK OAI21_X1
X$126582 \$55291 \$70514 \$83229 \$83250 NWELL PWELL BULK OAI21_X1
X$126585 \$55291 \$71156 \$82697 \$82997 NWELL PWELL BULK OAI21_X1
X$126599 \$56401 \$56402 \$55297 NWELL PWELL BULK NOR2_X1
X$126658 \$55332 S0_AXI_AWLEN[0] NWELL PWELL BULK BUF_X1
X$126671 \$55342 S1_AXI_WLAST NWELL PWELL BULK BUF_X1
X$126676 \$55471 \$55348 \$55811 \$55731 \$56132 NWELL PWELL BULK OR4_X2
X$126692 \$55363 \$56350 \$57589 NWELL PWELL BULK OR2_X1
X$126694 \$56350 \$55363 \$56631 NWELL PWELL BULK NOR2_X1
X$126703 \$55853 \$55365 \$56267 NWELL PWELL BULK NAND2_X1
X$126710 \$55366 \$56688 NWELL PWELL BULK INV_X4
X$126713 \$55366 \$56687 \$57569 NWELL PWELL BULK NOR2_X1
X$126716 \$55366 \$58279 \$58490 \$58933 NWELL PWELL BULK OR3_X4
X$126718 \$57909 \$58279 \$55366 \$58931 NWELL PWELL BULK NOR3_X4
X$126720 \$55366 \$55853 \$55504 \$I241636 NWELL PWELL BULK HA_X1
X$126735 \$55825 \$55374 \$56167 \$56189 NWELL PWELL BULK AOI21_X2
X$126750 \$55687 \$55382 \$55692 \$55684 NWELL PWELL BULK NOR3_X1
X$126754 \$58439 \$57705 \$57706 \$55410 NWELL PWELL BULK AND3_X2
X$126756 \$55820 \$55410 \$58877 NWELL PWELL BULK OR2_X4
X$126759 \$55820 \$55410 \$58075 NWELL PWELL BULK NOR2_X2
X$126764 \$58901 \$55410 \$58902 NWELL PWELL BULK NOR2_X1
X$126779 \$55435 S0_AXI_AWADDR[28] NWELL PWELL BULK BUF_X1
X$126784 M2_AXI_AWADDR[13] \$55582 NWELL PWELL BULK BUF_X1
X$126834 \$55466 \$56116 NWELL PWELL BULK INV_X1
X$126841 \$55468 \$55469 NWELL PWELL BULK INV_X1
X$126850 \$55471 \$55470 NWELL PWELL BULK INV_X4
X$126853 \$55811 \$59285 \$55470 \$59283 \$59799 NWELL PWELL BULK NAND4_X2
X$126858 \$55811 \$59871 \$55470 \$61147 \$61823 NWELL PWELL BULK NAND4_X2
X$126860 \$55470 \$59285 \$55811 \$59283 \$59987 NWELL PWELL BULK AND4_X1
X$126862 \$55470 \$55811 \$60683 NWELL PWELL BULK AND2_X1
X$126865 \$55811 \$55470 \$60359 NWELL PWELL BULK NAND2_X2
X$126892 \$58449 \$55471 \$60677 NWELL PWELL BULK NOR2_X1
X$126894 \$59985 \$58877 \$57042 \$55471 \$60285 NWELL PWELL BULK NOR4_X1
X$126897 \$55471 \$57042 \$58877 \$59985 \$60593 NWELL PWELL BULK OR4_X1
X$126918 \$55475 \$55824 \$55823 \$56653 NWELL PWELL BULK OR3_X1
X$126921 \$56641 \$56354 \$55475 \$55824 \$57294 NWELL PWELL BULK OAI22_X1
X$126923 \$55823 \$55824 \$55475 \$57598 NWELL PWELL BULK NOR3_X2
X$126929 \$55475 \$60000 \$59341 \$59852 NWELL PWELL BULK OAI21_X1
X$126934 \$60274 \$59414 \$55475 \$59431 NWELL PWELL BULK NOR3_X1
X$126937 \$60008 \$56641 \$60310 \$55475 \$59443 \$60302 NWELL PWELL BULK
+ OAI221_X2
X$126963 \$59871 \$58881 \$55476 \$60274 NWELL PWELL BULK NAND3_X1
X$126973 \$55833 \$55490 \$56224 \$55830 \$55485 NWELL PWELL BULK AOI22_X4
X$126983 \$55486 \$56663 \$56370 NWELL PWELL BULK NOR2_X2
X$126985 \$55486 \$56663 \$56665 \$56373 NWELL PWELL BULK NOR3_X1
X$127001 \$56649 \$55833 \$55490 \$56668 NWELL PWELL BULK AOI21_X1
X$127004 \$55833 \$55490 \$55716 NWELL PWELL BULK NAND2_X2
X$127016 \$72962 \$55496 \$72961 \$72964 NWELL PWELL BULK MUX2_X1
X$127019 \$71878 \$55496 \$71124 \$72267 NWELL PWELL BULK MUX2_X1
X$127021 \$71530 \$55496 \$71772 \$71531 NWELL PWELL BULK MUX2_X1
X$127023 \$74870 \$55496 \$74771 \$74776 NWELL PWELL BULK MUX2_X1
X$127025 \$59912 \$55496 \$58924 \$59914 NWELL PWELL BULK MUX2_X1
X$127028 \$57617 \$55496 \$57605 \$58099 NWELL PWELL BULK MUX2_X1
X$127031 \$57317 \$55496 \$57318 \$57737 NWELL PWELL BULK MUX2_X1
X$127034 \$64398 \$55496 \$64898 \$64743 NWELL PWELL BULK MUX2_X1
X$127036 \$64671 \$55496 \$64397 \$64676 NWELL PWELL BULK MUX2_X1
X$127038 \$63421 \$55496 \$63422 \$63816 NWELL PWELL BULK MUX2_X1
X$127040 \$63124 \$55496 \$62829 \$63426 NWELL PWELL BULK MUX2_X1
X$127043 \$71512 \$55496 \$71513 \$69858 NWELL PWELL BULK MUX2_X1
X$127045 \$67371 \$55496 \$67372 \$66996 NWELL PWELL BULK MUX2_X1
X$127048 \$67384 \$55496 \$68262 \$67376 NWELL PWELL BULK MUX2_X1
X$127051 \$68828 \$55496 \$69156 \$69252 NWELL PWELL BULK MUX2_X1
X$127054 \$56675 \$55496 \$56378 \$57953 NWELL PWELL BULK MUX2_X1
X$127056 \$59447 \$55496 \$59906 \$59444 NWELL PWELL BULK MUX2_X1
X$127062 \$76174 \$55496 \$76853 \$75877 NWELL PWELL BULK MUX2_X1
X$127064 \$75125 \$55496 \$75121 \$75504 NWELL PWELL BULK MUX2_X1
X$127067 \$73947 \$55496 \$73958 \$73133 NWELL PWELL BULK MUX2_X1
X$127070 \$74349 \$55496 \$73899 \$73452 NWELL PWELL BULK MUX2_X1
X$127072 \$55496 \$55845 \$58108 \$57315 NWELL PWELL BULK OAI21_X1
X$127076 \$57927 \$58301 \$55496 \$58108 NWELL PWELL BULK OAI21_X1
X$127079 \$58103 \$55496 \$58105 \$57937 NWELL PWELL BULK MUX2_X1
X$127084 \$60717 \$55496 \$60718 \$60399 NWELL PWELL BULK MUX2_X1
X$127086 \$59926 \$55496 \$59300 \$60400 NWELL PWELL BULK MUX2_X1
X$127089 \$60283 \$55496 \$60018 \$60985 NWELL PWELL BULK MUX2_X1
X$127092 \$59919 \$55496 \$58925 \$60396 NWELL PWELL BULK MUX2_X1
X$127094 \$71052 \$55496 \$69867 \$70469 NWELL PWELL BULK MUX2_X1
X$127096 \$70312 \$55496 \$70307 \$69251 NWELL PWELL BULK MUX2_X1
X$127098 \$55496 \$73857 NWELL PWELL BULK BUF_X16
X$127101 \$70460 \$55496 \$69627 \$70219 NWELL PWELL BULK MUX2_X1
X$127104 \$69773 \$55496 \$69863 \$69865 NWELL PWELL BULK MUX2_X1
X$127106 \$68416 \$55496 \$69041 \$68668 NWELL PWELL BULK MUX2_X1
X$127108 \$70453 \$55496 \$69612 \$69613 NWELL PWELL BULK MUX2_X1
X$127166 \$79780 \$55498 \$80714 \$80709 NWELL PWELL BULK MUX2_X1
X$127168 \$77481 \$55498 \$78672 \$78945 NWELL PWELL BULK MUX2_X1
X$127172 \$73889 \$55498 \$73897 \$73450 NWELL PWELL BULK MUX2_X1
X$127174 \$74436 \$55498 \$73874 \$73863 NWELL PWELL BULK MUX2_X1
X$127176 \$75858 \$55498 \$76101 \$76099 NWELL PWELL BULK MUX2_X1
X$127179 \$80079 \$55498 \$81610 \$81601 NWELL PWELL BULK MUX2_X1
X$127182 \$77712 \$55498 \$78160 \$77835 NWELL PWELL BULK MUX2_X1
X$127184 \$79146 \$55498 \$79141 \$79138 NWELL PWELL BULK MUX2_X1
X$127186 \$69035 \$55498 \$69041 \$69038 NWELL PWELL BULK MUX2_X1
X$127189 \$80093 \$55498 \$80092 \$80630 NWELL PWELL BULK MUX2_X1
X$127192 \$79157 \$55498 \$80613 \$80274 NWELL PWELL BULK MUX2_X1
X$127195 \$79771 \$55498 \$80452 \$80658 NWELL PWELL BULK MUX2_X1
X$127200 \$63126 \$55498 \$62830 \$63047 NWELL PWELL BULK MUX2_X1
X$127206 \$70244 \$55498 \$70733 \$70250 NWELL PWELL BULK MUX2_X1
X$127209 \$75187 \$55498 \$75776 \$76058 NWELL PWELL BULK MUX2_X1
X$127212 \$71521 \$55498 \$70824 \$71429 NWELL PWELL BULK MUX2_X1
X$127218 \$80385 \$55498 \$81404 \$81130 NWELL PWELL BULK MUX2_X1
X$127220 \$80137 \$55498 \$80819 \$80488 NWELL PWELL BULK MUX2_X1
X$127223 \$71133 \$55498 \$72172 \$72173 NWELL PWELL BULK MUX2_X1
X$127228 \$63419 \$55498 \$62828 \$63048 NWELL PWELL BULK MUX2_X1
X$127230 \$69149 \$55498 \$69759 \$69758 NWELL PWELL BULK MUX2_X1
X$127232 \$66992 \$55498 \$66995 \$66993 NWELL PWELL BULK MUX2_X1
X$127236 \$74300 \$55498 \$73853 \$74305 NWELL PWELL BULK MUX2_X1
X$127238 \$70217 \$55498 \$69778 \$70206 NWELL PWELL BULK MUX2_X1
X$127242 \$75199 \$55498 \$76785 \$76782 NWELL PWELL BULK MUX2_X1
X$127245 \$77139 \$55498 \$77676 \$77485 NWELL PWELL BULK MUX2_X1
X$127248 \$77175 \$55498 \$77920 \$77630 NWELL PWELL BULK MUX2_X1
X$127252 \$75774 \$55498 \$77121 \$77125 NWELL PWELL BULK MUX2_X1
X$127254 \$76910 \$55498 \$77448 \$77449 NWELL PWELL BULK MUX2_X1
X$127257 \$77679 \$55498 \$77421 \$77195 NWELL PWELL BULK MUX2_X1
X$127259 \$78920 \$55498 \$79992 \$79996 NWELL PWELL BULK MUX2_X1
X$127261 \$76198 \$55498 \$77584 \$77290 NWELL PWELL BULK MUX2_X1
X$127264 \$77142 \$55498 \$78003 \$78001 NWELL PWELL BULK MUX2_X1
X$127267 \$76686 \$55498 \$76522 \$77032 NWELL PWELL BULK MUX2_X1
X$127269 \$78342 \$55498 \$78947 \$78952 NWELL PWELL BULK MUX2_X1
X$127347 \$58102 \$55501 NWELL PWELL BULK BUF_X8
X$127364 \$55502 \$55504 \$56287 \$55683 NWELL PWELL BULK MUX2_X1
X$127366 \$56387 \$56386 \$55503 NWELL PWELL BULK XOR2_X1
X$127368 \$55503 \$55504 \$55682 NWELL PWELL BULK NOR2_X1
X$127378 \$55504 \$55507 \$55848 NWELL PWELL BULK NOR2_X1
X$127381 \$55678 \$56386 \$55507 \$56291 \$56287 NWELL PWELL BULK FA_X1
X$127385 \$55512 \$55510 \$56294 NWELL PWELL BULK NAND2_X1
X$127389 \$55853 \$55510 \$55854 NWELL PWELL BULK NAND2_X1
X$127395 \$55853 \$56264 \$55511 NWELL PWELL BULK NAND2_X1
X$127397 \$56688 \$55512 \$I241151 \$56387 NWELL PWELL BULK HA_X1
X$127401 \$55512 \$58113 \$58493 NWELL PWELL BULK NAND2_X1
X$127403 \$55512 \$55853 NWELL PWELL BULK INV_X2
X$127407 \$55512 \$57559 \$57181 NWELL PWELL BULK NAND2_X1
X$127409 \$55512 \$57180 \$56391 NWELL PWELL BULK NAND2_X1
X$127454 M0_AXI_WDATA[24] \$55542 NWELL PWELL BULK BUF_X1
X$127461 \$56730 \$58123 \$55542 \$56879 NWELL PWELL BULK MUX2_X1
X$127486 \$55938 S1_AXI_WDATA[17] NWELL PWELL BULK BUF_X1
X$127491 \$55936 M2_AXI_RLAST NWELL PWELL BULK BUF_X1
X$127519 \$58520 \$58123 \$55590 \$58653 NWELL PWELL BULK MUX2_X1
X$127614 \$55853 \$56244 \$55669 NWELL PWELL BULK NAND2_X1
X$127638 \$55684 \$55692 \$56277 \$55845 NWELL PWELL BULK AOI21_X1
X$127661 \$58917 \$55692 \$59444 \$56649 NWELL PWELL BULK OAI21_X2
X$127664 \$57953 \$55692 \$57733 NWELL PWELL BULK NOR2_X2
X$127667 \$59871 \$60306 \$58917 \$59444 \$55692 \$60299 NWELL PWELL BULK
+ OAI221_X1
X$127669 \$56684 \$57326 \$55692 \$57927 NWELL PWELL BULK NOR3_X1
X$127676 \$55692 \$58106 NWELL PWELL BULK BUF_X16
X$127705 \$56115 \$55804 \$56118 \$55708 \$56576 NWELL PWELL BULK OAI22_X1
X$127711 \$57709 \$55804 \$56626 \$55708 \$57006 NWELL PWELL BULK OAI22_X1
X$127732 \$56633 \$56571 \$55727 \$57062 NWELL PWELL BULK AOI21_X2
X$127735 \$56353 \$56636 \$55727 \$56571 NWELL PWELL BULK AOI21_X4
X$127740 \$55820 \$56357 \$55731 NWELL PWELL BULK NAND2_X2
X$127749 \$57279 \$55731 \$57570 NWELL PWELL BULK NOR2_X1
X$127751 \$57279 \$57054 \$55731 \$57716 NWELL PWELL BULK NOR3_X1
X$127753 \$55731 \$57054 \$57279 \$57987 NWELL PWELL BULK OR3_X1
X$127767 S2_AXI_RID[6] \$56782 NWELL PWELL BULK BUF_X2
X$127772 M2_AXI_AWADDR[18] \$55763 NWELL PWELL BULK BUF_X1
X$127777 M2_AXI_AWSIZE[2] \$55757 NWELL PWELL BULK BUF_X1
X$127847 \$55801 \$60216 \$I241141 \$60979 NWELL PWELL BULK HA_X1
X$127849 \$58062 \$58433 \$55801 \$58860 NWELL PWELL BULK NAND3_X4
X$127851 \$57269 \$58433 \$55801 \$58426 NWELL PWELL BULK NAND3_X4
X$127854 \$55801 \$55802 \$56996 NWELL PWELL BULK NAND2_X1
X$127857 \$55801 \$56341 \$56099 NWELL PWELL BULK NAND2_X1
X$127859 \$55801 \$56977 \$56978 NWELL PWELL BULK NAND2_X1
X$127861 \$56997 \$55801 NWELL PWELL BULK INV_X4
X$127863 \$55801 \$56618 \$57701 NWELL PWELL BULK NAND2_X1
X$127866 \$55801 \$56621 \$56344 NWELL PWELL BULK NAND2_X1
X$127869 \$55801 \$56620 \$56340 NWELL PWELL BULK NAND2_X1
X$127880 \$55802 \$56099 \$56102 NWELL PWELL BULK XOR2_X1
X$127897 \$55810 \$55811 \$57028 NWELL PWELL BULK NOR2_X1
X$127906 \$55822 \$55811 \$55820 \$56357 \$56167 NWELL PWELL BULK NAND4_X1
X$127911 \$55811 \$60677 \$59285 \$59778 \$61024 NWELL PWELL BULK OAI211_X2
X$127918 \$58302 \$59194 \$58422 \$55811 NWELL PWELL BULK MUX2_X2
X$127920 \$61180 \$58877 \$55811 \$61524 NWELL PWELL BULK NOR3_X1
X$127958 \$56357 \$55820 \$56347 NWELL PWELL BULK AND2_X1
X$127967 \$58290 \$58859 \$58422 \$55820 NWELL PWELL BULK MUX2_X2
X$127985 \$56648 \$55823 \$55824 \$57609 NWELL PWELL BULK OR3_X4
X$127990 \$56163 \$55823 \$55824 \$56362 NWELL PWELL BULK NAND3_X1
X$127992 \$56357 \$55824 \$55823 \$56645 NWELL PWELL BULK AND3_X1
X$127994 \$55824 \$55823 \$56649 \$56650 NWELL PWELL BULK OR3_X1
X$127999 \$55823 \$55824 \$56357 \$56655 NWELL PWELL BULK NAND3_X1
X$128002 \$55823 \$56357 \$58078 NWELL PWELL BULK NAND2_X1
X$128004 \$56649 \$55823 \$55824 \$58456 NWELL PWELL BULK NOR3_X1
X$128006 \$55823 \$55824 \$56356 \$58351 NWELL PWELL BULK NAND3_X4
X$128009 \$55824 \$55823 \$56163 \$57722 NWELL PWELL BULK AND3_X1
X$128028 \$55824 \$57082 \$56356 \$57280 NWELL PWELL BULK AND3_X1
X$128032 \$55824 \$57289 \$57062 \$58084 NWELL PWELL BULK AND3_X2
X$128035 \$57289 \$55824 \$57062 \$57301 NWELL PWELL BULK NAND3_X4
X$128038 \$55824 \$57082 \$56354 \$57613 NWELL PWELL BULK AND3_X2
X$128044 \$57082 \$55824 \$56354 \$56660 NWELL PWELL BULK NAND3_X4
X$128048 \$55824 \$58077 \$58768 NWELL PWELL BULK NOR2_X1
X$128073 \$56189 \$55829 \$56196 NWELL PWELL BULK NOR2_X4
X$128076 \$56189 \$55829 \$56641 \$55832 NWELL PWELL BULK NOR3_X1
X$128149 \$56083 \$55873 \$56412 NWELL PWELL BULK NOR2_X2
X$128166 \$57358 \$57359 \$55885 NWELL PWELL BULK NOR2_X1
X$128183 \$55890 S0_AXI_WDATA[31] NWELL PWELL BULK BUF_X1
X$128223 \$57774 S0_AXI_WDATA[0] NWELL PWELL BULK BUF_X1
X$128228 \$56429 S0_AXI_WDATA[1] NWELL PWELL BULK BUF_X1
X$128251 \$58709 \$59250 \$58937 \$55936 NWELL PWELL BULK MUX2_X2
X$128345 \$56997 \$56621 \$56095 NWELL PWELL BULK NAND2_X1
X$128376 \$56123 \$56118 NWELL PWELL BULK INV_X1
X$128399 \$70437 \$70631 \$64987 \$56163 NWELL PWELL BULK MUX2_X2
X$128406 \$58893 \$56163 \$59841 NWELL PWELL BULK NAND2_X1
X$128439 \$56668 \$56196 \$56373 \$57167 NWELL PWELL BULK MUX2_X1
X$128446 \$56370 \$56196 \$56375 \$57625 NWELL PWELL BULK NAND3_X4
X$128480 \$56224 \$56375 \$60311 NWELL PWELL BULK NAND2_X4
X$128482 \$56375 \$56224 \$60387 NWELL PWELL BULK AND2_X2
X$128493 \$57167 \$56375 \$57732 \$56673 \$57308 \$56234 NWELL PWELL BULK
+ AOI221_X2
X$128535 \$56387 \$56291 NWELL PWELL BULK INV_X1
X$128543 \$56693 \$56688 \$56296 \$57197 NWELL PWELL BULK MUX2_X1
X$128545 \$56296 \$56690 \$56297 NWELL PWELL BULK XNOR2_X1
X$128553 S2_AXI_RID[1] \$56583 NWELL PWELL BULK BUF_X2
X$128558 M2_AXI_AWID[1] \$56604 NWELL PWELL BULK BUF_X1
X$128613 \$56618 \$56621 \$56620 \$56341 NWELL PWELL BULK HA_X1
X$128616 \$56997 \$57269 \$56343 NWELL PWELL BULK NAND2_X1
X$128640 \$56660 \$56353 \$58025 NWELL PWELL BULK NOR2_X4
X$128642 \$56354 \$56353 \$56648 NWELL PWELL BULK NAND2_X1
X$128647 \$56353 \$56354 \$56356 NWELL PWELL BULK AND2_X2
X$128651 \$56353 \$58077 \$57728 NWELL PWELL BULK NOR2_X1
X$128676 \$56356 \$57598 \$56645 \$57298 NWELL PWELL BULK OAI21_X4
X$128680 \$56356 \$57722 \$58456 \$57723 NWELL PWELL BULK OAI21_X2
X$128684 \$57705 \$58439 \$57706 \$56357 NWELL PWELL BULK NAND3_X4
X$128692 \$58893 \$56357 \$59318 NWELL PWELL BULK NAND2_X1
X$128716 \$56648 \$56362 \$56650 \$56556 NWELL PWELL BULK AOI21_X1
X$128732 \$57732 \$56375 \$57167 \$57976 NWELL PWELL BULK AOI21_X1
X$128758 \$56383 \$57324 \$58481 \$58301 NWELL PWELL BULK NOR3_X1
X$128800 \$56412 \$71173 \$74070 \$74196 NWELL PWELL BULK OAI21_X1
X$128802 \$56412 \$71156 \$74921 \$74982 NWELL PWELL BULK OAI21_X1
X$128804 \$56412 \$70514 \$75339 \$75620 NWELL PWELL BULK OAI21_X1
X$128806 \$70521 \$56412 \$75623 \$76056 NWELL PWELL BULK OAI21_X1
X$128823 M2_AXI_WDATA[17] \$56424 NWELL PWELL BULK BUF_X1
X$128844 M2_AXI_WDATA[23] \$56740 NWELL PWELL BULK BUF_X1
X$128863 \$56439 \$58426 \$63089 \$63381 NWELL PWELL BULK MUX2_X1
X$128865 \$62520 \$57920 \$56439 \$62519 NWELL PWELL BULK MUX2_X1
X$128867 \$56439 \$58860 \$64209 \$64375 NWELL PWELL BULK MUX2_X1
X$128869 \$62807 \$57931 \$56439 \$62999 NWELL PWELL BULK MUX2_X1
X$128890 \$56783 S0_AXI_AWADDR[24] NWELL PWELL BULK BUF_X1
X$128916 \$70414 \$61075 \$56474 \$70903 NWELL PWELL BULK MUX2_X1
X$128918 \$70015 \$63057 \$56474 \$70019 NWELL PWELL BULK MUX2_X1
X$128921 \$69186 \$63210 \$56474 \$68930 NWELL PWELL BULK MUX2_X1
X$128923 \$69188 \$63530 \$56474 \$69359 NWELL PWELL BULK MUX2_X1
X$128970 \$57102 \$56556 \$56654 \$57104 \$57128 NWELL PWELL BULK OAI22_X2
X$128986 \$56997 \$56625 \$56577 NWELL PWELL BULK NAND2_X1
X$128991 M2_AXI_AWBURST[1] \$58380 NWELL PWELL BULK BUF_X1
X$128996 \$57670 S0_AXI_AWADDR[16] NWELL PWELL BULK BUF_X1
X$129002 \$56583 \$58426 \$59716 \$59717 NWELL PWELL BULK MUX2_X1
X$129004 \$56583 \$58860 \$59969 \$59968 NWELL PWELL BULK MUX2_X1
X$129007 \$60340 \$57931 \$56583 \$60576 NWELL PWELL BULK MUX2_X1
X$129009 \$61486 \$57920 \$56583 \$61489 NWELL PWELL BULK MUX2_X1
X$129077 \$56997 \$56618 \$57265 NWELL PWELL BULK NAND2_X1
X$129101 \$56625 \$57707 \$57705 NWELL PWELL BULK XNOR2_X2
X$129108 \$57015 \$56626 NWELL PWELL BULK INV_X1
X$129135 \$59782 \$56641 \$58794 \$57291 NWELL PWELL BULK AOI21_X4
X$129139 \$57301 \$56641 \$56660 \$56659 \$57303 \$57632 NWELL PWELL BULK
+ OAI221_X2
X$129141 \$56641 \$57301 \$56659 \$56660 \$57104 NWELL PWELL BULK OAI22_X1
X$129147 \$62819 \$56641 \$63396 \$63932 \$57054 NWELL PWELL BULK AOI211_X2
X$129149 \$56641 \$58881 \$62820 \$62588 NWELL PWELL BULK NOR3_X1
X$129153 \$64610 \$63714 \$63709 \$56641 NWELL PWELL BULK AND3_X4
X$129182 \$56648 \$56653 \$56655 \$56654 NWELL PWELL BULK AOI21_X2
X$129198 \$60008 \$56665 \$60310 \$56649 \$60312 \$60296 NWELL PWELL BULK
+ OAI221_X2
X$129213 \$57304 \$56654 \$57632 \$57305 NWELL PWELL BULK OAI21_X2
X$129230 \$56660 \$57115 \$57301 \$56665 \$57102 NWELL PWELL BULK OAI22_X1
X$129245 \$58891 \$58074 \$56664 \$59439 \$59341 NWELL PWELL BULK AOI22_X1
X$129257 \$63770 \$63102 \$63114 \$56665 NWELL PWELL BULK OAI21_X2
X$129261 \$56665 \$58332 NWELL PWELL BULK INV_X1
X$129278 \$56673 \$58475 NWELL PWELL BULK INV_X16
X$129283 \$74300 \$56680 \$74321 \$74314 NWELL PWELL BULK MUX2_X1
X$129285 \$79780 \$56680 \$80040 \$80036 NWELL PWELL BULK MUX2_X1
X$129287 \$79771 \$56680 \$80677 \$80356 NWELL PWELL BULK MUX2_X1
X$129290 \$79146 \$56680 \$79899 \$79900 NWELL PWELL BULK MUX2_X1
X$129293 \$79157 \$56680 \$78638 \$79155 NWELL PWELL BULK MUX2_X1
X$129296 \$80079 \$56680 \$80444 \$80607 NWELL PWELL BULK MUX2_X1
X$129298 \$78920 \$56680 \$78668 \$78923 NWELL PWELL BULK MUX2_X1
X$129301 \$77175 \$56680 \$77182 \$77940 NWELL PWELL BULK MUX2_X1
X$129305 \$76686 \$56680 \$76879 \$77042 NWELL PWELL BULK MUX2_X1
X$129307 \$80093 \$56680 \$80095 \$80315 NWELL PWELL BULK MUX2_X1
X$129310 \$75774 \$56680 \$75594 \$75773 NWELL PWELL BULK MUX2_X1
X$129312 \$71133 \$56680 \$73465 \$74337 NWELL PWELL BULK MUX2_X1
X$129316 \$63126 \$56680 \$65913 \$65485 NWELL PWELL BULK MUX2_X1
X$129321 \$66992 \$56680 \$67613 \$67798 NWELL PWELL BULK MUX2_X1
X$129323 \$70217 \$56680 \$70822 \$71403 NWELL PWELL BULK MUX2_X1
X$129326 \$75187 \$56680 \$76438 \$76072 NWELL PWELL BULK MUX2_X1
X$129328 \$76910 \$56680 \$77496 \$77997 NWELL PWELL BULK MUX2_X1
X$129332 \$80137 \$56680 \$79680 \$79679 NWELL PWELL BULK MUX2_X1
X$129343 \$63419 \$56680 \$64326 \$64319 NWELL PWELL BULK MUX2_X1
X$129345 \$69149 \$56680 \$69549 \$69249 NWELL PWELL BULK MUX2_X1
X$129347 \$70244 \$56680 \$70264 \$69632 NWELL PWELL BULK MUX2_X1
X$129349 \$71521 \$56680 \$72970 \$73286 NWELL PWELL BULK MUX2_X1
X$129351 \$75199 \$56680 \$75470 \$75475 NWELL PWELL BULK MUX2_X1
X$129353 \$75858 \$56680 \$75802 \$75466 NWELL PWELL BULK MUX2_X1
X$129355 \$73889 \$56680 \$74439 \$74868 NWELL PWELL BULK MUX2_X1
X$129357 \$74436 \$56680 \$75493 \$75202 NWELL PWELL BULK MUX2_X1
X$129359 \$77679 \$56680 \$78604 \$78602 NWELL PWELL BULK MUX2_X1
X$129361 \$77481 \$56680 \$77673 \$77962 NWELL PWELL BULK MUX2_X1
X$129364 \$77142 \$56680 \$77439 \$77199 NWELL PWELL BULK MUX2_X1
X$129366 \$77139 \$56680 \$77143 \$76555 NWELL PWELL BULK MUX2_X1
X$129369 \$69035 \$56680 \$69612 \$70154 NWELL PWELL BULK MUX2_X1
X$129371 \$76198 \$56680 \$76383 \$76201 NWELL PWELL BULK MUX2_X1
X$129373 \$80385 \$56680 \$80379 \$80134 NWELL PWELL BULK MUX2_X1
X$129375 \$77712 \$56680 \$78463 \$78464 NWELL PWELL BULK MUX2_X1
X$129377 \$78342 \$56680 \$78066 \$78248 NWELL PWELL BULK MUX2_X1
X$129455 \$58279 \$56688 \$57739 \$59908 NWELL PWELL BULK MUX2_X1
X$129457 \$57909 \$56688 \$57329 \$57332 NWELL PWELL BULK MUX2_X1
X$129459 \$56688 \$57329 \$57328 NWELL PWELL BULK NOR2_X1
X$129464 \$57739 \$56688 \$57916 \$58109 NWELL PWELL BULK MUX2_X1
X$129468 \$57912 \$56688 \$56690 NWELL PWELL BULK AND2_X1
X$129471 \$58279 \$57909 \$56688 \$58932 NWELL PWELL BULK NAND3_X4
X$129473 \$58279 \$58490 \$56688 \$58929 NWELL PWELL BULK NAND3_X4
X$129486 \$56693 \$57180 \$56694 NWELL PWELL BULK XNOR2_X2
X$129514 \$57747 \$57749 \$56709 NWELL PWELL BULK NOR2_X1
X$129574 \$56818 \$56739 \$56819 \$59506 NWELL PWELL BULK DFF_X1
X$129592 M2_AXI_WDATA[28] \$57423 NWELL PWELL BULK BUF_X2
X$129609 \$57800 M2_AXI_RID[3] NWELL PWELL BULK BUF_X1
X$129614 \$57798 S0_AXI_WDATA[28] NWELL PWELL BULK BUF_X1
X$129629 \$56779 S0_AXI_AWSIZE[1] NWELL PWELL BULK BUF_X1
X$129634 \$64982 \$57920 \$56782 \$65286 NWELL PWELL BULK MUX2_X1
X$129637 \$56782 \$58426 \$64371 \$64583 NWELL PWELL BULK MUX2_X1
X$129639 \$56782 \$58860 \$64706 \$65275 NWELL PWELL BULK MUX2_X1
X$129642 \$65573 \$57931 \$56782 \$65269 NWELL PWELL BULK MUX2_X1
X$129848 \$56952 S0_AXI_AWID[2] NWELL PWELL BULK BUF_X1
X$129899 \$60623 \$60316 \$56997 NWELL PWELL BULK NAND2_X4
X$129902 \$58433 \$58062 \$56997 \$57920 NWELL PWELL BULK NOR3_X4
X$129906 \$56997 \$58433 \$57700 NWELL PWELL BULK NAND2_X1
X$129911 \$58433 \$57269 \$56997 \$57931 NWELL PWELL BULK NOR3_X4
X$129913 \$56997 \$58023 \$60665 \$I241527 NWELL PWELL BULK HA_X1
X$129928 \$57707 \$58023 \$57708 \$57004 NWELL PWELL BULK MUX2_X1
X$129960 \$58068 \$57975 \$57042 NWELL PWELL BULK OR2_X1
X$130030 \$57728 \$57303 \$57307 \$57116 NWELL PWELL BULK AOI21_X1
X$130038 \$57122 S1_AXI_WID[1] NWELL PWELL BULK BUF_X1
X$130100 M2_AXI_AWLEN[4] \$57432 NWELL PWELL BULK BUF_X1
X$130158 \$57269 \$58065 \$57706 NWELL PWELL BULK XNOR2_X2
X$130162 \$57269 \$58062 NWELL PWELL BULK INV_X2
X$130176 \$57280 \$58069 \$57273 NWELL PWELL BULK NOR2_X1
X$130189 \$58077 \$58808 \$58078 \$57278 NWELL PWELL BULK AOI21_X1
X$130210 \$58076 \$58074 \$57289 \$58069 \$58794 NWELL PWELL BULK AOI22_X2
X$130221 \$57294 \$58085 \$58808 NWELL PWELL BULK NOR2_X1
X$130225 \$58365 \$58077 \$57298 \$57299 NWELL PWELL BULK AOI21_X4
X$130230 \$58891 \$58084 \$57299 \$57613 \$58085 NWELL PWELL BULK AOI22_X4
X$130238 \$57301 \$75876 \$76235 \$57609 \$77085 NWELL PWELL BULK OAI22_X2
X$130244 \$61189 \$60539 \$60708 \$57301 \$61192 \$62079 NWELL PWELL BULK
+ OAI221_X2
X$130247 \$57301 \$65588 \$57609 \$65021 \$65613 NWELL PWELL BULK OAI22_X1
X$130249 \$57301 \$67900 \$57609 \$65029 \$68319 NWELL PWELL BULK OAI22_X1
X$130251 \$73456 \$57609 \$57301 \$72602 \$73906 NWELL PWELL BULK OAI22_X1
X$130254 \$57301 \$72605 \$57609 \$72607 \$73013 NWELL PWELL BULK OAI22_X1
X$130258 \$57301 \$69637 \$57609 \$69874 \$70272 NWELL PWELL BULK OAI22_X1
X$130261 \$57301 \$69158 \$57609 \$69169 \$69157 NWELL PWELL BULK OAI22_X1
X$130263 \$57301 \$67361 \$57609 \$67610 \$68215 NWELL PWELL BULK OAI22_X1
X$130265 \$57301 \$68246 \$57609 \$67886 \$68235 NWELL PWELL BULK OAI22_X1
X$130267 \$57301 \$72590 \$57609 \$72591 \$72940 NWELL PWELL BULK OAI22_X1
X$130269 \$57301 \$71799 \$57609 \$72193 \$71881 NWELL PWELL BULK OAI22_X1
X$130271 \$57301 \$72573 \$57609 \$73118 \$72874 NWELL PWELL BULK OAI22_X1
X$130273 \$57301 \$74856 \$57609 \$74723 \$74854 NWELL PWELL BULK OAI22_X1
X$130276 \$57301 \$75189 \$57609 \$75417 \$75188 NWELL PWELL BULK OAI22_X1
X$130278 \$57301 \$72572 \$57609 \$72575 \$72884 NWELL PWELL BULK OAI22_X1
X$130280 \$57301 \$79375 \$57609 \$79015 \$79371 NWELL PWELL BULK OAI22_X1
X$130282 \$57301 \$79022 \$57609 \$78992 \$79296 NWELL PWELL BULK OAI22_X1
X$130284 \$57301 \$76549 \$57609 \$76902 \$77393 NWELL PWELL BULK OAI22_X1
X$130286 \$57301 \$76527 \$57609 \$76529 \$77056 NWELL PWELL BULK OAI22_X1
X$130288 \$57301 \$79005 \$57609 \$78991 \$79595 NWELL PWELL BULK OAI22_X1
X$130292 \$57301 \$78318 \$57609 \$78305 \$79219 NWELL PWELL BULK OAI22_X1
X$130295 \$57301 \$77924 \$57609 \$77731 \$77902 NWELL PWELL BULK OAI22_X1
X$130297 \$57301 \$76215 \$57609 \$76218 \$76743 NWELL PWELL BULK OAI22_X1
X$130299 \$57301 \$81842 \$57609 \$80861 \$81845 NWELL PWELL BULK OAI22_X1
X$130301 \$57301 \$80848 \$57609 \$80851 \$81059 NWELL PWELL BULK OAI22_X1
X$130304 \$57301 \$78321 \$57609 \$78325 \$78546 NWELL PWELL BULK OAI22_X1
X$130306 \$57301 \$80844 \$57609 \$80455 \$81039 NWELL PWELL BULK OAI22_X1
X$130310 \$57301 \$82215 \$57609 \$80837 \$82034 NWELL PWELL BULK OAI22_X1
X$130312 \$57301 \$81852 \$57609 \$81128 \$81853 NWELL PWELL BULK OAI22_X1
X$130314 \$57301 \$81476 \$57609 \$78262 \$81791 NWELL PWELL BULK OAI22_X1
X$130317 \$57301 \$81860 \$57609 \$80487 \$82495 NWELL PWELL BULK OAI22_X1
X$130319 \$57301 \$81482 \$57609 \$79033 \$81484 NWELL PWELL BULK OAI22_X1
X$130322 \$57301 \$80130 \$57609 \$78064 \$80481 NWELL PWELL BULK OAI22_X1
X$130324 \$57301 \$79402 \$57609 \$77742 \$80401 NWELL PWELL BULK OAI22_X1
X$130399 \$58014 \$57723 \$57303 \$57726 NWELL PWELL BULK AND3_X1
X$130406 \$58094 \$58785 \$57304 NWELL PWELL BULK OR2_X1
X$130415 \$57305 \$57726 \$58091 NWELL PWELL BULK NOR2_X1
X$130426 \$58768 \$58914 \$58076 \$57312 NWELL PWELL BULK AOI21_X2
X$130433 \$57315 \$59448 \$58756 \$58757 NWELL PWELL BULK AND3_X1
X$130462 \$57329 \$57739 \$57916 \$57912 NWELL PWELL BULK HA_X1
X$130536 \$58555 \$58155 \$57380 NWELL PWELL BULK NOR2_X1
X$130549 \$57431 S0_AXI_WID[6] NWELL PWELL BULK BUF_X1
X$130554 M0_AXI_WDATA[21] \$57414 NWELL PWELL BULK CLKBUF_X2
X$130559 \$57386 S0_AXI_AWSIZE[0] NWELL PWELL BULK BUF_X1
X$130582 \$60919 \$58123 \$57414 \$60731 NWELL PWELL BULK MUX2_X1
X$130630 \$57431 \$62301 NWELL PWELL BULK BUF_X1
X$130744 \$57909 \$57559 \$57907 NWELL PWELL BULK XNOR2_X2
X$130757 \$57710 \$57570 \$57709 NWELL PWELL BULK NAND2_X1
X$130796 \$57609 \$62224 NWELL PWELL BULK INV_X1
X$130919 \$57613 \$57724 \$58014 \$58332 \$58084 NWELL PWELL BULK AOI22_X4
X$130939 \$58475 \$60539 \$57625 \$60708 \$60997 \$59892 NWELL PWELL BULK
+ OAI221_X2
X$130942 \$67900 \$57625 \$65029 \$60311 \$68341 NWELL PWELL BULK OAI22_X1
X$130944 \$69158 \$57625 \$69169 \$60311 \$69569 NWELL PWELL BULK OAI22_X1
X$130946 \$65588 \$57625 \$65021 \$60311 \$65899 NWELL PWELL BULK OAI22_X1
X$130948 \$72602 \$57625 \$73456 \$60311 \$73458 NWELL PWELL BULK OAI22_X1
X$130950 \$72605 \$57625 \$72607 \$60311 \$73277 NWELL PWELL BULK OAI22_X1
X$130956 \$69637 \$57625 \$69874 \$60311 \$70291 NWELL PWELL BULK OAI22_X1
X$130958 \$67361 \$57625 \$67610 \$60311 \$68226 NWELL PWELL BULK OAI22_X1
X$130960 \$68246 \$57625 \$67886 \$60311 \$68256 NWELL PWELL BULK OAI22_X1
X$130963 \$72590 \$57625 \$72591 \$60311 \$72958 NWELL PWELL BULK OAI22_X1
X$130965 \$71799 \$57625 \$72193 \$60311 \$72274 NWELL PWELL BULK OAI22_X1
X$130968 \$72572 \$57625 \$72575 \$60311 \$72252 NWELL PWELL BULK OAI22_X1
X$130970 \$72573 \$57625 \$73118 \$60311 \$73310 NWELL PWELL BULK OAI22_X1
X$130973 \$75189 \$57625 \$75417 \$60311 \$75427 NWELL PWELL BULK OAI22_X1
X$130975 \$74856 \$57625 \$74723 \$60311 \$75116 NWELL PWELL BULK OAI22_X1
X$130977 \$76215 \$57625 \$76218 \$60311 \$76219 NWELL PWELL BULK OAI22_X1
X$130980 \$79375 \$57625 \$79015 \$60311 \$79668 NWELL PWELL BULK OAI22_X1
X$130983 \$79022 \$57625 \$78992 \$60311 \$79392 NWELL PWELL BULK OAI22_X1
X$130985 \$76549 \$57625 \$76902 \$60311 \$76803 NWELL PWELL BULK OAI22_X1
X$130987 \$76527 \$57625 \$76529 \$60311 \$76734 NWELL PWELL BULK OAI22_X1
X$130989 \$79005 \$57625 \$78991 \$60311 \$79230 NWELL PWELL BULK OAI22_X1
X$130991 \$78318 \$57625 \$78305 \$60311 \$78901 NWELL PWELL BULK OAI22_X1
X$130993 \$77924 \$57625 \$77731 \$60311 \$77927 NWELL PWELL BULK OAI22_X1
X$130995 \$81842 \$57625 \$80861 \$60311 \$81847 NWELL PWELL BULK OAI22_X1
X$130997 \$82215 \$57625 \$80837 \$60311 \$81710 NWELL PWELL BULK OAI22_X1
X$130999 \$78321 \$57625 \$78325 \$60311 \$78043 NWELL PWELL BULK OAI22_X1
X$131001 \$80848 \$57625 \$80851 \$60311 \$80857 NWELL PWELL BULK OAI22_X1
X$131003 \$80844 \$57625 \$80455 \$60311 \$81165 NWELL PWELL BULK OAI22_X1
X$131005 \$81852 \$57625 \$81128 \$60311 \$82519 NWELL PWELL BULK OAI22_X1
X$131007 \$81476 \$57625 \$78262 \$60311 \$82496 NWELL PWELL BULK OAI22_X1
X$131009 \$79402 \$57625 \$77742 \$60311 \$80400 NWELL PWELL BULK OAI22_X1
X$131011 \$75876 \$57625 \$76235 \$60311 \$76843 NWELL PWELL BULK OAI22_X1
X$131015 \$80130 \$57625 \$78064 \$60311 \$81101 NWELL PWELL BULK OAI22_X1
X$131019 \$81482 \$57625 \$79033 \$60311 \$81779 NWELL PWELL BULK OAI22_X1
X$131021 \$81860 \$57625 \$80487 \$60311 \$82128 NWELL PWELL BULK OAI22_X1
X$131098 \$57666 S0_AXI_AWADDR[25] NWELL PWELL BULK BUF_X1
X$131103 S2_AXI_RDATA[6] \$58566 NWELL PWELL BULK BUF_X2
X$131200 \$57723 \$58014 \$59313 NWELL PWELL BULK NAND2_X1
X$131231 \$57937 \$57737 \$58106 \$58097 NWELL PWELL BULK MUX2_X2
X$131281 \$58174 S1_AXI_WDATA[20] NWELL PWELL BULK BUF_X1
X$131286 \$59023 S0_AXI_WSTRB[1] NWELL PWELL BULK BUF_X1
X$131291 M2_AXI_WDATA[1] \$58181 NWELL PWELL BULK BUF_X1
X$131312 \$61740 \$60727 \$58937 \$57800 NWELL PWELL BULK MUX2_X2
X$131362 \$57872 S1_AXI_WDATA[9] NWELL PWELL BULK BUF_X1
X$131390 \$57894 S1_AXI_WSTRB[3] NWELL PWELL BULK BUF_X1
X$131403 M2_AXI_AWLEN[0] \$57898 NWELL PWELL BULK CLKBUF_X2
X$131426 \$58496 \$58931 \$57905 \$59266 NWELL PWELL BULK MUX2_X1
X$131429 \$57905 \$58929 \$59262 \$59877 NWELL PWELL BULK MUX2_X1
X$131431 \$57905 \$58933 \$58935 \$59862 NWELL PWELL BULK MUX2_X1
X$131433 \$57905 \$58932 \$58497 \$59257 NWELL PWELL BULK MUX2_X1
X$131442 \$58279 \$58113 \$57906 NWELL PWELL BULK XNOR2_X2
X$131452 \$57909 \$58490 NWELL PWELL BULK INV_X1
X$131472 \$82884 \$57920 \$82885 \$83305 NWELL PWELL BULK MUX2_X1
X$131474 \$72841 \$57920 \$71859 \$72238 NWELL PWELL BULK MUX2_X1
X$131476 \$65580 \$57920 \$65578 \$65579 NWELL PWELL BULK MUX2_X1
X$131478 \$68153 \$57920 \$62771 \$67866 NWELL PWELL BULK MUX2_X1
X$131480 \$67860 \$57920 \$65678 \$68135 NWELL PWELL BULK MUX2_X1
X$131483 \$66886 \$57920 \$64018 \$66700 NWELL PWELL BULK MUX2_X1
X$131485 \$79162 \$57920 \$78027 \$78825 NWELL PWELL BULK MUX2_X1
X$131487 \$83601 \$57920 \$82340 \$83981 NWELL PWELL BULK MUX2_X1
X$131497 \$64926 \$57920 \$58566 \$64927 NWELL PWELL BULK MUX2_X1
X$131501 \$61114 \$57920 \$59693 \$60656 NWELL PWELL BULK MUX2_X1
X$131503 \$83289 \$57920 \$83430 \$83004 NWELL PWELL BULK MUX2_X1
X$131506 \$71712 \$57920 NWELL PWELL BULK BUF_X8
X$131509 \$69616 \$57920 \$69458 \$70161 NWELL PWELL BULK MUX2_X1
X$131511 \$68177 \$57920 \$67599 \$68165 NWELL PWELL BULK MUX2_X1
X$131513 \$74643 \$57920 \$73105 \$74644 NWELL PWELL BULK MUX2_X1
X$131552 \$57926 S0_AXI_AWLEN[5] NWELL PWELL BULK BUF_X1
X$131570 \$73411 \$57931 \$73105 \$73737 NWELL PWELL BULK MUX2_X1
X$131574 \$65575 \$57931 \$65578 \$65797 NWELL PWELL BULK MUX2_X1
X$131576 \$78477 \$57931 \$78027 \$78472 NWELL PWELL BULK MUX2_X1
X$131579 \$69225 \$57931 \$69458 \$69454 NWELL PWELL BULK MUX2_X1
X$131581 \$84393 \$57931 \$83430 \$84003 NWELL PWELL BULK MUX2_X1
X$131583 \$83000 \$57931 \$82340 \$82998 NWELL PWELL BULK MUX2_X1
X$131585 \$63922 \$57931 \$58566 \$64194 NWELL PWELL BULK MUX2_X1
X$131590 \$68410 \$57931 \$65678 \$68409 NWELL PWELL BULK MUX2_X1
X$131601 \$61453 \$57931 \$59693 \$61113 NWELL PWELL BULK MUX2_X1
X$131603 \$83434 \$57931 \$82885 \$83829 NWELL PWELL BULK MUX2_X1
X$131605 \$71841 \$57931 NWELL PWELL BULK BUF_X8
X$131608 \$69054 \$57931 \$67599 \$69050 NWELL PWELL BULK MUX2_X1
X$131611 \$67273 \$57931 \$64018 \$67784 NWELL PWELL BULK MUX2_X1
X$131614 \$67282 \$57931 \$62771 \$67792 NWELL PWELL BULK MUX2_X1
X$131616 \$72563 \$57931 \$71859 \$72834 NWELL PWELL BULK MUX2_X1
X$131671 \$59194 \$58430 \$57975 NWELL PWELL BULK NOR2_X1
X$131687 \$67307 \$58005 \$58475 \$68336 NWELL PWELL BULK OAI21_X1
X$131689 \$68148 \$58005 \$58475 \$69568 NWELL PWELL BULK OAI21_X1
X$131691 \$76232 \$58005 \$58475 \$76844 NWELL PWELL BULK OAI21_X1
X$131693 \$73909 \$58005 \$58475 \$74028 NWELL PWELL BULK OAI21_X1
X$131695 \$72281 \$58005 \$58475 \$73131 NWELL PWELL BULK OAI21_X1
X$131697 \$65023 \$58005 \$58475 \$65026 NWELL PWELL BULK OAI21_X1
X$131700 \$69868 \$58005 \$58475 \$70296 NWELL PWELL BULK OAI21_X1
X$131702 \$67607 \$58005 \$58475 \$67612 NWELL PWELL BULK OAI21_X1
X$131704 \$74427 \$58005 \$58475 \$75114 NWELL PWELL BULK OAI21_X1
X$131707 \$72255 \$58005 \$58475 \$72265 NWELL PWELL BULK OAI21_X1
X$131709 \$72890 \$58005 \$58475 \$72577 NWELL PWELL BULK OAI21_X1
X$131713 \$72866 \$58005 \$58475 \$73309 NWELL PWELL BULK OAI21_X1
X$131716 \$68809 \$58005 \$58475 \$68731 NWELL PWELL BULK OAI21_X1
X$131719 \$75574 \$58005 \$58475 \$75581 NWELL PWELL BULK OAI21_X1
X$131722 \$78836 \$58005 \$58475 \$79378 NWELL PWELL BULK OAI21_X1
X$131724 \$76526 \$58005 \$58475 \$76532 NWELL PWELL BULK OAI21_X1
X$131727 \$78657 \$58005 \$58475 \$78549 NWELL PWELL BULK OAI21_X1
X$131731 \$79393 \$58005 \$58475 \$79729 NWELL PWELL BULK OAI21_X1
X$131734 \$77726 \$58005 \$58475 \$77925 NWELL PWELL BULK OAI21_X1
X$131738 \$76867 \$58005 \$58475 \$76754 NWELL PWELL BULK OAI21_X1
X$131740 \$76899 \$58005 \$58475 \$76903 NWELL PWELL BULK OAI21_X1
X$131743 \$82224 \$58005 \$58475 \$82479 NWELL PWELL BULK OAI21_X1
X$131745 \$81586 \$58005 \$58475 \$81715 NWELL PWELL BULK OAI21_X1
X$131749 \$80853 \$58005 \$58475 \$80680 NWELL PWELL BULK OAI21_X1
X$131752 \$79217 \$58005 \$58475 \$79362 NWELL PWELL BULK OAI21_X1
X$131754 \$78650 \$58005 \$58475 \$78327 NWELL PWELL BULK OAI21_X1
X$131757 \$81157 \$58005 \$58475 \$81161 NWELL PWELL BULK OAI21_X1
X$131759 \$82230 \$58005 \$58475 \$82508 NWELL PWELL BULK OAI21_X1
X$131762 \$81801 \$58005 \$58475 \$81864 NWELL PWELL BULK OAI21_X1
X$131764 \$82234 \$58005 \$58475 \$82482 NWELL PWELL BULK OAI21_X1
X$131766 \$80131 \$58005 \$58475 \$80398 NWELL PWELL BULK OAI21_X1
X$131768 \$80871 \$58005 \$58475 \$80872 NWELL PWELL BULK OAI21_X1
X$131770 \$81393 \$58005 \$58475 \$81489 NWELL PWELL BULK OAI21_X1
X$131821 \$71803 \$58005 \$58475 \$72982 NWELL PWELL BULK OAI21_X1
X$131856 \$58785 \$58094 \$58020 NWELL PWELL BULK NOR2_X1
X$131861 \$58874 \$58023 \$60219 \$60595 NWELL PWELL BULK MUX2_X1
X$131864 \$59402 \$58023 \$60220 \$60591 NWELL PWELL BULK MUX2_X1
X$131869 \$58871 \$58023 \$59402 \$58873 NWELL PWELL BULK MUX2_X1
X$131874 \$58023 \$59236 \$58441 NWELL PWELL BULK NAND2_X1
X$131877 \$58065 \$58023 \$58874 \$58759 NWELL PWELL BULK MUX2_X1
X$131880 \$58023 \$60216 NWELL PWELL BULK INV_X1
X$131890 \$65613 \$58025 \$65900 NWELL PWELL BULK NOR2_X1
X$131892 \$69157 \$58025 \$68835 NWELL PWELL BULK NOR2_X1
X$131895 \$68319 \$58025 \$68329 NWELL PWELL BULK NOR2_X1
X$131897 \$73906 \$58025 \$73453 NWELL PWELL BULK NOR2_X1
X$131899 \$73013 \$58025 \$72280 NWELL PWELL BULK NOR2_X1
X$131901 \$58025 \$61189 NWELL PWELL BULK INV_X2
X$131903 \$70272 \$58025 \$69869 NWELL PWELL BULK NOR2_X1
X$131905 \$68215 \$58025 \$67605 NWELL PWELL BULK NOR2_X1
X$131907 \$68235 \$58025 \$68704 NWELL PWELL BULK NOR2_X1
X$131909 \$72940 \$58025 \$72589 NWELL PWELL BULK NOR2_X1
X$131911 \$71881 \$58025 \$71525 NWELL PWELL BULK NOR2_X1
X$131914 \$74854 \$58025 \$74708 NWELL PWELL BULK NOR2_X1
X$131916 \$75188 \$58025 \$75575 NWELL PWELL BULK NOR2_X1
X$131918 \$72874 \$58025 \$72875 NWELL PWELL BULK NOR2_X1
X$131920 \$72884 \$58025 \$73329 NWELL PWELL BULK NOR2_X1
X$131923 \$77393 \$58025 \$77185 NWELL PWELL BULK NOR2_X1
X$131926 \$77056 \$58025 \$76881 NWELL PWELL BULK NOR2_X1
X$131928 \$79219 \$58025 \$79003 NWELL PWELL BULK NOR2_X1
X$131931 \$77902 \$58025 \$77896 NWELL PWELL BULK NOR2_X1
X$131933 \$77085 \$58025 \$77096 NWELL PWELL BULK NOR2_X1
X$131935 \$79296 \$58025 \$79299 NWELL PWELL BULK NOR2_X1
X$131937 \$76743 \$58025 \$77067 NWELL PWELL BULK NOR2_X1
X$131939 \$81845 \$58025 \$82563 NWELL PWELL BULK NOR2_X1
X$131942 \$78546 \$58025 \$78544 NWELL PWELL BULK NOR2_X1
X$131944 \$81059 \$58025 \$81700 NWELL PWELL BULK NOR2_X1
X$131947 \$79371 \$58025 \$79589 NWELL PWELL BULK NOR2_X1
X$131950 \$79595 \$58025 \$79964 NWELL PWELL BULK NOR2_X1
X$131953 \$81039 \$58025 \$81349 NWELL PWELL BULK NOR2_X1
X$131955 \$82034 \$58025 \$81837 NWELL PWELL BULK NOR2_X1
X$131957 \$81853 \$58025 \$82229 NWELL PWELL BULK NOR2_X1
X$131959 \$82495 \$58025 \$82494 NWELL PWELL BULK NOR2_X1
X$131962 \$81791 \$58025 \$81804 NWELL PWELL BULK NOR2_X1
X$131964 \$81484 \$58025 \$81787 NWELL PWELL BULK NOR2_X1
X$131967 \$80481 \$58025 \$80868 NWELL PWELL BULK NOR2_X1
X$131969 \$80401 \$58025 \$80403 NWELL PWELL BULK NOR2_X1
X$132048 M2_AXI_AWID[2] \$58397 NWELL PWELL BULK CLKBUF_X2
X$132082 \$58418 \$58420 \$58056 \$58290 NWELL PWELL BULK MUX2_X1
X$132089 \$58057 \$58420 \$58058 \$58302 NWELL PWELL BULK MUX2_X1
X$132118 \$58302 \$58422 \$58068 NWELL PWELL BULK NOR2_X1
X$132131 \$58077 \$58069 NWELL PWELL BULK INV_X1
X$132134 \$61166 \$58897 \$58074 \$58914 \$59439 NWELL PWELL BULK OR4_X4
X$132137 \$58074 \$58914 \$58909 NWELL PWELL BULK NOR2_X4
X$132140 \$59999 \$60258 \$60252 \$58074 NWELL PWELL BULK OAI21_X4
X$132145 \$58785 \$58901 \$60000 \$58074 \$58770 NWELL PWELL BULK AND4_X1
X$132147 \$60000 \$60382 \$58074 \$60008 NWELL PWELL BULK NAND3_X4
X$132159 \$61039 \$60683 \$58075 \$60367 NWELL PWELL BULK NAND3_X1
X$132162 \$58075 \$60683 \$61039 \$61160 NWELL PWELL BULK AND3_X1
X$132164 \$61150 \$61155 \$59407 \$60683 \$58075 NWELL PWELL BULK AOI22_X4
X$132166 \$60683 \$58075 \$61137 NWELL PWELL BULK NAND2_X1
X$132169 \$58075 \$59987 \$59283 \$59807 \$59426 NWELL PWELL BULK AOI22_X1
X$132177 \$58902 \$58076 \$58089 NWELL PWELL BULK NAND2_X1
X$132179 \$59852 \$58902 \$58076 \$61651 NWELL PWELL BULK OAI21_X1
X$132182 \$60385 \$58076 \$58458 \$60695 NWELL PWELL BULK NAND3_X1
X$132185 \$58076 \$60382 \$58909 \$60693 NWELL PWELL BULK AOI21_X1
X$132188 \$58076 \$60302 \$60531 NWELL PWELL BULK NAND2_X4
X$132203 \$58077 \$64222 \$61512 NWELL PWELL BULK XNOR2_X1
X$132242 \$58467 \$58909 \$58465 \$58770 \$58891 \$58092 NWELL PWELL BULK
+ AOI221_X2
X$132244 \$58094 \$60958 \$60971 NWELL PWELL BULK XNOR2_X1
X$132257 \$60387 \$58097 \$61180 \$58095 \$61178 NWELL PWELL BULK AOI22_X2
X$132260 \$60387 \$60389 \$60702 \$58095 \$60538 NWELL PWELL BULK AOI22_X2
X$132264 \$60387 \$60390 \$58095 \$60705 \$60997 NWELL PWELL BULK AOI22_X1
X$132266 \$60387 \$60012 \$61173 \$58095 \$61691 NWELL PWELL BULK AOI22_X2
X$132273 \$61180 \$61181 \$60706 \$58097 \$62076 NWELL PWELL BULK AOI22_X1
X$132275 \$62224 \$58097 \$61846 \$61180 \$62659 NWELL PWELL BULK AOI22_X1
X$132290 \$58099 \$58481 \$58473 NWELL PWELL BULK NOR2_X2
X$132297 \$71520 \$58102 \$71521 \$71794 NWELL PWELL BULK MUX2_X1
X$132300 \$68416 \$58102 \$69035 \$67867 NWELL PWELL BULK MUX2_X1
X$132302 \$76236 \$58102 \$75774 \$76478 NWELL PWELL BULK MUX2_X1
X$132306 \$63806 \$58102 \$63419 \$63420 NWELL PWELL BULK MUX2_X1
X$132309 \$63125 \$58102 \$63126 \$63825 NWELL PWELL BULK MUX2_X1
X$132312 \$70235 \$58102 \$70244 \$69861 NWELL PWELL BULK MUX2_X1
X$132315 \$70461 \$58102 \$70217 \$70715 NWELL PWELL BULK MUX2_X1
X$132318 \$78690 \$58102 \$78342 \$78955 NWELL PWELL BULK MUX2_X1
X$132320 \$80475 \$58102 \$80385 \$80757 NWELL PWELL BULK MUX2_X1
X$132323 \$71780 \$58102 \$71133 \$71775 NWELL PWELL BULK MUX2_X1
X$132329 \$70306 \$58102 \$69149 \$70476 NWELL PWELL BULK MUX2_X1
X$132332 \$66714 \$58102 \$66992 \$67364 NWELL PWELL BULK MUX2_X1
X$132334 \$73444 \$58102 NWELL PWELL BULK BUF_X8
X$132336 \$77431 \$58102 \$77679 \$77196 NWELL PWELL BULK MUX2_X1
X$132338 \$77186 \$58102 \$77139 \$77189 NWELL PWELL BULK MUX2_X1
X$132340 \$77990 \$58102 \$77142 \$77744 NWELL PWELL BULK MUX2_X1
X$132342 \$80801 \$58102 \$80137 \$80798 NWELL PWELL BULK MUX2_X1
X$132344 \$78060 \$58102 \$76910 \$78615 NWELL PWELL BULK MUX2_X1
X$132391 \$76425 \$58106 \$76706 \$76529 NWELL PWELL BULK MUX2_X1
X$132393 \$73862 \$58106 \$73864 \$72591 NWELL PWELL BULK MUX2_X1
X$132395 \$75196 \$58106 \$76108 \$74723 NWELL PWELL BULK MUX2_X1
X$132398 \$79520 \$79150 \$58106 \$78991 NWELL PWELL BULK MUX2_X2
X$132400 \$80970 \$80965 \$58106 \$80837 NWELL PWELL BULK MUX2_X2
X$132402 \$81021 \$58106 \$80839 \$80851 NWELL PWELL BULK MUX2_X1
X$132405 \$79541 \$79538 \$58106 \$78992 NWELL PWELL BULK MUX2_X2
X$132408 \$80454 \$58106 \$80345 \$80455 NWELL PWELL BULK MUX2_X1
X$132411 \$68668 \$69613 \$58106 \$60012 NWELL PWELL BULK MUX2_X2
X$132413 \$71531 \$58106 \$73133 \$72607 NWELL PWELL BULK MUX2_X1
X$132416 \$73452 \$58106 \$74776 \$73456 NWELL PWELL BULK MUX2_X1
X$132418 \$60400 \$60399 \$58106 \$60390 NWELL PWELL BULK MUX2_X2
X$132420 \$60396 \$60985 \$58106 \$60389 NWELL PWELL BULK MUX2_X2
X$132423 \$63816 \$58106 \$64676 \$65021 NWELL PWELL BULK MUX2_X1
X$132426 \$75571 \$58106 \$75851 \$75417 NWELL PWELL BULK MUX2_X1
X$132428 \$66996 \$58106 \$67376 \$67610 NWELL PWELL BULK MUX2_X1
X$132430 \$69865 \$58106 \$70469 \$69874 NWELL PWELL BULK MUX2_X1
X$132433 \$79032 \$58106 \$79298 \$79033 NWELL PWELL BULK MUX2_X1
X$132436 \$78057 \$58106 \$78261 \$78262 NWELL PWELL BULK MUX2_X1
X$132438 \$77490 \$58106 \$77985 \$77742 NWELL PWELL BULK MUX2_X1
X$132440 \$80478 \$58106 \$80778 \$81128 NWELL PWELL BULK MUX2_X1
X$132442 \$75877 \$58106 \$75504 \$76235 NWELL PWELL BULK MUX2_X1
X$132446 \$58106 \$58481 NWELL PWELL BULK INV_X1
X$132449 \$63426 \$58106 \$64743 \$65029 NWELL PWELL BULK MUX2_X1
X$132453 \$74863 \$58106 \$75130 \$73118 NWELL PWELL BULK MUX2_X1
X$132455 \$72267 \$58106 \$72964 \$72575 NWELL PWELL BULK MUX2_X1
X$132457 \$74340 \$58106 \$74437 \$72193 NWELL PWELL BULK MUX2_X1
X$132460 \$70219 \$58106 \$69858 \$67886 NWELL PWELL BULK MUX2_X1
X$132462 \$77192 \$58106 \$76557 \$76902 NWELL PWELL BULK MUX2_X1
X$132464 \$78051 \$58106 \$78588 \$78325 NWELL PWELL BULK MUX2_X1
X$132468 \$77363 \$58106 \$77930 \$77731 NWELL PWELL BULK MUX2_X1
X$132471 \$77750 \$58106 \$77495 \$78064 NWELL PWELL BULK MUX2_X1
X$132474 \$80715 \$58106 \$80725 \$80861 NWELL PWELL BULK MUX2_X1
X$132477 \$79251 \$58106 \$79011 \$79015 NWELL PWELL BULK MUX2_X1
X$132479 \$76872 \$58106 \$75842 \$76218 NWELL PWELL BULK MUX2_X1
X$132482 \$78162 \$58106 \$78024 \$78305 NWELL PWELL BULK MUX2_X1
X$132484 \$81089 \$58106 \$80358 \$80487 NWELL PWELL BULK MUX2_X1
X$132515 \$69251 \$58106 \$69252 \$69169 NWELL PWELL BULK MUX2_X1
X$132597 \$65644 \$58123 \$59507 \$65854 NWELL PWELL BULK MUX2_X1
X$132600 \$60441 \$58123 \$60054 \$60478 NWELL PWELL BULK MUX2_X1
X$132603 \$69685 \$58123 \$68922 \$70043 NWELL PWELL BULK MUX2_X1
X$132607 \$69311 \$58123 \$69949 \$69681 NWELL PWELL BULK MUX2_X1
X$132609 \$67959 \$58123 \$67664 \$68558 NWELL PWELL BULK MUX2_X1
X$132612 \$66794 \$58123 \$66047 \$66793 NWELL PWELL BULK MUX2_X1
X$132616 \$68493 \$58123 \$67954 \$68105 NWELL PWELL BULK MUX2_X1
X$132622 \$62844 \$58123 \$62696 \$63254 NWELL PWELL BULK MUX2_X1
X$132629 \$63991 \$58123 \$63992 \$64510 NWELL PWELL BULK MUX2_X1
X$132708 \$59546 S1_AXI_WDATA[15] NWELL PWELL BULK BUF_X1
X$132713 \$58189 S1_AXI_WDATA[23] NWELL PWELL BULK BUF_X1
X$132761 \$68388 \$63210 \$58207 \$68000 NWELL PWELL BULK MUX2_X1
X$132764 \$68908 \$63530 \$58207 \$69180 NWELL PWELL BULK MUX2_X1
X$132766 \$67561 \$63057 \$58207 \$67977 NWELL PWELL BULK MUX2_X1
X$132769 \$69332 \$61075 \$58207 \$69329 NWELL PWELL BULK MUX2_X1
X$132781 \$I175146 \$58615 \$58211 \$59565 NWELL PWELL BULK DFF_X1
X$132804 \$59121 \$58232 \$59490 NWELL PWELL BULK NOR2_X2
X$132837 \$58262 \$58693 \$58691 NWELL PWELL BULK NOR2_X2
X$132886 \$58909 \$59440 \$59867 \$58332 \$58770 \$58468 NWELL PWELL BULK
+ AOI221_X2
X$132895 \$58351 \$61846 NWELL PWELL BULK INV_X1
X$132899 \$58351 \$65023 \$65900 \$66007 NWELL PWELL BULK OAI21_X1
X$132901 \$58351 \$68148 \$68835 \$69260 NWELL PWELL BULK OAI21_X1
X$132904 \$58351 \$67307 \$68329 \$67477 NWELL PWELL BULK OAI21_X1
X$132908 \$58351 \$72281 \$72280 \$69892 NWELL PWELL BULK OAI21_X1
X$132910 \$58351 \$73909 \$73453 \$74026 NWELL PWELL BULK OAI21_X1
X$132912 \$58351 \$69868 \$69869 \$68817 NWELL PWELL BULK OAI21_X1
X$132914 \$58351 \$67607 \$67605 \$67878 NWELL PWELL BULK OAI21_X1
X$132917 \$58351 \$68809 \$68704 \$67873 NWELL PWELL BULK OAI21_X1
X$132919 \$58351 \$72255 \$72589 \$71515 NWELL PWELL BULK OAI21_X1
X$132921 \$58351 \$71803 \$71525 \$69885 NWELL PWELL BULK OAI21_X1
X$132924 \$58351 \$75574 \$75575 \$74843 NWELL PWELL BULK OAI21_X1
X$132927 \$58351 \$74427 \$74708 \$73999 NWELL PWELL BULK OAI21_X1
X$132930 \$73329 \$58351 \$72890 \$73106 NWELL PWELL BULK OAI21_X2
X$132933 \$58351 \$72866 \$72875 \$70817 NWELL PWELL BULK OAI21_X1
X$132936 \$58351 \$79393 \$79299 \$79404 NWELL PWELL BULK OAI21_X1
X$132940 \$77185 \$58351 \$76899 \$77655 NWELL PWELL BULK OAI21_X2
X$132942 \$58351 \$76526 \$76881 \$77169 NWELL PWELL BULK OAI21_X1
X$132945 \$78544 \$58351 \$78650 \$78298 NWELL PWELL BULK OAI21_X2
X$132948 \$77896 \$58351 \$77726 \$76995 NWELL PWELL BULK OAI21_X2
X$132950 \$77096 \$58351 \$76232 \$77367 NWELL PWELL BULK OAI21_X2
X$132953 \$77067 \$58351 \$76867 \$76515 NWELL PWELL BULK OAI21_X2
X$132956 \$58351 \$82224 \$82563 \$82562 NWELL PWELL BULK OAI21_X1
X$132958 \$58351 \$78657 \$79003 \$79979 NWELL PWELL BULK OAI21_X1
X$132960 \$79589 \$58351 \$78836 \$79336 NWELL PWELL BULK OAI21_X2
X$132963 \$58351 \$79217 \$79964 \$80098 NWELL PWELL BULK OAI21_X1
X$132966 \$81349 \$58351 \$81157 \$81146 NWELL PWELL BULK OAI21_X2
X$132970 \$58351 \$80853 \$81700 \$81840 NWELL PWELL BULK OAI21_X1
X$132973 \$58351 \$81586 \$81837 \$82552 NWELL PWELL BULK OAI21_X1
X$132976 \$58351 \$81801 \$81804 \$81806 NWELL PWELL BULK OAI21_X1
X$132978 \$58351 \$80131 \$80403 \$80771 NWELL PWELL BULK OAI21_X1
X$132980 \$58351 \$80871 \$80868 \$81483 NWELL PWELL BULK OAI21_X1
X$132983 \$58351 \$82234 \$82494 \$82831 NWELL PWELL BULK OAI21_X1
X$132986 \$58351 \$82230 \$82229 \$83140 NWELL PWELL BULK OAI21_X1
X$132989 \$58351 \$81393 \$81787 \$81493 NWELL PWELL BULK OAI21_X1
X$133050 \$58365 \$70796 \$71096 NWELL PWELL BULK NAND2_X1
X$133052 \$58365 \$70442 \$70641 NWELL PWELL BULK NAND2_X1
X$133054 \$58365 \$70970 \$70800 NWELL PWELL BULK NAND2_X1
X$133056 \$58365 \$71848 \$I241074 \$71005 NWELL PWELL BULK HA_X1
X$133059 \$71104 \$70804 \$58365 \$65879 NWELL PWELL BULK NAND3_X4
X$133061 \$58365 \$69843 \$70643 NWELL PWELL BULK NAND2_X1
X$133063 \$58365 \$70803 NWELL PWELL BULK INV_X2
X$133066 \$58365 \$70441 \$71100 NWELL PWELL BULK NAND2_X1
X$133069 \$58365 \$69841 \$69845 NWELL PWELL BULK NAND2_X1
X$133071 \$70987 \$70804 \$58365 \$66724 NWELL PWELL BULK NAND3_X4
X$133091 \$58384 S0_AXI_AWADDR[1] NWELL PWELL BULK BUF_X1
X$133096 \$59528 S0_AXI_AWADDR[8] NWELL PWELL BULK BUF_X1
X$133162 \$58417 \$58420 \$59183 \$58859 NWELL PWELL BULK MUX2_X1
X$133172 \$83178 \$58420 \$84017 \$83433 NWELL PWELL BULK MUX2_X1
X$133174 \$83435 \$58420 \$83308 \$83634 NWELL PWELL BULK MUX2_X1
X$133176 \$72460 \$58420 \$72565 \$72567 NWELL PWELL BULK MUX2_X1
X$133178 \$72825 \$58420 \$72560 \$72836 NWELL PWELL BULK MUX2_X1
X$133180 \$71354 \$58420 \$71115 \$72849 NWELL PWELL BULK MUX2_X1
X$133183 \$66175 \$58420 \$65585 \$64986 NWELL PWELL BULK MUX2_X1
X$133186 \$68143 \$58420 \$68412 \$68146 NWELL PWELL BULK MUX2_X1
X$133188 \$68681 \$58420 \$68673 \$68185 NWELL PWELL BULK MUX2_X1
X$133190 \$62807 \$58420 \$62520 \$63005 NWELL PWELL BULK MUX2_X1
X$133192 \$71670 \$58420 \$71842 \$70437 NWELL PWELL BULK MUX2_X1
X$133194 \$61453 \$58420 \$61114 \$61461 NWELL PWELL BULK MUX2_X1
X$133196 \$70794 \$58420 \$70436 \$70631 NWELL PWELL BULK MUX2_X1
X$133200 \$59969 \$58420 \$59716 \$60342 NWELL PWELL BULK MUX2_X1
X$133202 \$60340 \$58420 \$61486 \$60974 NWELL PWELL BULK MUX2_X1
X$133205 \$64209 \$58420 \$63089 \$62809 NWELL PWELL BULK MUX2_X1
X$133207 \$64924 \$65305 \$58420 \$65299 NWELL PWELL BULK OAI21_X1
X$133209 \$58420 \$64710 \$65299 \$61813 NWELL PWELL BULK OAI21_X1
X$133211 \$58864 \$58420 \$58866 \$59194 NWELL PWELL BULK MUX2_X1
X$133216 \$64197 \$58420 \$64373 \$64985 NWELL PWELL BULK MUX2_X1
X$133218 \$59393 \$58420 \$59395 \$59966 NWELL PWELL BULK MUX2_X1
X$133220 \$83002 \$58420 \$83177 \$82539 NWELL PWELL BULK MUX2_X1
X$133222 \$84007 \$58420 \$83008 \$82694 NWELL PWELL BULK MUX2_X1
X$133225 \$83318 \$58420 \$84043 \$82887 NWELL PWELL BULK MUX2_X1
X$133227 \$69785 \$58420 \$69608 \$69788 NWELL PWELL BULK MUX2_X1
X$133229 \$68684 \$58420 \$68803 \$68422 NWELL PWELL BULK MUX2_X1
X$133231 \$69851 \$58420 \$69795 \$69852 NWELL PWELL BULK MUX2_X1
X$133233 \$69223 \$58420 \$69615 \$70173 NWELL PWELL BULK MUX2_X1
X$133235 \$71018 \$58420 \$71347 \$72090 NWELL PWELL BULK MUX2_X1
X$133237 \$66977 \$58420 \$66976 \$68144 NWELL PWELL BULK MUX2_X1
X$133240 \$66902 \$58420 \$67298 \$67302 NWELL PWELL BULK MUX2_X1
X$133242 \$67861 \$58420 \$67593 \$68651 NWELL PWELL BULK MUX2_X1
X$133244 \$67297 \$58420 \$67595 \$67301 NWELL PWELL BULK MUX2_X1
X$133246 \$81964 \$58420 \$82200 \$82351 NWELL PWELL BULK MUX2_X1
X$133249 \$73749 \$58420 \$73412 \$72562 NWELL PWELL BULK MUX2_X1
X$133251 \$58420 \$72080 NWELL PWELL BULK BUF_X16
X$133254 \$78306 \$58420 \$78827 \$78831 NWELL PWELL BULK MUX2_X1
X$133256 \$78186 \$58420 \$78483 \$78030 NWELL PWELL BULK MUX2_X1
X$133312 \$63005 \$62809 \$58422 \$60705 NWELL PWELL BULK MUX2_X2
X$133314 \$60974 \$60342 \$58422 \$60702 NWELL PWELL BULK MUX2_X2
X$133316 \$61461 \$59966 \$58422 \$61173 NWELL PWELL BULK MUX2_X2
X$133322 \$65580 \$64982 \$58422 \$64924 NWELL PWELL BULK NOR3_X1
X$133326 \$58422 \$64987 NWELL PWELL BULK BUF_X16
X$133328 \$58422 \$58430 NWELL PWELL BULK INV_X1
X$133331 \$65575 \$65573 \$58422 \$65577 NWELL PWELL BULK NOR3_X1
X$133333 \$65577 \$58422 \$64979 \$64710 NWELL PWELL BULK AOI21_X1
X$133348 \$78027 \$58426 \$78489 \$78193 NWELL PWELL BULK MUX2_X1
X$133352 \$82885 \$58426 \$83831 \$84421 NWELL PWELL BULK MUX2_X1
X$133355 \$80438 \$58426 \$80832 \$80833 NWELL PWELL BULK MUX2_X1
X$133357 \$65578 \$58426 \$65581 \$65811 NWELL PWELL BULK MUX2_X1
X$133359 \$62771 \$58426 \$66898 \$66899 NWELL PWELL BULK MUX2_X1
X$133361 \$72556 \$58426 \$72817 \$72808 NWELL PWELL BULK MUX2_X1
X$133364 \$67599 \$58426 \$69463 \$68802 NWELL PWELL BULK MUX2_X1
X$133367 \$69458 \$58426 \$69796 \$69617 NWELL PWELL BULK MUX2_X1
X$133370 \$83430 \$58426 \$83825 \$84013 NWELL PWELL BULK MUX2_X1
X$133373 \$74832 \$58426 \$75023 \$75022 NWELL PWELL BULK MUX2_X1
X$133376 \$71489 \$58426 \$70436 \$70623 NWELL PWELL BULK MUX2_X1
X$133379 \$82647 \$58426 \$83554 \$83549 NWELL PWELL BULK MUX2_X1
X$133382 \$81423 \$58426 \$82528 \$82648 NWELL PWELL BULK MUX2_X1
X$133384 \$78978 \$58426 \$79478 \$79328 NWELL PWELL BULK MUX2_X1
X$133387 \$80828 \$58426 \$81428 \$81930 NWELL PWELL BULK MUX2_X1
X$133389 \$80558 \$58426 \$80557 \$80559 NWELL PWELL BULK MUX2_X1
X$133393 \$58566 \$58426 \$65818 \$64984 NWELL PWELL BULK MUX2_X1
X$133395 \$75701 \$58426 \$76365 \$76189 NWELL PWELL BULK MUX2_X1
X$133404 \$59693 \$58426 \$59395 \$60194 NWELL PWELL BULK MUX2_X1
X$133406 \$83418 \$58426 \$83915 \$83912 NWELL PWELL BULK MUX2_X1
X$133409 \$81137 \$58426 \$82304 \$82298 NWELL PWELL BULK MUX2_X1
X$133411 \$73552 \$58426 \$74404 \$74826 NWELL PWELL BULK MUX2_X1
X$133413 \$71843 \$58426 \$73093 \$73393 NWELL PWELL BULK MUX2_X1
X$133416 \$76861 \$58426 \$77566 \$77266 NWELL PWELL BULK MUX2_X1
X$133418 \$79325 \$58426 \$79735 \$80204 NWELL PWELL BULK MUX2_X1
X$133421 \$78418 \$58426 \$78016 \$78424 NWELL PWELL BULK MUX2_X1
X$133424 \$78290 \$58426 \$78405 \$78009 NWELL PWELL BULK MUX2_X1
X$133426 \$79740 \$58426 \$80218 \$79870 NWELL PWELL BULK MUX2_X1
X$133428 \$76191 \$58426 \$77460 \$77268 NWELL PWELL BULK MUX2_X1
X$133430 \$76185 \$58426 \$77558 \$77555 NWELL PWELL BULK MUX2_X1
X$133433 \$82340 \$58426 \$82345 \$82674 NWELL PWELL BULK MUX2_X1
X$133436 \$75838 \$58426 \$75723 \$75837 NWELL PWELL BULK MUX2_X1
X$133438 \$64018 \$58426 \$68649 \$68653 NWELL PWELL BULK MUX2_X1
X$133440 \$65678 \$58426 \$68794 \$69216 NWELL PWELL BULK MUX2_X1
X$133442 \$82531 \$58426 \$83426 \$83251 NWELL PWELL BULK MUX2_X1
X$133444 \$73105 \$58426 \$72833 \$72827 NWELL PWELL BULK MUX2_X1
X$133446 \$71859 \$58426 \$72100 \$72461 NWELL PWELL BULK MUX2_X1
X$133449 \$71500 \$58426 \$70811 \$71719 NWELL PWELL BULK MUX2_X1
X$133511 \$65581 \$64371 \$58430 \$65305 NWELL PWELL BULK NOR3_X1
X$133523 \$58433 \$58871 \$58439 NWELL PWELL BULK XNOR2_X2
X$133539 \$59239 \$58441 \$58443 \$58875 NWELL PWELL BULK MUX2_X1
X$133543 \$58449 \$58881 NWELL PWELL BULK INV_X2
X$133548 \$58880 \$59407 \$58449 \$59259 NWELL PWELL BULK AOI21_X1
X$133550 \$58449 \$60348 \$60671 \$61550 NWELL PWELL BULK OAI21_X1
X$133552 \$58449 \$61133 \$60670 \$61546 NWELL PWELL BULK AOI21_X1
X$133554 \$58449 \$60352 \$60671 \$61570 NWELL PWELL BULK OAI21_X1
X$133558 \$58882 \$60375 \$61021 \$58449 \$60679 \$60358 \$60612 NWELL PWELL
+ BULK OAI33_X1
X$133560 \$62556 \$59405 \$61822 \$58449 NWELL PWELL BULK DFF_X2
X$133562 \$61143 \$58449 \$59285 \$61144 NWELL PWELL BULK NOR3_X1
X$133582 \$59285 \$58880 \$58454 NWELL PWELL BULK NOR2_X2
X$133585 \$60670 \$58454 \$61141 NWELL PWELL BULK NAND2_X1
X$133592 \$58458 \$58882 \$59305 \$59436 \$58894 NWELL PWELL BULK OAI211_X4
X$133594 \$58882 \$58458 \$59821 NWELL PWELL BULK NAND2_X1
X$133596 \$58458 \$60375 NWELL PWELL BULK INV_X1
X$133602 \$58881 \$58458 \$59414 \$59794 NWELL PWELL BULK AND3_X1
X$133606 \$59414 \$58458 \$58881 \$59807 NWELL PWELL BULK NAND3_X1
X$133608 \$61822 \$58458 \$62582 NWELL PWELL BULK NAND2_X1
X$133620 \$60379 \$60000 \$60004 \$59439 \$58465 NWELL PWELL BULK NOR4_X1
X$133623 \$58896 \$58897 \$59318 \$58785 \$58899 \$59324 \$58467 NWELL PWELL
+ BULK OAI33_X1
X$133628 \$58467 \$58909 \$59443 NWELL PWELL BULK NAND2_X1
X$133767 \$58481 \$59914 \$58917 NWELL PWELL BULK OR2_X1
X$133789 \$58496 \$59253 \$59262 \$58709 NWELL PWELL BULK MUX2_X1
X$133798 \$58935 \$59253 \$58497 \$59250 NWELL PWELL BULK MUX2_X1
X$133810 \$62976 \$62850 \$58514 NWELL PWELL BULK NOR2_X2
X$133850 \$I177111 \$58537 \$58968 \$58969 NWELL PWELL BULK DFF_X1
X$133861 \$I177064 \$58538 \$58972 \$58969 NWELL PWELL BULK DFF_X1
X$133867 \$59053 \$58550 \$60469 NWELL PWELL BULK NOR2_X2
X$133883 \$59010 S0_AXI_WDATA[15] NWELL PWELL BULK BUF_X1
X$133888 M2_AXI_WDATA[19] \$59508 NWELL PWELL BULK BUF_X1
X$133898 \$58566 \$58860 \$66172 \$65583 NWELL PWELL BULK MUX2_X1
X$133997 \$58691 \$70514 \$73493 \$72919 NWELL PWELL BULK OAI21_X1
X$134000 \$70521 \$58691 \$71913 \$72398 NWELL PWELL BULK OAI21_X1
X$134002 \$58691 \$71173 \$72906 \$73235 NWELL PWELL BULK OAI21_X1
X$134005 \$58691 \$71156 \$71345 \$71155 NWELL PWELL BULK OAI21_X1
X$134073 \$59426 \$59819 \$59407 \$58785 NWELL PWELL BULK AOI21_X2
X$134082 \$58896 \$58897 \$59841 \$58785 \$58899 \$59850 \$59440 NWELL PWELL
+ BULK OAI33_X1
X$134095 M2_AXI_AWLEN[3] \$59638 NWELL PWELL BULK BUF_X1
X$134104 \$59360 S0_AXI_AWADDR[7] NWELL PWELL BULK BUF_X1
X$134121 \$I174598 \$58833 \$58831 \$59544 NWELL PWELL BULK DFF_X1
X$134132 \$I178960 \$58839 \$59568 \$59565 NWELL PWELL BULK DFF_X1
X$134140 \$I178999 \$59580 \$58840 \$59565 NWELL PWELL BULK DFF_X1
X$134145 M2_AXI_AWID[0] \$58845 NWELL PWELL BULK BUF_X1
X$134163 \$71500 \$58860 \$71346 \$70687 NWELL PWELL BULK MUX2_X1
X$134168 \$80438 \$58860 \$80077 \$80587 NWELL PWELL BULK MUX2_X1
X$134170 \$82340 \$58860 \$81962 \$81958 NWELL PWELL BULK MUX2_X1
X$134172 \$62771 \$58860 \$66892 \$66893 NWELL PWELL BULK MUX2_X1
X$134175 \$67599 \$58860 \$68180 \$67872 NWELL PWELL BULK MUX2_X1
X$134178 \$65678 \$58860 \$68792 \$69435 NWELL PWELL BULK MUX2_X1
X$134181 \$82531 \$58860 \$83425 \$83941 NWELL PWELL BULK MUX2_X1
X$134184 \$83418 \$58860 \$83540 \$83538 NWELL PWELL BULK MUX2_X1
X$134186 \$78418 \$58860 \$78782 \$78781 NWELL PWELL BULK MUX2_X1
X$134188 \$76191 \$58860 \$78017 \$78137 NWELL PWELL BULK MUX2_X1
X$134191 \$80558 \$58860 \$81237 \$80922 NWELL PWELL BULK MUX2_X1
X$134193 \$81137 \$58860 \$81244 \$81419 NWELL PWELL BULK MUX2_X1
X$134195 \$78978 \$58860 \$80073 \$79856 NWELL PWELL BULK MUX2_X1
X$134199 \$71843 \$58860 \$71680 \$72036 NWELL PWELL BULK MUX2_X1
X$134201 \$71489 \$58860 \$70794 \$70792 NWELL PWELL BULK MUX2_X1
X$134204 \$73552 \$58860 \$75007 \$74999 NWELL PWELL BULK MUX2_X1
X$134212 \$59693 \$58860 \$59393 \$59691 NWELL PWELL BULK MUX2_X1
X$134214 \$81423 \$58860 \$82310 \$82312 NWELL PWELL BULK MUX2_X1
X$134216 \$82647 \$58860 \$82642 \$82869 NWELL PWELL BULK MUX2_X1
X$134218 \$76185 \$58860 \$77150 \$77148 NWELL PWELL BULK MUX2_X1
X$134220 \$80828 \$58860 \$81928 \$81425 NWELL PWELL BULK MUX2_X1
X$134222 \$75701 \$58860 \$76007 \$75549 NWELL PWELL BULK MUX2_X1
X$134224 \$76861 \$58860 \$77259 \$77158 NWELL PWELL BULK MUX2_X1
X$134226 \$79325 \$58860 \$79734 \$80202 NWELL PWELL BULK MUX2_X1
X$134228 \$79740 \$58860 \$79866 \$79863 NWELL PWELL BULK MUX2_X1
X$134230 \$78290 \$58860 \$78104 \$78106 NWELL PWELL BULK MUX2_X1
X$134232 \$83430 \$58860 \$83625 \$83431 NWELL PWELL BULK MUX2_X1
X$134235 \$82885 \$58860 \$83022 \$83311 NWELL PWELL BULK MUX2_X1
X$134237 \$73105 \$58860 \$73308 \$72826 NWELL PWELL BULK MUX2_X1
X$134239 \$72556 \$58860 \$72070 \$71498 NWELL PWELL BULK MUX2_X1
X$134242 \$74832 \$58860 \$74199 \$74407 NWELL PWELL BULK MUX2_X1
X$134245 \$69458 \$58860 \$70694 \$70455 NWELL PWELL BULK MUX2_X1
X$134248 \$64018 \$58860 \$68141 \$68138 NWELL PWELL BULK MUX2_X1
X$134251 \$65578 \$58860 \$64705 \$66275 NWELL PWELL BULK MUX2_X1
X$134253 \$75838 \$58860 \$76195 \$76652 NWELL PWELL BULK MUX2_X1
X$134255 \$71859 \$58860 \$71114 \$71858 NWELL PWELL BULK MUX2_X1
X$134257 \$78027 \$58860 \$78026 \$78180 NWELL PWELL BULK MUX2_X1
X$134334 \$59402 \$58874 \$60219 \$59236 NWELL PWELL BULK HA_X1
X$134346 \$58877 \$59799 \$59794 \$58893 \$58888 NWELL PWELL BULK OAI22_X4
X$134349 \$60359 \$58877 \$59270 NWELL PWELL BULK NOR2_X2
X$134351 \$60364 \$60684 \$60359 \$59839 \$58877 NWELL PWELL BULK OAI22_X4
X$134353 \$61823 \$58877 \$63395 \$62588 \$59321 NWELL PWELL BULK AOI211_X2
X$134358 \$58877 \$61823 \$61052 NWELL PWELL BULK OR2_X1
X$134361 \$62593 \$61826 \$61024 \$58877 \$61155 \$60252 NWELL PWELL BULK
+ OAI221_X2
X$134377 \$59752 \$59259 \$59762 \$59758 \$58878 \$59248 NWELL PWELL BULK
+ OAI221_X1
X$134381 \$60232 \$60671 \$58880 \$60672 NWELL PWELL BULK NAND3_X1
X$134383 \$61138 \$58880 \$60352 \$61538 NWELL PWELL BULK AOI21_X1
X$134385 \$61137 \$58880 \$61560 NWELL PWELL BULK NOR2_X1
X$134387 \$61136 \$59405 \$61143 \$58880 NWELL PWELL BULK DFF_X2
X$134389 \$58880 \$59978 NWELL PWELL BULK INV_X1
X$134403 \$59839 \$58881 \$59980 \$61021 NWELL PWELL BULK MUX2_X1
X$134407 \$60679 \$58881 \$59414 \$60597 NWELL PWELL BULK AOI21_X1
X$134410 \$60684 \$60364 \$58881 \$60686 NWELL PWELL BULK NOR3_X1
X$134412 \$61819 \$60232 \$59871 \$58881 \$62214 NWELL PWELL BULK NAND4_X1
X$134414 \$61583 \$58881 \$61147 NWELL PWELL BULK NAND2_X1
X$134418 \$59778 \$60352 \$58881 \$61148 NWELL PWELL BULK OAI21_X1
X$134420 \$61148 \$60671 \$59285 \$58881 \$61600 NWELL PWELL BULK AOI22_X1
X$134438 \$58882 \$60679 \$60369 NWELL PWELL BULK NOR2_X1
X$134443 \$58882 \$61560 \$60345 \$61133 NWELL PWELL BULK OAI21_X1
X$134446 \$60352 \$58882 \$60232 NWELL PWELL BULK NOR2_X1
X$134448 \$60670 \$60345 \$58882 \$61538 \$61536 NWELL PWELL BULK OAI22_X1
X$134450 \$60352 \$58882 \$60345 \$60348 NWELL PWELL BULK AOI21_X1
X$134453 \$62580 \$61144 \$58882 \$61821 NWELL PWELL BULK OAI21_X1
X$134466 \$59283 \$58888 NWELL PWELL BULK INV_X1
X$134478 \$59821 \$59430 \$58890 \$59819 NWELL PWELL BULK AOI21_X1
X$134482 \$63714 \$63709 \$64610 \$58891 NWELL PWELL BULK NAND3_X4
X$134491 \$62819 \$58891 \$62817 \$60684 NWELL PWELL BULK NAND3_X2
X$134493 \$62817 \$58891 \$62819 \$61155 NWELL PWELL BULK AND3_X2
X$134511 \$58893 \$59436 \$59839 \$59439 NWELL PWELL BULK OAI21_X4
X$134518 \$60364 \$60684 \$58894 \$60366 \$61048 NWELL PWELL BULK OAI22_X2
X$134520 \$60597 \$58894 \$59428 \$60258 NWELL PWELL BULK OAI21_X2
X$134522 \$58894 \$60366 \$60352 NWELL PWELL BULK NOR2_X2
X$134529 \$59839 \$59436 \$58896 NWELL PWELL BULK NOR2_X1
X$134534 \$61160 \$59774 \$59321 \$61163 \$60679 \$58897 NWELL PWELL BULK
+ AOI221_X2
X$134539 \$58897 \$58909 \$59439 \$61658 NWELL PWELL BULK AND3_X4
X$134547 \$60367 \$61048 \$58899 NWELL PWELL BULK NOR2_X1
X$134553 \$60691 \$59871 \$58900 NWELL PWELL BULK NOR2_X1
X$134559 \$61160 \$59774 \$59321 \$61157 \$60679 \$58901 NWELL PWELL BULK
+ AOI221_X2
X$134576 \$58909 \$60382 \$60385 NWELL PWELL BULK NAND2_X1
X$134578 \$59440 \$58909 \$60312 NWELL PWELL BULK NAND2_X1
X$134588 \$60285 \$59835 \$59839 \$60370 \$59998 \$59871 \$58914 NWELL PWELL
+ BULK OAI222_X2
X$134592 \$60382 \$58914 \$59999 \$60706 NWELL PWELL BULK AND3_X1
X$134594 \$58914 \$60382 \$59999 \$60310 NWELL PWELL BULK NAND3_X4
X$134618 \$I176472 \$58925 \$59917 \$59450 NWELL PWELL BULK DFF_X1
X$134620 \$74896 \$58929 \$75602 \$75744 NWELL PWELL BULK MUX2_X1
X$134622 \$75897 \$58929 \$75898 \$76115 NWELL PWELL BULK MUX2_X1
X$134624 \$74272 \$58929 \$74258 \$74269 NWELL PWELL BULK MUX2_X1
X$134627 \$73145 \$58929 \$73482 \$73869 NWELL PWELL BULK MUX2_X1
X$134630 \$73478 \$58929 \$74726 \$73887 NWELL PWELL BULK MUX2_X1
X$134633 \$74043 \$58929 \$74677 \$74254 NWELL PWELL BULK MUX2_X1
X$134636 \$69915 \$58929 \$69920 \$70383 NWELL PWELL BULK MUX2_X1
X$134639 \$67629 \$58929 \$67751 \$67633 NWELL PWELL BULK MUX2_X1
X$134642 \$67030 \$58929 \$67029 \$67508 NWELL PWELL BULK MUX2_X1
X$134644 \$60714 \$58929 \$61742 \$61210 NWELL PWELL BULK MUX2_X1
X$134646 \$62251 \$58929 \$61876 \$62036 NWELL PWELL BULK MUX2_X1
X$134649 \$80469 \$58929 \$80525 \$80987 NWELL PWELL BULK MUX2_X1
X$134651 \$82267 \$58929 \$82606 \$82605 NWELL PWELL BULK MUX2_X1
X$134653 \$77512 \$58929 \$78200 \$78203 NWELL PWELL BULK MUX2_X1
X$134655 \$76930 \$58929 \$77041 \$76579 NWELL PWELL BULK MUX2_X1
X$134657 \$79059 \$58929 \$78364 \$78844 NWELL PWELL BULK MUX2_X1
X$134659 \$82255 \$58929 \$83514 \$84035 NWELL PWELL BULK MUX2_X1
X$134661 \$82449 \$58929 \$83511 \$83637 NWELL PWELL BULK MUX2_X1
X$134663 \$68331 \$58929 \$68683 \$68856 NWELL PWELL BULK MUX2_X1
X$134665 \$78223 \$58929 \$77773 \$77931 NWELL PWELL BULK MUX2_X1
X$134667 \$69912 \$58929 \$69913 \$70400 NWELL PWELL BULK MUX2_X1
X$134671 \$59892 \$58929 \$60236 \$60026 NWELL PWELL BULK MUX2_X1
X$134674 \$59462 \$58929 \$60217 \$59463 NWELL PWELL BULK MUX2_X1
X$134677 \$76265 \$58929 \$76268 \$76269 NWELL PWELL BULK MUX2_X1
X$134679 \$65620 \$58929 \$65621 \$65048 NWELL PWELL BULK MUX2_X1
X$134681 \$72301 \$58929 \$72302 \$72408 NWELL PWELL BULK MUX2_X1
X$134684 \$71537 \$58929 \$71740 \$71408 NWELL PWELL BULK MUX2_X1
X$134686 \$71149 \$58929 \$70981 \$71393 NWELL PWELL BULK MUX2_X1
X$134689 \$76533 \$58929 \$77025 \$77028 NWELL PWELL BULK MUX2_X1
X$134692 \$79017 \$58929 \$79066 \$79438 NWELL PWELL BULK MUX2_X1
X$134695 \$78366 \$58929 \$79527 \$79190 NWELL PWELL BULK MUX2_X1
X$134697 \$78336 \$58929 \$78370 \$78526 NWELL PWELL BULK MUX2_X1
X$134699 \$82235 \$58929 \$83506 \$83505 NWELL PWELL BULK MUX2_X1
X$134702 \$81211 \$58929 \$81643 \$81524 NWELL PWELL BULK MUX2_X1
X$134704 \$81673 \$58929 \$81889 \$82394 NWELL PWELL BULK MUX2_X1
X$134706 \$80161 \$58929 \$80162 \$80163 NWELL PWELL BULK MUX2_X1
X$134709 \$80165 \$58929 \$80281 \$80288 NWELL PWELL BULK MUX2_X1
X$134711 \$80993 \$58929 \$81662 \$81995 NWELL PWELL BULK MUX2_X1
X$134754 \$61209 \$58931 \$60714 \$61766 NWELL PWELL BULK MUX2_X1
X$134757 \$60411 \$58931 \$59462 \$60936 NWELL PWELL BULK MUX2_X1
X$134759 \$61875 \$58931 \$62251 \$62745 NWELL PWELL BULK MUX2_X1
X$134763 \$60405 \$58931 \$59892 \$60022 NWELL PWELL BULK MUX2_X1
X$134766 \$61201 \$58931 NWELL PWELL BULK BUF_X8
X$134774 \$74896 \$58932 \$74897 \$75069 NWELL PWELL BULK MUX2_X1
X$134776 \$72301 \$58932 \$72955 \$72960 NWELL PWELL BULK MUX2_X1
X$134779 \$71537 \$58932 \$72297 \$72625 NWELL PWELL BULK MUX2_X1
X$134781 \$71149 \$58932 \$71150 \$71737 NWELL PWELL BULK MUX2_X1
X$134783 \$68331 \$58932 \$68465 \$68311 NWELL PWELL BULK MUX2_X1
X$134786 \$59892 \$58932 \$60521 \$60945 NWELL PWELL BULK MUX2_X1
X$134788 \$62251 \$58932 \$62839 \$63150 NWELL PWELL BULK MUX2_X1
X$134792 \$80469 \$58932 \$80527 \$80628 NWELL PWELL BULK MUX2_X1
X$134794 \$82235 \$58932 \$83073 \$82773 NWELL PWELL BULK MUX2_X1
X$134796 \$76930 \$58932 \$76263 \$76262 NWELL PWELL BULK MUX2_X1
X$134798 \$76533 \$58932 \$77224 \$77225 NWELL PWELL BULK MUX2_X1
X$134801 \$80161 \$58932 \$81204 \$81670 NWELL PWELL BULK MUX2_X1
X$134805 \$79059 \$58932 \$78724 \$78853 NWELL PWELL BULK MUX2_X1
X$134808 \$76265 \$58932 \$77523 \$77228 NWELL PWELL BULK MUX2_X1
X$134811 \$82267 \$58932 \$82935 \$82607 NWELL PWELL BULK MUX2_X1
X$134814 \$82255 \$58932 \$83516 \$83221 NWELL PWELL BULK MUX2_X1
X$134816 \$67030 \$58932 \$66337 \$66651 NWELL PWELL BULK MUX2_X1
X$134820 \$65620 \$58932 \$66017 \$65624 NWELL PWELL BULK MUX2_X1
X$134822 \$69912 \$58932 \$70842 \$71405 NWELL PWELL BULK MUX2_X1
X$134824 \$67629 \$58932 \$67929 \$68279 NWELL PWELL BULK MUX2_X1
X$134827 \$59462 \$58932 \$59466 \$58936 NWELL PWELL BULK MUX2_X1
X$134829 \$60714 \$58932 \$61734 \$61211 NWELL PWELL BULK MUX2_X1
X$134831 \$74043 \$58932 \$75722 \$75724 NWELL PWELL BULK MUX2_X1
X$134833 \$74272 \$58932 \$75423 \$75434 NWELL PWELL BULK MUX2_X1
X$134835 \$73145 \$58932 \$73861 \$73484 NWELL PWELL BULK MUX2_X1
X$134838 \$69915 \$58932 \$69656 \$70357 NWELL PWELL BULK MUX2_X1
X$134840 \$73478 \$58932 \$74460 \$73479 NWELL PWELL BULK MUX2_X1
X$134843 \$75897 \$58932 \$75731 \$75606 NWELL PWELL BULK MUX2_X1
X$134845 \$77512 \$58932 \$77778 \$77893 NWELL PWELL BULK MUX2_X1
X$134848 \$79017 \$58932 \$79441 \$79439 NWELL PWELL BULK MUX2_X1
X$134851 \$78366 \$58932 \$78535 \$78367 NWELL PWELL BULK MUX2_X1
X$134855 \$78336 \$58932 \$78371 \$78514 NWELL PWELL BULK MUX2_X1
X$134857 \$81211 \$58932 \$81212 \$81294 NWELL PWELL BULK MUX2_X1
X$134860 \$81673 \$58932 \$83093 \$83315 NWELL PWELL BULK MUX2_X1
X$134863 \$82449 \$58932 \$82600 \$83218 NWELL PWELL BULK MUX2_X1
X$134868 \$80165 \$58932 \$80521 \$80665 NWELL PWELL BULK MUX2_X1
X$134870 \$80993 \$58932 \$80990 \$80991 NWELL PWELL BULK MUX2_X1
X$134872 \$78223 \$58932 \$78073 \$78212 NWELL PWELL BULK MUX2_X1
X$134926 \$74896 \$58933 \$75445 \$75442 NWELL PWELL BULK MUX2_X1
X$134928 \$73145 \$58933 \$74465 \$74463 NWELL PWELL BULK MUX2_X1
X$134931 \$75897 \$58933 \$75605 \$76128 NWELL PWELL BULK MUX2_X1
X$134933 \$72301 \$58933 \$72632 \$73852 NWELL PWELL BULK MUX2_X1
X$134935 \$71537 \$58933 \$72138 \$71907 NWELL PWELL BULK MUX2_X1
X$134937 \$73478 \$58933 \$73881 \$73016 NWELL PWELL BULK MUX2_X1
X$134940 \$74043 \$58933 \$76103 \$75419 NWELL PWELL BULK MUX2_X1
X$134943 \$68331 \$58933 \$69278 \$69489 NWELL PWELL BULK MUX2_X1
X$134945 \$69915 \$58933 \$69283 \$69282 NWELL PWELL BULK MUX2_X1
X$134948 \$71149 \$58933 \$70976 \$70971 NWELL PWELL BULK MUX2_X1
X$134950 \$65620 \$58933 \$65950 \$65623 NWELL PWELL BULK MUX2_X1
X$134953 \$67629 \$58933 \$67928 \$68469 NWELL PWELL BULK MUX2_X1
X$134955 \$59892 \$58933 \$59889 \$60027 NWELL PWELL BULK MUX2_X1
X$134958 \$62251 \$58933 \$63148 \$63149 NWELL PWELL BULK MUX2_X1
X$134961 \$80161 \$58933 \$81004 \$81007 NWELL PWELL BULK MUX2_X1
X$134964 \$80469 \$58933 \$80621 \$80627 NWELL PWELL BULK MUX2_X1
X$134966 \$81211 \$58933 \$81525 \$81636 NWELL PWELL BULK MUX2_X1
X$134968 \$81673 \$58933 \$83100 \$83103 NWELL PWELL BULK MUX2_X1
X$134971 \$82235 \$58933 \$82929 \$83078 NWELL PWELL BULK MUX2_X1
X$134974 \$79017 \$58933 \$79506 \$79178 NWELL PWELL BULK MUX2_X1
X$134976 \$76265 \$58933 \$77324 \$77619 NWELL PWELL BULK MUX2_X1
X$134978 \$78336 \$58933 \$78516 \$78518 NWELL PWELL BULK MUX2_X1
X$134981 \$82255 \$58933 \$83894 \$83896 NWELL PWELL BULK MUX2_X1
X$134983 \$82449 \$58933 \$82763 \$83071 NWELL PWELL BULK MUX2_X1
X$134986 \$67030 \$58933 \$66741 \$67033 NWELL PWELL BULK MUX2_X1
X$134988 \$69912 \$58933 \$70690 \$70691 NWELL PWELL BULK MUX2_X1
X$134992 \$59462 \$58933 \$59468 \$60211 NWELL PWELL BULK MUX2_X1
X$134994 \$60714 \$58933 \$60409 \$60517 NWELL PWELL BULK MUX2_X1
X$134996 \$74272 \$58933 \$74900 \$75062 NWELL PWELL BULK MUX2_X1
X$134998 \$76533 \$58933 \$77519 \$77879 NWELL PWELL BULK MUX2_X1
X$135001 \$77512 \$58933 \$77890 \$77513 NWELL PWELL BULK MUX2_X1
X$135005 \$80165 \$58933 \$80167 \$80170 NWELL PWELL BULK MUX2_X1
X$135007 \$78366 \$58933 \$78537 \$78543 NWELL PWELL BULK MUX2_X1
X$135009 \$76930 \$58933 \$76933 \$77039 NWELL PWELL BULK MUX2_X1
X$135011 \$82267 \$58933 \$82348 \$82346 NWELL PWELL BULK MUX2_X1
X$135013 \$80993 \$58933 \$81892 \$81893 NWELL PWELL BULK MUX2_X1
X$135016 \$79059 \$58933 \$79212 \$79216 NWELL PWELL BULK MUX2_X1
X$135019 \$78223 \$58933 \$77918 \$77919 NWELL PWELL BULK MUX2_X1
X$135078 \$76141 \$58937 \$76134 \$76136 NWELL PWELL BULK MUX2_X1
X$135080 \$76261 \$58937 \$75608 \$76786 NWELL PWELL BULK MUX2_X1
X$135083 \$74048 \$58937 \$74902 \$75222 NWELL PWELL BULK MUX2_X1
X$135085 \$73147 \$58937 \$73850 \$73489 NWELL PWELL BULK MUX2_X1
X$135088 \$72996 \$58937 \$71736 \$72994 NWELL PWELL BULK MUX2_X1
X$135090 \$72428 \$58937 \$72424 \$73002 NWELL PWELL BULK MUX2_X1
X$135092 \$75224 \$58937 \$76102 \$77024 NWELL PWELL BULK MUX2_X1
X$135094 \$70490 \$58937 \$70985 \$70991 NWELL PWELL BULK MUX2_X1
X$135096 \$69921 \$58937 \$70356 \$70350 NWELL PWELL BULK MUX2_X1
X$135098 \$66193 \$58937 \$66183 \$66192 NWELL PWELL BULK MUX2_X1
X$135100 \$67031 \$58937 \$67516 \$67757 NWELL PWELL BULK MUX2_X1
X$135105 \$62751 \$61877 \$58937 \$61230 NWELL PWELL BULK MUX2_X2
X$135110 \$81006 \$58937 \$81320 \$81517 NWELL PWELL BULK MUX2_X1
X$135112 \$80643 \$58937 \$80624 \$80260 NWELL PWELL BULK MUX2_X1
X$135114 \$81977 \$58937 \$82347 \$82737 NWELL PWELL BULK MUX2_X1
X$135116 \$77222 \$58937 \$77872 \$78368 NWELL PWELL BULK MUX2_X1
X$135119 \$84485 \$58937 \$83617 \$84280 NWELL PWELL BULK MUX2_X1
X$135121 \$80518 \$58937 \$80666 \$82260 NWELL PWELL BULK MUX2_X1
X$135123 \$82933 \$58937 \$83273 \$83281 NWELL PWELL BULK MUX2_X1
X$135125 \$68468 \$58937 \$68674 \$68675 NWELL PWELL BULK MUX2_X1
X$135128 \$69741 \$58937 \$69653 \$70390 NWELL PWELL BULK MUX2_X1
X$135130 \$74461 \$58937 \$74698 \$75067 NWELL PWELL BULK MUX2_X1
X$135133 \$74893 \$58937 \$75074 \$75453 NWELL PWELL BULK MUX2_X1
X$135136 \$77328 \$58937 \$77857 \$77867 NWELL PWELL BULK MUX2_X1
X$135138 \$77218 \$58937 \$77632 \$77640 NWELL PWELL BULK MUX2_X1
X$135141 \$79182 \$58937 \$79507 \$79180 NWELL PWELL BULK MUX2_X1
X$135143 \$79919 \$58937 \$80253 \$80263 NWELL PWELL BULK MUX2_X1
X$135146 \$79433 \$58937 \$79531 \$82381 NWELL PWELL BULK MUX2_X1
X$135149 \$82928 \$58937 \$83498 \$83883 NWELL PWELL BULK MUX2_X1
X$135151 \$83504 \$58937 \$84279 \$84612 NWELL PWELL BULK MUX2_X1
X$135153 \$83510 \$58937 \$82601 \$84560 NWELL PWELL BULK MUX2_X1
X$135155 \$82261 \$58937 \$81985 \$82598 NWELL PWELL BULK MUX2_X1
X$135157 \$78070 \$58937 \$78072 \$78361 NWELL PWELL BULK MUX2_X1
X$135160 \$79205 \$58937 \$79208 \$79207 NWELL PWELL BULK MUX2_X1
X$135162 \$78363 \$58937 \$78199 \$78074 NWELL PWELL BULK MUX2_X1
X$135223 M0_AXI_WDATA[8] \$58940 NWELL PWELL BULK CLKBUF_X2
X$135238 \$61881 \$60506 \$58952 NWELL PWELL BULK NOR2_X2
X$135268 \$I177334 \$60140 \$60143 \$58969 NWELL PWELL BULK DFF_X1
X$135270 \$I177416 \$60754 \$61450 \$58969 NWELL PWELL BULK DFF_X1
X$135272 \$I177292 \$61243 \$61899 \$58969 NWELL PWELL BULK DFF_X1
X$135278 \$I177121 \$59493 \$59622 \$58969 NWELL PWELL BULK DFF_X1
X$135281 \$I175142 \$63487 \$62859 \$58969 NWELL PWELL BULK DFF_X1
X$135283 \$I176751 \$64785 \$65277 \$58969 NWELL PWELL BULK DFF_X1
X$135286 \$I177049 \$62872 \$63178 \$58969 NWELL PWELL BULK DFF_X1
X$135288 \$I175769 \$63180 \$63491 \$58969 NWELL PWELL BULK DFF_X1
X$135290 \$I177061 \$62868 \$62935 \$58969 NWELL PWELL BULK DFF_X1
X$135292 \$I177106 \$64105 \$64541 \$58969 NWELL PWELL BULK DFF_X1
X$135295 \$I177093 \$64436 \$64437 \$58969 NWELL PWELL BULK DFF_X1
X$135298 \$I177045 \$64532 \$64823 \$58969 NWELL PWELL BULK DFF_X1
X$135301 \$I175914 \$64786 \$65245 \$58969 NWELL PWELL BULK DFF_X1
X$135303 \$I175989 \$64441 \$64529 \$58969 NWELL PWELL BULK DFF_X1
X$135305 \$I175815 \$62468 \$62471 \$58969 NWELL PWELL BULK DFF_X1
X$135307 \$I174977 \$59629 \$59634 \$58969 NWELL PWELL BULK DFF_X1
X$135309 \$I175849 \$60490 \$60488 \$58969 NWELL PWELL BULK DFF_X1
X$135312 \$I175917 \$60130 \$60483 \$58969 NWELL PWELL BULK DFF_X1
X$135315 \$I175817 \$61251 \$61973 \$58969 NWELL PWELL BULK DFF_X1
X$135318 \$I175897 \$61411 \$60834 \$58969 NWELL PWELL BULK DFF_X1
X$135321 \$I175911 \$61907 \$62493 \$58969 NWELL PWELL BULK DFF_X1
X$135324 \$I175932 \$63490 \$63634 \$58969 NWELL PWELL BULK DFF_X1
X$135326 \$I175014 \$64434 \$64832 \$58969 NWELL PWELL BULK DFF_X1
X$135328 \$I177075 \$62864 \$62947 \$58969 NWELL PWELL BULK DFF_X1
X$135330 \$I175837 \$63172 \$63171 \$58969 NWELL PWELL BULK DFF_X1
X$135333 \$I175843 \$61903 \$61429 \$58969 NWELL PWELL BULK DFF_X1
X$135335 \$I175848 \$62281 \$62521 \$58969 NWELL PWELL BULK DFF_X1
X$135338 \$I175845 \$62284 \$62509 \$58969 NWELL PWELL BULK DFF_X1
X$135341 \$62420 \$58969 NWELL PWELL BULK BUF_X4
X$135367 \$59059 \$58976 \$59055 NWELL PWELL BULK NOR2_X2
X$135373 \$I177213 \$58980 \$60098 \$59506 NWELL PWELL BULK DFF_X1
X$135380 M0_AXI_WDATA[15] \$59507 NWELL PWELL BULK CLKBUF_X2
X$135385 M2_AXI_WDATA[12] \$59004 NWELL PWELL BULK CLKBUF_X2
X$135434 \$59042 \$59567 \$59041 NWELL PWELL BULK NOR2_X2
X$135438 \$59041 \$70514 \$77795 \$77810 NWELL PWELL BULK OAI21_X1
X$135441 \$70521 \$59041 \$78089 \$78088 NWELL PWELL BULK OAI21_X1
X$135443 \$59041 \$71173 \$78390 \$78772 NWELL PWELL BULK OAI21_X1
X$135447 \$59041 \$71156 \$78787 \$78748 NWELL PWELL BULK OAI21_X1
X$135464 \$59055 \$71156 \$74083 \$74127 NWELL PWELL BULK OAI21_X1
X$135466 \$59055 \$70514 \$73179 \$73522 NWELL PWELL BULK OAI21_X1
X$135468 \$70521 \$59055 \$72750 \$73208 NWELL PWELL BULK OAI21_X1
X$135470 \$59055 \$71173 \$74085 \$74084 NWELL PWELL BULK OAI21_X1
X$135620 \$73477 \$59253 \$74726 \$74893 NWELL PWELL BULK MUX2_X1
X$135623 \$72294 \$59253 \$71740 \$72428 NWELL PWELL BULK MUX2_X1
X$135625 \$68462 \$59253 \$68683 \$69741 NWELL PWELL BULK MUX2_X1
X$135628 \$70699 \$59253 \$69913 \$70490 NWELL PWELL BULK MUX2_X1
X$135630 \$65944 \$59253 \$65621 \$66193 NWELL PWELL BULK MUX2_X1
X$135632 \$66741 \$59253 \$66337 \$67516 NWELL PWELL BULK MUX2_X1
X$135634 \$69278 \$59253 \$68465 \$69653 NWELL PWELL BULK MUX2_X1
X$135637 \$67631 \$59253 \$67029 \$67031 NWELL PWELL BULK MUX2_X1
X$135640 \$60409 \$59253 \$61734 \$60727 NWELL PWELL BULK MUX2_X1
X$135647 \$81004 \$59253 \$81204 \$81320 NWELL PWELL BULK MUX2_X1
X$135649 \$83100 \$59253 \$83093 \$83498 NWELL PWELL BULK MUX2_X1
X$135651 \$77216 \$59253 \$77041 \$77218 NWELL PWELL BULK MUX2_X1
X$135653 \$65950 \$59253 \$66017 \$66183 NWELL PWELL BULK MUX2_X1
X$135656 \$59253 \$68283 NWELL PWELL BULK BUF_X16
X$135658 \$59468 \$59253 \$59466 \$60414 NWELL PWELL BULK MUX2_X1
X$135661 \$61209 \$59253 \$61742 \$61740 NWELL PWELL BULK MUX2_X1
X$135663 \$59889 \$59253 \$60521 \$60030 NWELL PWELL BULK MUX2_X1
X$135665 \$60405 \$59253 \$60236 \$60520 NWELL PWELL BULK MUX2_X1
X$135667 \$63148 \$59253 \$62839 \$61877 NWELL PWELL BULK MUX2_X1
X$135669 \$60411 \$59253 \$60217 \$60930 NWELL PWELL BULK MUX2_X1
X$135672 \$61875 \$59253 \$61876 \$62751 NWELL PWELL BULK MUX2_X1
X$135675 \$75605 \$59253 \$75731 \$75608 NWELL PWELL BULK MUX2_X1
X$135677 \$72138 \$59253 \$72297 \$72424 NWELL PWELL BULK MUX2_X1
X$135679 \$70690 \$59253 \$70842 \$70985 NWELL PWELL BULK MUX2_X1
X$135681 \$74465 \$59253 \$73861 \$74698 NWELL PWELL BULK MUX2_X1
X$135683 \$76444 \$59253 \$75898 \$76261 NWELL PWELL BULK MUX2_X1
X$135685 \$73480 \$59253 \$73482 \$74461 NWELL PWELL BULK MUX2_X1
X$135687 \$76142 \$59253 \$75602 \$76141 NWELL PWELL BULK MUX2_X1
X$135690 \$75445 \$59253 \$74897 \$76134 NWELL PWELL BULK MUX2_X1
X$135693 \$73881 \$59253 \$74460 \$75074 NWELL PWELL BULK MUX2_X1
X$135695 \$77890 \$59253 \$77778 \$78199 NWELL PWELL BULK MUX2_X1
X$135698 \$82256 \$59253 \$81889 \$82928 NWELL PWELL BULK MUX2_X1
X$135701 \$79812 \$59253 \$80162 \$81006 NWELL PWELL BULK MUX2_X1
X$135703 \$79212 \$59253 \$78724 \$79208 NWELL PWELL BULK MUX2_X1
X$135705 \$78360 \$59253 \$77773 \$78070 NWELL PWELL BULK MUX2_X1
X$135707 \$78840 \$59253 \$78364 \$79205 NWELL PWELL BULK MUX2_X1
X$135709 \$77775 \$59253 \$78200 \$78363 NWELL PWELL BULK MUX2_X1
X$135711 \$77918 \$59253 \$78073 \$78072 NWELL PWELL BULK MUX2_X1
X$135775 \$61583 \$59270 \$59285 \$61143 \$61819 NWELL PWELL BULK OAI22_X1
X$135777 \$62212 \$59270 \$62580 NWELL PWELL BULK NOR2_X1
X$135779 \$59270 \$60674 \$61570 \$61138 NWELL PWELL BULK AOI21_X1
X$135781 \$59978 \$59285 \$59270 \$59980 NWELL PWELL BULK MUX2_X1
X$135790 \$62219 \$60679 \$59283 NWELL PWELL BULK NAND2_X2
X$135806 \$60352 \$59285 \$60674 NWELL PWELL BULK NAND2_X1
X$135808 \$60232 \$60671 \$61137 \$59285 \$62073 NWELL PWELL BULK NAND4_X1
X$135810 \$62555 \$59405 \$61583 \$59285 NWELL PWELL BULK DFF_X2
X$135818 \$59778 \$59285 \$59985 NWELL PWELL BULK NOR2_X1
X$135825 \$59285 \$60353 NWELL PWELL BULK INV_X1
X$135829 \$59285 \$59774 \$59772 \$59762 NWELL PWELL BULK OAI21_X1
X$135863 \$66303 \$65999 \$59313 \$66716 NWELL PWELL BULK MUX2_X1
X$135865 \$59313 \$66724 \$65993 \$66614 NWELL PWELL BULK MUX2_X1
X$135867 \$59313 \$65879 \$65994 \$65607 NWELL PWELL BULK MUX2_X1
X$135870 \$67002 \$66312 \$59313 \$67395 NWELL PWELL BULK MUX2_X1
X$135906 S2_AXI_RID[3] \$59693 NWELL PWELL BULK CLKBUF_X2
X$135915 M2_AXI_AWADDR[9] \$59358 NWELL PWELL BULK BUF_X1
X$135939 \$I174610 \$59560 \$59365 \$59565 NWELL PWELL BULK DFF_X1
X$135997 \$60691 \$61157 \$62620 \$59405 NWELL PWELL BULK DFF_X1
X$135999 \$59998 \$61836 \$62621 \$59405 NWELL PWELL BULK DFF_X1
X$136002 \$I178851 \$61674 \$62636 \$59405 NWELL PWELL BULK DFF_X1
X$136004 \$I178879 \$63305 \$62823 \$59405 NWELL PWELL BULK DFF_X1
X$136006 \$I176301 \$63403 \$63318 \$59405 NWELL PWELL BULK DFF_X1
X$136009 \$I174617 \$63937 \$64259 \$59405 NWELL PWELL BULK DFF_X1
X$136012 \$I174500 \$63111 \$63112 \$59405 NWELL PWELL BULK DFF_X1
X$136015 \$I174438 \$63405 \$64272 \$59405 NWELL PWELL BULK DFF_X1
X$136018 \$I174377 \$63050 \$62223 \$59405 NWELL PWELL BULK DFF_X1
X$136021 \$I178872 \$62219 \$62220 \$59405 NWELL PWELL BULK DFF_X1
X$136023 \$I174361 \$64286 \$64284 \$59405 NWELL PWELL BULK DFF_X1
X$136026 \$I176015 \$63116 \$63787 \$59405 NWELL PWELL BULK DFF_X1
X$136028 \$I178880 \$62825 \$63049 \$59405 NWELL PWELL BULK DFF_X1
X$136030 \$I178892 \$64734 \$64911 \$59405 NWELL PWELL BULK DFF_X1
X$136033 \$I176311 \$64913 \$64916 \$59405 NWELL PWELL BULK DFF_X1
X$136035 \$I174422 \$63407 \$64737 \$59405 NWELL PWELL BULK DFF_X1
X$136038 \$I174386 \$65015 \$64738 \$59405 NWELL PWELL BULK DFF_X1
X$136040 \$I174531 \$59753 \$60227 \$59405 NWELL PWELL BULK DFF_X1
X$136046 \$I174413 \$59906 \$59902 \$59405 NWELL PWELL BULK DFF_X1
X$136048 \$I178682 \$64727 \$65004 \$59405 NWELL PWELL BULK DFF_X1
X$136051 \$I178689 \$65374 \$64724 \$59405 NWELL PWELL BULK DFF_X1
X$136054 \$I178690 \$65368 \$64381 \$59405 NWELL PWELL BULK DFF_X1
X$136056 \$I175583 \$63389 \$63388 \$59405 NWELL PWELL BULK DFF_X1
X$136059 \$I178679 \$63097 \$63391 \$59405 NWELL PWELL BULK DFF_X1
X$136061 \$I175539 \$63096 \$63390 \$59405 NWELL PWELL BULK DFF_X1
X$136064 \$I178796 \$62814 \$63928 \$59405 NWELL PWELL BULK DFF_X1
X$136067 \$62820 \$I169560 \$63401 \$59405 NWELL PWELL BULK DFF_X1
X$136094 \$59992 \$60593 \$60275 \$59407 \$60588 \$60000 NWELL PWELL BULK
+ AOI221_X2
X$136097 \$60232 \$59407 \$59758 NWELL PWELL BULK NAND2_X1
X$136122 \$61150 \$61155 \$59774 \$59430 \$59994 NWELL PWELL BULK AOI22_X4
X$136125 \$59430 \$59994 \$60670 NWELL PWELL BULK NAND2_X1
X$136128 \$59431 \$59430 \$59835 NWELL PWELL BULK NAND2_X1
X$136131 \$59430 \$59431 \$59992 NWELL PWELL BULK AND2_X1
X$136135 \$60369 \$59430 \$59994 \$60370 NWELL PWELL BULK NAND3_X1
X$136138 \$59994 \$59430 \$60369 \$60588 NWELL PWELL BULK AND3_X1
X$136160 \$60299 \$60000 \$60004 \$59439 \$59867 NWELL PWELL BULK NOR4_X1
X$136163 \$60004 \$59439 \$60382 NWELL PWELL BULK NOR2_X4
X$136195 \$I178896 \$63953 \$63128 \$59450 NWELL PWELL BULK DFF_X1
X$136198 \$63124 \$63125 \$63825 \$59450 NWELL PWELL BULK DFF_X1
X$136200 \$62829 \$62830 \$63047 \$59450 NWELL PWELL BULK DFF_X1
X$136203 \$I174347 \$64661 \$64902 \$59450 NWELL PWELL BULK DFF_X1
X$136206 \$I178011 \$64394 \$64655 \$59450 NWELL PWELL BULK DFF_X1
X$136208 \$I174337 \$63417 \$63415 \$59450 NWELL PWELL BULK DFF_X1
X$136210 \$I179114 \$63416 \$63119 \$59450 NWELL PWELL BULK DFF_X1
X$136212 \$64671 \$64666 \$64668 \$59450 NWELL PWELL BULK DFF_X1
X$136214 \$64398 \$64681 \$64678 \$59450 NWELL PWELL BULK DFF_X1
X$136216 \$I174325 \$62236 \$62703 \$59450 NWELL PWELL BULK DFF_X1
X$136219 \$I177623 \$60718 \$61758 \$59450 NWELL PWELL BULK DFF_X1
X$136221 \$64397 \$64326 \$64319 \$59450 NWELL PWELL BULK DFF_X1
X$136224 \$63421 \$63806 \$63420 \$59450 NWELL PWELL BULK DFF_X1
X$136226 \$63422 \$62828 \$63048 \$59450 NWELL PWELL BULK DFF_X1
X$136228 \$I178110 \$59912 \$60015 \$59450 NWELL PWELL BULK DFF_X1
X$136232 \$I178904 \$59919 \$60291 \$59450 NWELL PWELL BULK DFF_X1
X$136235 \$I176383 \$64401 \$64893 \$59450 NWELL PWELL BULK DFF_X1
X$136237 \$I177890 \$63432 \$63433 \$59450 NWELL PWELL BULK DFF_X1
X$136239 \$I174378 \$62240 \$62239 \$59450 NWELL PWELL BULK DFF_X1
X$136242 \$I177649 \$63429 \$63430 \$59450 NWELL PWELL BULK DFF_X1
X$136245 \$I177632 \$63834 \$63130 \$59450 NWELL PWELL BULK DFF_X1
X$136247 \$I174360 \$61865 \$62714 \$59450 NWELL PWELL BULK DFF_X1
X$136250 \$I174384 \$61862 \$62716 \$59450 NWELL PWELL BULK DFF_X1
X$136253 \$I176646 \$62705 \$62237 \$59450 NWELL PWELL BULK DFF_X1
X$136256 \$I176214 \$63133 \$63435 \$59450 NWELL PWELL BULK DFF_X1
X$136258 \$I177998 \$63956 \$64309 \$59450 NWELL PWELL BULK DFF_X1
X$136261 \$I177626 \$64897 \$65535 \$59450 NWELL PWELL BULK DFF_X1
X$136264 \$I177827 \$65038 \$65515 \$59450 NWELL PWELL BULK DFF_X1
X$136266 \$I174471 \$65039 \$65511 \$59450 NWELL PWELL BULK DFF_X1
X$136324 \$I175436 \$60038 \$59478 \$60037 NWELL PWELL BULK DFF_X1
X$136328 \$62009 \$60745 \$59482 NWELL PWELL BULK NOR2_X1
X$136343 \$I177130 \$59484 \$60748 \$60037 NWELL PWELL BULK DFF_X1
X$136350 \$70521 \$59490 \$72055 \$72318 NWELL PWELL BULK OAI21_X1
X$136352 \$59490 \$71173 \$73731 \$73735 NWELL PWELL BULK OAI21_X1
X$136354 \$59490 \$70514 \$73163 \$73742 NWELL PWELL BULK OAI21_X1
X$136356 \$59490 \$71156 \$74188 \$74071 NWELL PWELL BULK OAI21_X1
X$136382 \$59498 \$60471 \$60810 \$59506 NWELL PWELL BULK DFF_X1
X$136388 \$60812 \$60447 \$59499 NWELL PWELL BULK NOR2_X1
X$136404 \$I176987 \$59503 \$60107 \$59506 NWELL PWELL BULK DFF_X1
X$136411 \$60052 \$60441 \$60478 \$59506 NWELL PWELL BULK DFF_X1
X$136414 \$60119 \$59601 \$59611 \$59506 NWELL PWELL BULK DFF_X1
X$136416 \$I175816 \$60440 \$60823 \$59506 NWELL PWELL BULK DFF_X1
X$136418 \$64470 \$64033 \$64034 \$59506 NWELL PWELL BULK DFF_X1
X$136421 \$62902 \$62363 \$62298 \$59506 NWELL PWELL BULK DFF_X1
X$136423 \$64451 \$64005 \$64021 \$59506 NWELL PWELL BULK DFF_X1
X$136426 \$64791 \$65209 \$65211 \$59506 NWELL PWELL BULK DFF_X1
X$136429 \$65141 \$65098 \$64798 \$59506 NWELL PWELL BULK DFF_X1
X$136431 \$64449 \$64478 \$64482 \$59506 NWELL PWELL BULK DFF_X1
X$136433 \$64513 \$63991 \$64510 \$59506 NWELL PWELL BULK DFF_X1
X$136435 \$64819 \$65085 \$65225 \$59506 NWELL PWELL BULK DFF_X1
X$136438 \$I175380 \$61912 \$61909 \$59506 NWELL PWELL BULK DFF_X1
X$136440 \$I177139 \$61253 \$60762 \$59506 NWELL PWELL BULK DFF_X1
X$136443 \$I177141 \$60804 \$61366 \$59506 NWELL PWELL BULK DFF_X1
X$136446 \$60056 \$60111 \$60472 \$59506 NWELL PWELL BULK DFF_X1
X$136450 \$I177152 \$62920 \$63593 \$59506 NWELL PWELL BULK DFF_X1
X$136452 \$I174515 \$63183 \$63223 \$59506 NWELL PWELL BULK DFF_X1
X$136455 \$64444 \$64067 \$64065 \$59506 NWELL PWELL BULK DFF_X1
X$136457 \$63187 \$61916 \$62401 \$59506 NWELL PWELL BULK DFF_X1
X$136460 \$62420 \$59506 NWELL PWELL BULK BUF_X4
X$136463 \$63578 \$64050 \$64056 \$59506 NWELL PWELL BULK DFF_X1
X$136465 \$63218 \$62415 \$62916 \$59506 NWELL PWELL BULK DFF_X1
X$136471 \$I176259 \$60065 \$59529 \$59506 NWELL PWELL BULK DFF_X1
X$136473 \$I176988 \$60769 \$61342 \$59506 NWELL PWELL BULK DFF_X1
X$136475 \$62342 \$62304 \$62896 \$59506 NWELL PWELL BULK DFF_X1
X$136477 \$I175505 \$60774 \$61263 \$59506 NWELL PWELL BULK DFF_X1
X$136479 \$I175508 \$60771 \$61320 \$59506 NWELL PWELL BULK DFF_X1
X$136529 M2_AXI_WID[3] \$60806 NWELL PWELL BULK BUF_X1
X$136534 \$61230 M2_AXI_RID[0] NWELL PWELL BULK BUF_X1
X$136558 \$I174599 \$59540 \$59538 \$59544 NWELL PWELL BULK DFF_X1
X$136568 \$I174517 \$64940 \$65116 \$59544 NWELL PWELL BULK DFF_X1
X$136571 \$I179071 \$63513 \$63511 \$59544 NWELL PWELL BULK DFF_X1
X$136573 \$I179113 \$62899 \$63061 \$59544 NWELL PWELL BULK DFF_X1
X$136576 \$I174552 \$63532 \$63535 \$59544 NWELL PWELL BULK DFF_X1
X$136579 \$I174528 \$63059 \$64008 \$59544 NWELL PWELL BULK DFF_X1
X$136581 \$I179115 \$61786 \$62318 \$59544 NWELL PWELL BULK DFF_X1
X$136584 \$I179120 \$63883 \$64475 \$59544 NWELL PWELL BULK DFF_X1
X$136586 \$I179117 \$63545 \$64336 \$59544 NWELL PWELL BULK DFF_X1
X$136588 \$I174555 \$63879 \$64338 \$59544 NWELL PWELL BULK DFF_X1
X$136591 \$I174603 \$63066 \$63563 \$59544 NWELL PWELL BULK DFF_X1
X$136593 \$I179119 \$63063 \$63548 \$59544 NWELL PWELL BULK DFF_X1
X$136596 \$60318 \$59937 \$60077 \$59544 NWELL PWELL BULK DFF_X1
X$136598 \$61281 \$61290 \$61278 \$59544 NWELL PWELL BULK DFF_X1
X$136600 \$61300 \$61287 \$61077 \$59544 NWELL PWELL BULK DFF_X1
X$136602 \$60088 \$60082 \$59938 \$59544 NWELL PWELL BULK DFF_X1
X$136604 \$I179090 \$61076 \$61931 \$59544 NWELL PWELL BULK DFF_X1
X$136606 \$I179118 \$62329 \$62332 \$59544 NWELL PWELL BULK DFF_X1
X$136609 \$I174519 \$64481 \$64826 \$59544 NWELL PWELL BULK DFF_X1
X$136612 \$I179099 \$60322 \$59944 \$59544 NWELL PWELL BULK DFF_X1
X$136615 \$I179024 \$60633 \$60820 \$59544 NWELL PWELL BULK DFF_X1
X$136617 \$I174597 \$62162 \$62776 \$59544 NWELL PWELL BULK DFF_X1
X$136620 \$62164 \$59544 NWELL PWELL BULK BUF_X4
X$136622 \$I179008 \$60101 \$59942 \$59544 NWELL PWELL BULK DFF_X1
X$136625 \$I174602 \$61086 \$60816 \$59544 NWELL PWELL BULK DFF_X1
X$136627 \$I174329 \$62159 \$62344 \$59544 NWELL PWELL BULK DFF_X1
X$136632 \$I178932 \$61081 \$61303 \$59544 NWELL PWELL BULK DFF_X1
X$136635 \$I178933 \$61315 \$62359 \$59544 NWELL PWELL BULK DFF_X1
X$136638 \$I174308 \$61304 \$61943 \$59544 NWELL PWELL BULK DFF_X1
X$136640 \$I174314 \$60320 \$60811 \$59544 NWELL PWELL BULK DFF_X1
X$136681 \$I176423 \$62171 \$62405 \$59565 NWELL PWELL BULK DFF_X1
X$136684 \$I176420 \$64695 \$64855 \$59565 NWELL PWELL BULK DFF_X1
X$136687 \$I174661 \$64845 \$64847 \$59565 NWELL PWELL BULK DFF_X1
X$136689 \$I174662 \$64852 \$64693 \$59565 NWELL PWELL BULK DFF_X1
X$136692 \$I174615 \$64082 \$64074 \$59565 NWELL PWELL BULK DFF_X1
X$136695 \$I174674 \$64060 \$63573 \$59565 NWELL PWELL BULK DFF_X1
X$136698 \$I179029 \$62780 \$62779 \$59565 NWELL PWELL BULK DFF_X1
X$136701 \$I174675 \$63887 \$64057 \$59565 NWELL PWELL BULK DFF_X1
X$136703 \$I174646 \$61090 \$61349 \$59565 NWELL PWELL BULK DFF_X1
X$136706 \$I174644 \$61791 \$62374 \$59565 NWELL PWELL BULK DFF_X1
X$136708 \$I179028 \$62781 \$62934 \$59565 NWELL PWELL BULK DFF_X1
X$136710 \$I176394 \$63595 \$63067 \$59565 NWELL PWELL BULK DFF_X1
X$136712 \$I179031 \$63351 \$63590 \$59565 NWELL PWELL BULK DFF_X1
X$136715 \$I174647 \$64341 \$64834 \$59565 NWELL PWELL BULK DFF_X1
X$136718 \$I179030 \$62778 \$63228 \$59565 NWELL PWELL BULK DFF_X1
X$136721 \$I176422 \$63356 \$64089 \$59565 NWELL PWELL BULK DFF_X1
X$136723 \$I174658 \$64503 \$65165 \$59565 NWELL PWELL BULK DFF_X1
X$136725 \$I179106 \$59950 \$61359 \$59565 NWELL PWELL BULK DFF_X1
X$136728 \$I177956 \$59951 \$60505 \$59565 NWELL PWELL BULK DFF_X1
X$136733 \$I174611 \$59594 \$59593 \$59565 NWELL PWELL BULK DFF_X1
X$136735 \$I174651 \$60327 \$60848 \$59565 NWELL PWELL BULK DFF_X1
X$136737 \$I179025 \$59581 \$59948 \$59565 NWELL PWELL BULK DFF_X1
X$136739 \$I174649 \$60323 \$60324 \$59565 NWELL PWELL BULK DFF_X1
X$136742 \$62164 \$59565 NWELL PWELL BULK BUF_X4
X$136745 \$I176369 \$60638 \$61368 \$59565 NWELL PWELL BULK DFF_X1
X$136747 \$I174653 \$61793 \$62396 \$59565 NWELL PWELL BULK DFF_X1
X$136750 \$I179026 \$62165 \$62388 \$59565 NWELL PWELL BULK DFF_X1
X$136985 \$59753 \$59754 \$60345 NWELL PWELL BULK NOR2_X1
X$136987 \$59753 \$59973 NWELL PWELL BULK INV_X1
X$137028 \$59778 \$60679 \$61039 NWELL PWELL BULK NOR2_X1
X$137042 \$63706 \$59782 \$62205 \$63329 NWELL PWELL BULK MUX2_X1
X$137045 \$64716 \$59782 \$64990 \$I241565 NWELL PWELL BULK HA_X1
X$137047 \$59782 \$61811 \$62206 NWELL PWELL BULK NAND2_X1
X$137050 \$64377 \$59782 \$62538 \$64219 NWELL PWELL BULK MUX2_X1
X$137052 \$62538 \$59782 \$62535 \$62531 NWELL PWELL BULK MUX2_X1
X$137054 \$62205 \$59782 \$63011 \$62533 NWELL PWELL BULK MUX2_X1
X$137057 \$62207 \$59782 \$63091 NWELL PWELL BULK NAND2_X1
X$137060 \$59782 \$65338 NWELL PWELL BULK INV_X1
X$137063 \$59782 \$63331 \$63091 \$63713 NWELL PWELL BULK OAI21_X1
X$137132 \$60679 \$59871 NWELL PWELL BULK INV_X2
X$137138 \$59871 \$59998 \$60275 NWELL PWELL BULK NOR2_X1
X$137175 \$59890 \$62420 NWELL PWELL BULK BUF_X4
X$137179 \$59890 \$72902 NWELL PWELL BULK BUF_X4
X$137254 \$59941 S0_AXI_AWADDR[27] NWELL PWELL BULK BUF_X1
X$137259 M2_AXI_AWLEN[6] \$59960 NWELL PWELL BULK BUF_X1
X$137290 \$I177785 \$61097 \$61990 \$59956 NWELL PWELL BULK DFF_X1
X$137292 \$I174470 \$61096 \$61378 \$59956 NWELL PWELL BULK DFF_X1
X$137295 \$I177808 \$62173 \$62418 \$59956 NWELL PWELL BULK DFF_X1
X$137297 \$I177796 \$60877 \$60135 \$59956 NWELL PWELL BULK DFF_X1
X$137299 \$I177809 \$60329 \$60641 \$59956 NWELL PWELL BULK DFF_X1
X$137302 \$I177804 \$63897 \$64533 \$59956 NWELL PWELL BULK DFF_X1
X$137305 \$I176431 \$64357 \$64356 \$59956 NWELL PWELL BULK DFF_X1
X$137307 \$62164 \$59956 NWELL PWELL BULK BUF_X4
X$137310 \$I177795 \$63071 \$62175 \$59956 NWELL PWELL BULK DFF_X1
X$137312 \$I174459 \$64694 \$65205 \$59956 NWELL PWELL BULK DFF_X1
X$137314 \$I177801 \$63610 \$63605 \$59956 NWELL PWELL BULK DFF_X1
X$137316 \$I177794 \$63070 \$62785 \$59956 NWELL PWELL BULK DFF_X1
X$137318 \$I174439 \$62177 \$62435 \$59956 NWELL PWELL BULK DFF_X1
X$137320 \$I176427 \$62179 \$61796 \$59956 NWELL PWELL BULK DFF_X1
X$137323 \$61101 \$60336 \$60649 \$59956 NWELL PWELL BULK DFF_X1
X$137326 \$I176262 \$61797 \$61406 \$59956 NWELL PWELL BULK DFF_X1
X$137329 \$I177968 \$62463 \$62183 \$59956 NWELL PWELL BULK DFF_X1
X$137332 \$I176398 \$60652 \$61104 \$59956 NWELL PWELL BULK DFF_X1
X$137335 \$60651 \$60337 \$60897 \$59956 NWELL PWELL BULK DFF_X1
X$137338 \$I176284 \$63371 \$63902 \$59956 NWELL PWELL BULK DFF_X1
X$137340 \$I176285 \$64360 \$64700 \$59956 NWELL PWELL BULK DFF_X1
X$137342 \$I176426 \$63075 \$63632 \$59956 NWELL PWELL BULK DFF_X1
X$137345 \$I177967 \$62180 \$62791 \$59956 NWELL PWELL BULK DFF_X1
X$137348 \$I177957 \$64554 \$64887 \$59956 NWELL PWELL BULK DFF_X1
X$137350 \$I177826 \$63638 \$64126 \$59956 NWELL PWELL BULK DFF_X1
X$137353 \$I176321 \$64872 \$64540 \$59956 NWELL PWELL BULK DFF_X1
X$137355 \$I177798 \$63899 \$64351 \$59956 NWELL PWELL BULK DFF_X1
X$137358 \$I177800 \$63901 \$63621 \$59956 NWELL PWELL BULK DFF_X1
X$137360 \$I177793 \$62789 \$62958 \$59956 NWELL PWELL BULK DFF_X1
X$137362 \$I176323 \$63364 \$63624 \$59956 NWELL PWELL BULK DFF_X1
X$137365 \$I176438 \$63647 \$63904 \$59956 NWELL PWELL BULK DFF_X1
X$137407 \$I176796 \$59969 \$59968 \$60579 NWELL PWELL BULK DFF_X1
X$137423 \$60353 \$59978 \$60358 NWELL PWELL BULK NAND2_X1
X$137454 \$61674 \$60679 \$59999 NWELL PWELL BULK NAND2_X2
X$137477 \$61048 \$60367 \$61052 \$60686 \$61159 \$60004 NWELL PWELL BULK
+ OAI221_X2
X$137492 \$67900 \$60008 \$67014 NWELL PWELL BULK NOR2_X1
X$137494 \$75876 \$60008 \$76165 NWELL PWELL BULK NOR2_X1
X$137496 \$72602 \$60008 \$73280 NWELL PWELL BULK NOR2_X1
X$137498 \$72605 \$60008 \$72610 NWELL PWELL BULK NOR2_X1
X$137500 \$65588 \$60008 \$65479 NWELL PWELL BULK NOR2_X1
X$137502 \$61194 \$60539 \$60708 \$60008 \$60995 \$60975 NWELL PWELL BULK
+ OAI221_X2
X$137507 \$69637 \$60008 \$69878 NWELL PWELL BULK NOR2_X1
X$137510 \$69158 \$60008 \$69557 NWELL PWELL BULK NOR2_X1
X$137512 \$67361 \$60008 \$67805 NWELL PWELL BULK NOR2_X1
X$137514 \$72590 \$60008 \$73292 NWELL PWELL BULK NOR2_X1
X$137516 \$71799 \$60008 \$71884 NWELL PWELL BULK NOR2_X1
X$137519 \$74856 \$60008 \$74729 NWELL PWELL BULK NOR2_X1
X$137521 \$72572 \$60008 \$73321 NWELL PWELL BULK NOR2_X1
X$137523 \$72573 \$60008 \$72581 NWELL PWELL BULK NOR2_X1
X$137525 \$68246 \$60008 \$68811 NWELL PWELL BULK NOR2_X1
X$137527 \$75189 \$60008 \$75798 NWELL PWELL BULK NOR2_X1
X$137529 \$76215 \$60008 \$76221 NWELL PWELL BULK NOR2_X1
X$137532 \$79375 \$60008 \$79672 NWELL PWELL BULK NOR2_X1
X$137535 \$79022 \$60008 \$79025 NWELL PWELL BULK NOR2_X1
X$137537 \$76549 \$60008 \$76550 NWELL PWELL BULK NOR2_X1
X$137539 \$76527 \$60008 \$76888 NWELL PWELL BULK NOR2_X1
X$137541 \$78318 \$60008 \$79224 NWELL PWELL BULK NOR2_X1
X$137544 \$77924 \$60008 \$78253 NWELL PWELL BULK NOR2_X1
X$137546 \$81842 \$60008 \$82488 NWELL PWELL BULK NOR2_X1
X$137548 \$82215 \$60008 \$82061 NWELL PWELL BULK NOR2_X1
X$137550 \$80848 \$60008 \$81081 NWELL PWELL BULK NOR2_X1
X$137552 \$79005 \$60008 \$79630 NWELL PWELL BULK NOR2_X1
X$137554 \$78321 \$60008 \$78664 NWELL PWELL BULK NOR2_X1
X$137557 \$80844 \$60008 \$80457 NWELL PWELL BULK NOR2_X1
X$137559 \$81852 \$60008 \$81855 NWELL PWELL BULK NOR2_X1
X$137561 \$81476 \$60008 \$82232 NWELL PWELL BULK NOR2_X1
X$137563 \$81482 \$60008 \$81387 NWELL PWELL BULK NOR2_X1
X$137565 \$79402 \$60008 \$79403 NWELL PWELL BULK NOR2_X1
X$137567 \$81860 \$60008 \$82119 NWELL PWELL BULK NOR2_X1
X$137569 \$80130 \$60008 \$81098 NWELL PWELL BULK NOR2_X1
X$137654 \$61173 \$61181 \$60012 \$60706 \$62056 NWELL PWELL BULK AOI22_X2
X$137657 \$62224 \$60012 \$61173 \$61846 \$62686 NWELL PWELL BULK AOI22_X2
X$137692 \$66339 \$66340 \$66632 \$60031 NWELL PWELL BULK DFF_X1
X$137694 \$66638 \$66644 \$66161 \$60031 NWELL PWELL BULK DFF_X1
X$137697 \$I179125 \$64764 \$64873 \$60031 NWELL PWELL BULK DFF_X1
X$137700 \$I175299 \$63461 \$64236 \$60031 NWELL PWELL BULK DFF_X1
X$137703 \$I175297 \$63455 \$63803 \$60031 NWELL PWELL BULK DFF_X1
X$137706 \$I175028 \$64409 \$64867 \$60031 NWELL PWELL BULK DFF_X1
X$137708 \$I174839 \$67751 \$67633 \$60031 NWELL PWELL BULK DFF_X1
X$137710 \$I178685 \$67929 \$68279 \$60031 NWELL PWELL BULK DFF_X1
X$137712 \$66167 \$60031 \$I245671 \$62831 NWELL PWELL BULK DFF_X2
X$137715 \$I178673 \$64266 \$66167 \$60031 NWELL PWELL BULK DFF_X1
X$137718 \$I174858 \$67037 \$67526 \$60031 NWELL PWELL BULK DFF_X1
X$137721 \$I178728 \$67635 \$67746 \$60031 NWELL PWELL BULK DFF_X1
X$137723 \$I176043 \$66337 \$66651 \$60031 NWELL PWELL BULK DFF_X1
X$137726 \$I176612 \$65054 \$65933 \$60031 NWELL PWELL BULK DFF_X1
X$137728 \$I178412 \$63143 \$63018 \$60031 NWELL PWELL BULK DFF_X1
X$137730 \$63449 \$60031 \$I245692 \$63138 NWELL PWELL BULK DFF_X2
X$137732 \$65493 \$64750 \$65505 \$60031 NWELL PWELL BULK DFF_X1
X$137734 \$I178079 \$63451 \$64759 \$60031 NWELL PWELL BULK DFF_X1
X$137737 \$I175950 \$61209 \$61766 \$60031 NWELL PWELL BULK DFF_X1
X$137740 \$I175215 \$61742 \$61210 \$60031 NWELL PWELL BULK DFF_X1
X$137743 \$62249 \$62250 \$62248 \$60031 NWELL PWELL BULK DFF_X1
X$137745 \$I178929 \$62839 \$63150 \$60031 NWELL PWELL BULK DFF_X1
X$137747 \$I175337 \$65055 \$64874 \$60031 NWELL PWELL BULK DFF_X1
X$137752 \$I174249 \$63148 \$63149 \$60031 NWELL PWELL BULK DFF_X1
X$137755 \$I179209 \$63452 \$64407 \$60031 NWELL PWELL BULK DFF_X1
X$137758 \$I175217 \$63453 \$63146 \$60031 NWELL PWELL BULK DFF_X1
X$137761 \$I179146 \$60409 \$60517 \$60031 NWELL PWELL BULK DFF_X1
X$137763 \$I178927 \$61875 \$62745 \$60031 NWELL PWELL BULK DFF_X1
X$137765 \$I174452 \$61734 \$61211 \$60031 NWELL PWELL BULK DFF_X1
X$137768 \$I177353 \$67928 \$68469 \$60031 NWELL PWELL BULK DFF_X1
X$137792 \$64200 \$63471 \$64196 \$60037 NWELL PWELL BULK DFF_X1
X$137795 \$62986 \$62844 \$63254 \$60037 NWELL PWELL BULK DFF_X1
X$137797 \$63967 \$63467 \$63761 \$60037 NWELL PWELL BULK DFF_X1
X$137800 \$I176998 \$60430 \$60500 \$60037 NWELL PWELL BULK DFF_X1
X$137803 \$I176965 \$61888 \$62678 \$60037 NWELL PWELL BULK DFF_X1
X$137805 \$62269 \$62692 \$62701 \$60037 NWELL PWELL BULK DFF_X1
X$137808 \$I176090 \$61890 \$61232 \$60037 NWELL PWELL BULK DFF_X1
X$137810 \$I177145 \$62545 \$61240 \$60037 NWELL PWELL BULK DFF_X1
X$137813 \$I176903 \$61460 \$61470 \$60037 NWELL PWELL BULK DFF_X1
X$137816 \$I176891 \$60436 \$60147 \$60037 NWELL PWELL BULK DFF_X1
X$137818 \$I176899 \$60751 \$60856 \$60037 NWELL PWELL BULK DFF_X1
X$137820 \$I177136 \$60043 \$60042 \$60037 NWELL PWELL BULK DFF_X1
X$137823 \$65373 \$64858 \$65365 \$60037 NWELL PWELL BULK DFF_X1
X$137825 \$I177014 \$64774 \$64586 \$60037 NWELL PWELL BULK DFF_X1
X$137828 \$64419 \$63969 \$64593 \$60037 NWELL PWELL BULK DFF_X1
X$137831 \$I175610 \$63672 \$63679 \$60037 NWELL PWELL BULK DFF_X1
X$137834 \$I177166 \$64431 \$64558 \$60037 NWELL PWELL BULK DFF_X1
X$137837 \$I177137 \$63981 \$64427 \$60037 NWELL PWELL BULK DFF_X1
X$137840 \$I176954 \$64778 \$64426 \$60037 NWELL PWELL BULK DFF_X1
X$137843 \$I175659 \$63235 \$63166 \$60037 NWELL PWELL BULK DFF_X1
X$137846 \$I175665 \$64110 \$64108 \$60037 NWELL PWELL BULK DFF_X1
X$137848 \$I177163 \$61892 \$62001 \$60037 NWELL PWELL BULK DFF_X1
X$137850 \$I176506 \$61895 \$61531 \$60037 NWELL PWELL BULK DFF_X1
X$137853 \$I177196 \$63975 \$64775 \$60037 NWELL PWELL BULK DFF_X1
X$137856 \$I177151 \$62275 \$62273 \$60037 NWELL PWELL BULK DFF_X1
X$137858 \$I177138 \$63165 \$63242 \$60037 NWELL PWELL BULK DFF_X1
X$137861 \$62420 \$60037 NWELL PWELL BULK BUF_X4
X$137864 \$I176953 \$63710 \$63478 \$60037 NWELL PWELL BULK DFF_X1
X$137867 \$I177197 \$64151 \$63730 \$60037 NWELL PWELL BULK DFF_X1
X$137909 M0_AXI_WSTRB[2] \$60054 NWELL PWELL BULK BUF_X1
X$137932 \$60066 \$61921 NWELL PWELL BULK BUF_X1
X$137934 \$60066 S0_AXI_WID[7] NWELL PWELL BULK BUF_X1
X$137942 M2_AXI_WDATA[31] \$60793 NWELL PWELL BULK BUF_X1
X$138037 M2_AXI_AWLEN[7] \$60169 NWELL PWELL BULK CLKBUF_X2
X$138159 \$63953 \$63428 \$60296 \$63128 NWELL PWELL BULK MUX2_X1
X$138162 \$60296 \$63431 \$63429 \$63430 NWELL PWELL BULK MUX2_X1
X$138165 \$60296 \$61860 \$62705 \$62237 NWELL PWELL BULK MUX2_X1
X$138168 \$60296 \$61859 \$62236 \$62703 NWELL PWELL BULK MUX2_X1
X$138183 \$61674 \$60306 NWELL PWELL BULK INV_X1
X$138185 \$61835 \$62632 \$60306 \$61838 \$62636 NWELL PWELL BULK OAI22_X1
X$138197 \$61166 \$67307 \$60310 \$65029 \$67466 NWELL PWELL BULK OAI22_X1
X$138199 \$61166 \$76232 \$60310 \$76235 \$76234 NWELL PWELL BULK OAI22_X1
X$138201 \$73909 \$61166 \$60310 \$73456 \$73279 NWELL PWELL BULK OAI22_X1
X$138203 \$61166 \$72281 \$60310 \$72607 \$73031 NWELL PWELL BULK OAI22_X1
X$138205 \$61166 \$65023 \$60310 \$65021 \$65022 NWELL PWELL BULK OAI22_X1
X$138207 \$61166 \$69868 \$60310 \$69874 \$70754 NWELL PWELL BULK OAI22_X1
X$138210 \$61166 \$68148 \$60310 \$69169 \$69255 NWELL PWELL BULK OAI22_X1
X$138212 \$61166 \$67607 \$60310 \$67610 \$67608 NWELL PWELL BULK OAI22_X1
X$138214 \$61166 \$74427 \$60310 \$74723 \$74431 NWELL PWELL BULK OAI22_X1
X$138217 \$61166 \$71803 \$60310 \$72193 \$71882 NWELL PWELL BULK OAI22_X1
X$138220 \$61166 \$72255 \$60310 \$72591 \$73867 NWELL PWELL BULK OAI22_X1
X$138223 \$61166 \$72890 \$60310 \$72575 \$73318 NWELL PWELL BULK OAI22_X1
X$138226 \$61166 \$72866 \$60310 \$73118 \$72909 NWELL PWELL BULK OAI22_X1
X$138228 \$61166 \$68809 \$60310 \$67886 \$68727 NWELL PWELL BULK OAI22_X1
X$138230 \$61166 \$75574 \$60310 \$75417 \$75796 NWELL PWELL BULK OAI22_X1
X$138232 \$61166 \$78836 \$60310 \$79015 \$79270 NWELL PWELL BULK OAI22_X1
X$138235 \$61166 \$76899 \$60310 \$76902 \$77130 NWELL PWELL BULK OAI22_X1
X$138237 \$61166 \$76526 \$60310 \$76529 \$76528 NWELL PWELL BULK OAI22_X1
X$138239 \$61166 \$79217 \$78991 \$60310 \$79239 NWELL PWELL BULK OAI22_X2
X$138241 \$61166 \$78657 \$60310 \$78305 \$78898 NWELL PWELL BULK OAI22_X1
X$138244 \$61166 \$76867 \$60310 \$76218 \$76537 NWELL PWELL BULK OAI22_X1
X$138246 \$61166 \$79393 \$60310 \$78992 \$79704 NWELL PWELL BULK OAI22_X1
X$138248 \$61166 \$77726 \$60310 \$77731 \$78250 NWELL PWELL BULK OAI22_X1
X$138252 \$61166 \$82224 \$60310 \$80861 \$82113 NWELL PWELL BULK OAI22_X1
X$138254 \$61166 \$81586 \$80837 \$60310 \$82053 NWELL PWELL BULK OAI22_X2
X$138256 \$61166 \$80853 \$60310 \$80851 \$81077 NWELL PWELL BULK OAI22_X1
X$138258 \$61166 \$78650 \$60310 \$78325 \$79009 NWELL PWELL BULK OAI22_X1
X$138260 \$61166 \$81157 \$80455 \$60310 \$80674 NWELL PWELL BULK OAI22_X2
X$138262 \$61166 \$82230 \$60310 \$81128 \$82513 NWELL PWELL BULK OAI22_X1
X$138264 \$61166 \$81801 \$60310 \$78262 \$82504 NWELL PWELL BULK OAI22_X1
X$138266 \$61166 \$80131 \$60310 \$77742 \$80038 NWELL PWELL BULK OAI22_X1
X$138268 \$61166 \$81393 \$60310 \$79033 \$81388 NWELL PWELL BULK OAI22_X1
X$138270 \$61166 \$80871 \$60310 \$78064 \$80874 NWELL PWELL BULK OAI22_X1
X$138272 \$61166 \$82234 \$60310 \$80487 \$82126 NWELL PWELL BULK OAI22_X1
X$138447 \$61294 S0_AXI_AWADDR[9] NWELL PWELL BULK BUF_X1
X$138452 \$61299 S0_AXI_AWADDR[5] NWELL PWELL BULK BUF_X1
X$138458 S2_AXI_RVALID \$60316 NWELL PWELL BULK BUF_X1
X$138514 \$I174947 \$60340 \$60576 \$60579 NWELL PWELL BULK DFF_X1
X$138519 \$60979 \$60663 \$60343 NWELL PWELL BULK XOR2_X1
X$138521 \$60343 \$60665 \$60976 NWELL PWELL BULK NOR2_X1
X$138537 \$60612 \$60352 \$60575 NWELL PWELL BULK NAND2_X1
X$138575 \$60364 \$63742 \$63736 \$63395 NWELL PWELL BULK NOR3_X1
X$138579 \$63935 \$63103 \$63098 \$60364 NWELL PWELL BULK MUX2_X2
X$138610 \$60375 \$61651 \$61055 NWELL PWELL BULK AND2_X1
X$138634 \$60679 \$60385 \$60695 \$61664 NWELL PWELL BULK OAI21_X1
X$138649 \$62224 \$60389 \$61846 \$60702 \$62091 NWELL PWELL BULK AOI22_X1
X$138652 \$60702 \$61181 \$60389 \$60706 \$60991 NWELL PWELL BULK AOI22_X2
X$138660 \$62224 \$60390 \$60705 \$61846 \$61192 NWELL PWELL BULK AOI22_X2
X$138662 \$60705 \$61181 \$60706 \$60390 \$60995 NWELL PWELL BULK AOI22_X1
X$138678 \$63797 \$63102 \$64308 \$60394 NWELL PWELL BULK OAI21_X2
X$138682 \$62232 \$60394 \$60708 \$60712 \$63409 NWELL PWELL BULK AND4_X1
X$138752 \$60800 S1_AXI_WDATA[0] NWELL PWELL BULK BUF_X1
X$138757 M2_AXI_WDATA[0] \$62303 NWELL PWELL BULK BUF_X1
X$138767 \$60469 \$70514 \$71178 \$71248 NWELL PWELL BULK OAI21_X1
X$138769 \$60469 \$71173 \$72327 \$71943 NWELL PWELL BULK OAI21_X1
X$138771 \$70521 \$60469 \$70578 \$70523 NWELL PWELL BULK OAI21_X1
X$138774 \$60469 \$71156 \$71567 \$71941 NWELL PWELL BULK OAI21_X1
X$138845 \$60531 \$63138 \$63443 \$61859 NWELL PWELL BULK OR3_X4
X$138848 \$60531 \$62735 \$61202 \$I241535 NWELL PWELL BULK HA_X1
X$138851 \$60531 \$62246 NWELL PWELL BULK INV_X4
X$138854 \$63442 \$63138 \$60531 \$63428 NWELL PWELL BULK NOR3_X4
X$138884 \$61835 \$60575 \$62143 \$61838 \$62621 NWELL PWELL BULK OAI22_X1
X$138898 \$I176771 \$63089 \$63381 \$60579 NWELL PWELL BULK DFF_X1
X$138900 \$I174718 \$62520 \$62519 \$60579 NWELL PWELL BULK DFF_X1
X$138903 \$I174389 \$61486 \$61489 \$60579 NWELL PWELL BULK DFF_X1
X$138905 \$61497 \$61122 \$61493 \$60579 NWELL PWELL BULK DFF_X1
X$138907 \$I176807 \$62538 \$62202 \$60579 NWELL PWELL BULK DFF_X1
X$138911 \$I174861 \$63087 \$63675 \$60579 NWELL PWELL BULK DFF_X1
X$138913 \$I177337 \$62802 \$62513 \$60579 NWELL PWELL BULK DFF_X1
X$138915 \$64373 \$64926 \$64927 \$60579 NWELL PWELL BULK DFF_X1
X$138918 \$I177342 \$64371 \$64583 \$60579 NWELL PWELL BULK DFF_X1
X$138921 \$I176756 \$64982 \$65286 \$60579 NWELL PWELL BULK DFF_X1
X$138924 \$I174589 \$64989 \$65327 \$60579 NWELL PWELL BULK DFF_X1
X$138926 \$I176757 \$64209 \$64375 \$60579 NWELL PWELL BULK DFF_X1
X$138929 \$I176801 \$62807 \$62999 \$60579 NWELL PWELL BULK DFF_X1
X$138932 \$63925 \$60579 \$I245647 \$63052 NWELL PWELL BULK DFF_X2
X$138935 \$I177306 \$63916 \$63668 \$60579 NWELL PWELL BULK DFF_X1
X$138937 \$I177345 \$63684 \$63379 \$60579 NWELL PWELL BULK DFF_X1
X$138939 \$64197 \$63922 \$64194 \$60579 NWELL PWELL BULK DFF_X1
X$138942 \$I177304 \$65573 \$65269 \$60579 NWELL PWELL BULK DFF_X1
X$138945 \$I177325 \$64187 \$64580 \$60579 NWELL PWELL BULK DFF_X1
X$138948 \$I177314 \$64706 \$65275 \$60579 NWELL PWELL BULK DFF_X1
X$138951 \$I177346 \$63913 \$64577 \$60579 NWELL PWELL BULK DFF_X1
X$138955 \$I177309 \$61119 \$60963 \$60579 NWELL PWELL BULK DFF_X1
X$138957 \$I174634 \$62195 \$62196 \$60579 NWELL PWELL BULK DFF_X1
X$138960 \$I177308 \$61117 \$61808 \$60579 NWELL PWELL BULK DFF_X1
X$138962 \$I176686 \$64705 \$66275 \$60579 NWELL PWELL BULK DFF_X1
X$138965 \$66902 \$66892 \$66893 \$60579 NWELL PWELL BULK DFF_X1
X$138968 \$67297 \$67282 \$67792 \$60579 NWELL PWELL BULK DFF_X1
X$138970 \$I177680 \$65580 \$65579 \$60579 NWELL PWELL BULK DFF_X1
X$139016 \$60623 S2_AXI_RREADY NWELL PWELL BULK BUF_X1
X$139021 \$60836 S0_AXI_AWADDR[4] NWELL PWELL BULK BUF_X1
X$139032 \$61119 \$60623 NWELL PWELL BULK INV_X2
X$139048 \$61793 \$62167 \$60638 \$62398 NWELL PWELL BULK MUX2_X1
X$139065 \$61797 \$61798 \$60652 \$62184 NWELL PWELL BULK MUX2_X1
X$139081 \$61504 \$60663 \$61506 \$61498 \$61122 NWELL PWELL BULK FA_X1
X$139086 \$61497 \$60665 \$61122 \$62526 NWELL PWELL BULK MUX2_X1
X$139088 \$61502 \$61504 \$60665 \$61125 NWELL PWELL BULK AOI21_X1
X$139090 \$60665 \$61506 \$61502 NWELL PWELL BULK NOR2_X1
X$139105 \$61155 \$61150 \$60671 NWELL PWELL BULK NAND2_X2
X$139112 \$62565 \$60671 \$62213 \$61822 \$62212 NWELL PWELL BULK AOI22_X1
X$139116 \$60671 \$61546 \$62073 \$62559 NWELL PWELL BULK OAI21_X1
X$139145 \$60693 \$60679 \$61651 \$61170 NWELL PWELL BULK AOI21_X1
X$139150 \$61157 \$60679 \$61159 NWELL PWELL BULK NAND2_X1
X$139152 \$62582 \$61141 \$62214 \$60679 \$61822 \$62138 NWELL PWELL BULK
+ OAI221_X1
X$139194 \$60691 \$61163 NWELL PWELL BULK INV_X1
X$139260 \$64384 \$63102 \$64244 \$60708 NWELL PWELL BULK OAI21_X4
X$139269 \$65442 \$63102 \$65440 \$60712 NWELL PWELL BULK OAI21_X2
X$139300 \$62731 \$60720 \$61868 NWELL PWELL BULK XOR2_X1
X$139302 \$61774 \$60720 \$61206 \$61870 \$60721 NWELL PWELL BULK FA_X1
X$139304 \$61769 \$61202 \$60721 \$61775 NWELL PWELL BULK MUX2_X1
X$139382 \$61921 S0_AXI_WID[3] NWELL PWELL BULK BUF_X1
X$139387 \$60807 S1_AXI_WDATA[25] NWELL PWELL BULK BUF_X1
X$139399 \$60784 S1_AXI_WDATA[4] NWELL PWELL BULK BUF_X1
X$139528 \$60876 S0_AXI_AWADDR[26] NWELL PWELL BULK BUF_X1
X$139583 M2_AXI_WDATA[21] \$60925 NWELL PWELL BULK CLKBUF_X2
X$139615 \$61868 \$61202 \$60958 NWELL PWELL BULK NOR2_X1
X$139634 \$60975 \$61860 \$61862 \$62716 NWELL PWELL BULK MUX2_X1
X$139637 \$63834 \$63428 \$60975 \$63130 NWELL PWELL BULK MUX2_X1
X$139640 \$60975 \$63431 \$63432 \$63433 NWELL PWELL BULK MUX2_X1
X$139643 \$60975 \$61859 \$62240 \$62239 NWELL PWELL BULK MUX2_X1
X$139650 \$61119 \$60976 \$61120 NWELL PWELL BULK XNOR2_X1
X$139656 \$60979 \$61498 NWELL PWELL BULK INV_X1
X$139713 \$61788 S2_AXI_AWADDR[24] NWELL PWELL BULK BUF_X1
X$139718 \$61929 S2_AXI_AWADDR[31] NWELL PWELL BULK BUF_X1
X$139723 \$61075 \$69838 NWELL PWELL BULK BUF_X8
X$139741 \$65956 \$61075 \$64948 \$65548 NWELL PWELL BULK MUX2_X1
X$139747 \$71814 \$61075 \$71960 NWELL PWELL BULK OR2_X1
X$139795 \$61786 \$62167 \$61076 \$62316 NWELL PWELL BULK MUX2_X1
X$139864 \$61102 \$69838 NWELL PWELL BULK BUF_X8
X$139907 \$61800 \$61798 \$61108 \$62187 NWELL PWELL BULK MUX2_X1
X$139956 \$61137 \$61600 \$62141 NWELL PWELL BULK OR2_X1
X$139964 \$61141 \$61822 \$62565 NWELL PWELL BULK NAND2_X1
X$139982 \$62593 \$61826 \$61150 NWELL PWELL BULK OR2_X2
X$139984 \$62138 \$61155 \$61150 \$62632 NWELL PWELL BULK NAND3_X1
X$140012 \$61157 \$61830 NWELL PWELL BULK INV_X1
X$140028 \$61166 \$61181 NWELL PWELL BULK INV_X1
X$140174 \$72226 \$71845 \$64987 \$61180 NWELL PWELL BULK MUX2_X2
X$140221 \$61658 \$61194 NWELL PWELL BULK INV_X2
X$140232 \$71908 \$61201 \$71149 \$72298 NWELL PWELL BULK MUX2_X1
X$140234 \$76762 \$61201 \$76265 \$76763 NWELL PWELL BULK MUX2_X1
X$140237 \$69919 \$61201 \$69915 \$69917 NWELL PWELL BULK MUX2_X1
X$140240 \$83502 \$61201 \$82235 \$84078 NWELL PWELL BULK MUX2_X1
X$140243 \$80524 \$61201 \$80469 \$80522 NWELL PWELL BULK MUX2_X1
X$140245 \$82604 \$61201 \$82267 \$82264 NWELL PWELL BULK MUX2_X1
X$140247 \$83656 \$61201 \$82449 \$84056 NWELL PWELL BULK MUX2_X1
X$140250 \$67927 \$61201 \$67629 \$68296 NWELL PWELL BULK MUX2_X1
X$140252 \$67631 \$61201 \$67030 \$68317 NWELL PWELL BULK MUX2_X1
X$140254 \$68463 \$61201 NWELL PWELL BULK BUF_X8
X$140256 \$74469 \$61201 \$74043 \$74267 NWELL PWELL BULK MUX2_X1
X$140258 \$65944 \$61201 \$65620 \$66197 NWELL PWELL BULK MUX2_X1
X$140260 \$72630 \$61201 \$72301 \$72628 NWELL PWELL BULK MUX2_X1
X$140262 \$74047 \$61201 \$74272 \$73487 NWELL PWELL BULK MUX2_X1
X$140264 \$73480 \$61201 \$73145 \$73248 NWELL PWELL BULK MUX2_X1
X$140266 \$79437 \$61201 \$79017 \$79525 NWELL PWELL BULK MUX2_X1
X$140268 \$78528 \$61201 \$78336 \$78529 NWELL PWELL BULK MUX2_X1
X$140270 \$81523 \$61201 \$81211 \$81522 NWELL PWELL BULK MUX2_X1
X$140272 \$83891 \$61201 \$82255 \$84047 NWELL PWELL BULK MUX2_X1
X$140294 \$61202 \$61206 \$61204 NWELL PWELL BULK NOR2_X1
X$140299 \$61204 \$61774 \$61202 \$61205 NWELL PWELL BULK AOI21_X1
X$140350 \$65404 \$62994 \$61227 NWELL PWELL BULK NOR2_X2
X$140384 \$63481 \$63482 \$61237 NWELL PWELL BULK NOR2_X1
X$140421 \$61958 \$61258 \$61351 NWELL PWELL BULK NOR2_X1
X$140425 \$62353 S1_AXI_WDATA[19] NWELL PWELL BULK BUF_X1
X$140430 \$61367 S0_AXI_WDATA[12] NWELL PWELL BULK BUF_X1
X$140647 \$61813 \$62065 \$61524 \$61522 NWELL PWELL BULK AND3_X1
X$140692 \$61583 \$62213 NWELL PWELL BULK INV_X1
X$140720 \$67014 \$67466 \$61658 \$66203 NWELL PWELL BULK NOR3_X2
X$140722 \$69557 \$69255 \$61658 \$68372 NWELL PWELL BULK NOR3_X2
X$140724 \$76165 \$76234 \$61658 \$76150 NWELL PWELL BULK NOR3_X2
X$140727 \$73280 \$61658 \$73279 \$71002 NWELL PWELL BULK NOR3_X2
X$140729 \$72610 \$73031 \$61658 \$72450 NWELL PWELL BULK NOR3_X2
X$140731 \$65479 \$65022 \$61658 \$65031 NWELL PWELL BULK NOR3_X2
X$140734 \$69878 \$70754 \$61658 \$69647 NWELL PWELL BULK NOR3_X2
X$140736 \$67805 \$67608 \$61658 \$66307 NWELL PWELL BULK NOR3_X2
X$140739 \$74729 \$74431 \$61658 \$74040 NWELL PWELL BULK NOR3_X2
X$140741 \$71884 \$71882 \$61658 \$69643 NWELL PWELL BULK NOR3_X2
X$140743 \$73292 \$73867 \$61658 \$73132 NWELL PWELL BULK NOR3_X2
X$140746 \$72581 \$72909 \$61658 \$69748 NWELL PWELL BULK NOR3_X2
X$140748 \$73321 \$73318 \$61658 \$72288 NWELL PWELL BULK NOR3_X2
X$140750 \$68811 \$68727 \$61658 \$67910 NWELL PWELL BULK NOR3_X2
X$140752 \$75798 \$75796 \$61658 \$74443 NWELL PWELL BULK NOR3_X2
X$140754 \$76221 \$76537 \$61658 \$76238 NWELL PWELL BULK NOR3_X2
X$140756 \$79672 \$79270 \$61658 \$79042 NWELL PWELL BULK NOR3_X2
X$140759 \$79025 \$79704 \$61658 \$78707 NWELL PWELL BULK NOR3_X2
X$140763 \$76550 \$77130 \$61658 \$77092 NWELL PWELL BULK NOR3_X2
X$140766 \$76888 \$76528 \$61658 \$76159 NWELL PWELL BULK NOR3_X2
X$140770 \$79224 \$78898 \$61658 \$78067 NWELL PWELL BULK NOR3_X2
X$140773 \$78253 \$78250 \$61658 \$77497 NWELL PWELL BULK NOR3_X2
X$140776 \$82488 \$82113 \$61658 \$82241 NWELL PWELL BULK NOR3_X2
X$140778 \$81081 \$81077 \$61658 \$80355 NWELL PWELL BULK NOR3_X2
X$140780 \$61658 \$82053 \$82061 \$82067 NWELL PWELL BULK NOR3_X4
X$140782 \$61658 \$79239 \$79630 \$78720 NWELL PWELL BULK NOR3_X4
X$140784 \$78664 \$79009 \$61658 \$77767 NWELL PWELL BULK NOR3_X2
X$140787 \$61658 \$80674 \$80457 \$80146 NWELL PWELL BULK NOR3_X4
X$140789 \$81855 \$82513 \$61658 \$82817 NWELL PWELL BULK NOR3_X2
X$140792 \$82232 \$82504 \$61658 \$82581 NWELL PWELL BULK NOR3_X2
X$140795 \$79403 \$80038 \$61658 \$79801 NWELL PWELL BULK NOR3_X2
X$140797 \$81387 \$81388 \$61658 \$81188 NWELL PWELL BULK NOR3_X2
X$140799 \$82119 \$82126 \$61658 \$81881 NWELL PWELL BULK NOR3_X2
X$140801 \$81098 \$80874 \$61658 \$81082 NWELL PWELL BULK NOR3_X2
X$140947 \$62157 S2_AXI_AWLEN[6] NWELL PWELL BULK BUF_X1
X$140952 \$62320 S2_AXI_AWBURST[0] NWELL PWELL BULK BUF_X1
X$140962 \$63361 \$62317 \$63363 \$61788 NWELL PWELL BULK MUX2_X1
X$140990 \$63901 \$61798 \$64872 \$64544 NWELL PWELL BULK MUX2_X1
X$140994 \$62789 \$61798 \$63075 \$62790 NWELL PWELL BULK MUX2_X1
X$140996 \$64973 \$61798 \$65572 \$64975 NWELL PWELL BULK MUX2_X1
X$140999 \$64906 \$61798 \$64976 \$65252 NWELL PWELL BULK MUX2_X1
X$141002 \$64970 \$61798 \$64360 \$64132 NWELL PWELL BULK MUX2_X1
X$141005 \$63638 \$61798 \$63371 \$63369 NWELL PWELL BULK MUX2_X1
X$141009 \$62179 \$61798 \$62180 \$62455 NWELL PWELL BULK MUX2_X1
X$141011 \$71086 \$61798 \$71089 \$70945 NWELL PWELL BULK MUX2_X1
X$141013 \$68982 \$61798 \$69398 \$68787 NWELL PWELL BULK MUX2_X1
X$141015 \$65967 \$61798 \$65567 \$65969 NWELL PWELL BULK MUX2_X1
X$141017 \$67585 \$61798 \$67588 \$66968 NWELL PWELL BULK MUX2_X1
X$141019 \$68108 \$61798 \$67852 \$68111 NWELL PWELL BULK MUX2_X1
X$141021 \$67856 \$61798 \$69214 \$68127 NWELL PWELL BULK MUX2_X1
X$141023 \$66972 \$61798 \$66271 \$66269 NWELL PWELL BULK MUX2_X1
X$141026 \$62463 \$61798 \$62185 \$62793 NWELL PWELL BULK MUX2_X1
X$141028 \$64357 \$61798 \$64554 \$64545 NWELL PWELL BULK MUX2_X1
X$141031 \$69835 \$61798 \$69760 \$70944 NWELL PWELL BULK MUX2_X1
X$141033 \$70429 \$61798 \$69839 \$71092 NWELL PWELL BULK MUX2_X1
X$141036 \$61798 \$62167 NWELL PWELL BULK BUF_X16
X$141039 \$61798 \$65119 NWELL PWELL BULK BUF_X16
X$141041 \$72221 \$66260 \$I245680 \$61798 NWELL PWELL BULK DFF_X2
X$141043 \$66698 \$61798 \$66152 \$65974 NWELL PWELL BULK MUX2_X1
X$141045 \$66267 \$61798 \$65570 \$66140 NWELL PWELL BULK MUX2_X1
X$141047 \$63082 \$61798 \$62188 \$62484 NWELL PWELL BULK MUX2_X1
X$141049 \$63647 \$61798 \$63907 \$64366 NWELL PWELL BULK MUX2_X1
X$141052 \$64149 \$61798 \$63911 \$64570 NWELL PWELL BULK MUX2_X1
X$141055 \$69426 \$61798 \$69781 \$69604 NWELL PWELL BULK MUX2_X1
X$141057 \$65759 \$61798 \$65565 \$66128 NWELL PWELL BULK MUX2_X1
X$141059 \$66265 \$61798 \$67225 \$66470 NWELL PWELL BULK MUX2_X1
X$141061 \$69209 \$61798 \$69207 \$67591 NWELL PWELL BULK MUX2_X1
X$141064 \$66970 \$61798 \$66971 \$67764 NWELL PWELL BULK MUX2_X1
X$141066 \$70434 \$61798 \$70094 \$70791 NWELL PWELL BULK MUX2_X1
X$141069 \$69205 \$61798 \$68405 \$68994 NWELL PWELL BULK MUX2_X1
X$141132 \$61799 \$62350 NWELL PWELL BULK BUF_X8
X$141181 \$62205 \$62538 \$62535 \$61811 NWELL PWELL BULK HA_X1
X$141197 \$61831 \$61821 \$62618 \$61838 \$62220 NWELL PWELL BULK OAI22_X1
X$141216 \$63103 \$63102 \$61826 NWELL PWELL BULK NOR2_X1
X$141222 \$61830 \$61838 \$61831 \$62141 \$62620 NWELL PWELL BULK OAI22_X1
X$141236 \$61836 \$62143 NWELL PWELL BULK INV_X1
X$141259 \$61854 \$61860 \$63027 \$63280 NWELL PWELL BULK MUX2_X1
X$141261 \$61854 \$63431 \$64283 \$64402 NWELL PWELL BULK MUX2_X1
X$141264 \$63958 \$63428 \$61854 \$63862 NWELL PWELL BULK MUX2_X1
X$141266 \$61854 \$61859 \$62244 \$63031 NWELL PWELL BULK MUX2_X1
X$141274 \$61858 \$61859 \$61865 \$62714 NWELL PWELL BULK MUX2_X1
X$141276 \$61858 \$61860 \$61867 \$62242 NWELL PWELL BULK MUX2_X1
X$141278 \$61858 \$63431 \$63133 \$63435 NWELL PWELL BULK MUX2_X1
X$141281 \$63956 \$63428 \$61858 \$64309 NWELL PWELL BULK MUX2_X1
X$141290 \$62684 \$61859 \$64401 \$64893 NWELL PWELL BULK MUX2_X1
X$141293 \$68372 \$61859 \$68377 \$68375 NWELL PWELL BULK OAI21_X1
X$141295 \$61859 \$68362 \$67912 NWELL PWELL BULK NAND2_X1
X$141297 \$67910 \$61859 \$67912 \$68355 NWELL PWELL BULK OAI21_X1
X$141299 \$61859 \$67625 \$68377 NWELL PWELL BULK NAND2_X1
X$141301 \$66203 \$61859 \$67500 \$67628 NWELL PWELL BULK OAI21_X1
X$141304 \$61859 \$67021 \$66675 NWELL PWELL BULK NAND2_X1
X$141306 \$66307 \$61859 \$66675 \$66323 NWELL PWELL BULK OAI21_X1
X$141309 \$61859 \$67922 \$67500 NWELL PWELL BULK NAND2_X1
X$141312 \$61859 \$69271 \$69495 NWELL PWELL BULK NAND2_X1
X$141315 \$69647 \$61859 \$69495 \$69742 NWELL PWELL BULK OAI21_X1
X$141317 \$69643 \$61859 \$71009 \$71434 NWELL PWELL BULK OAI21_X1
X$141319 \$61859 \$71011 \$71009 NWELL PWELL BULK NAND2_X1
X$141321 \$74443 \$61859 \$74876 \$75499 NWELL PWELL BULK OAI21_X1
X$141323 \$61859 \$75209 \$74876 NWELL PWELL BULK NAND2_X1
X$141325 \$71002 \$61859 \$73258 \$73259 NWELL PWELL BULK OAI21_X1
X$141327 \$61859 \$73256 \$73258 NWELL PWELL BULK NAND2_X1
X$141329 \$74040 \$61859 \$73471 \$73470 NWELL PWELL BULK OAI21_X1
X$141331 \$72288 \$61859 \$73945 \$73136 NWELL PWELL BULK OAI21_X1
X$141333 \$61859 \$74042 \$73471 NWELL PWELL BULK NAND2_X1
X$141336 \$61859 \$70370 \$69641 NWELL PWELL BULK NAND2_X1
X$141339 \$69748 \$61859 \$69641 \$70364 NWELL PWELL BULK OAI21_X1
X$141342 \$61859 \$72613 \$73057 NWELL PWELL BULK NAND2_X1
X$141345 \$72450 \$61859 \$73057 \$73955 NWELL PWELL BULK OAI21_X1
X$141353 \$65031 \$61859 \$65513 \$65515 NWELL PWELL BULK OAI21_X1
X$141355 \$61859 \$65038 \$65513 NWELL PWELL BULK NAND2_X1
X$141357 \$81188 \$61859 \$81195 \$81193 NWELL PWELL BULK OAI21_X1
X$141359 \$61859 \$80496 \$81056 NWELL PWELL BULK NAND2_X1
X$141362 \$61859 \$82072 \$81195 NWELL PWELL BULK NAND2_X1
X$141364 \$80355 \$61859 \$81056 \$80495 NWELL PWELL BULK OAI21_X1
X$141367 \$61859 \$83879 \$83348 NWELL PWELL BULK NAND2_X1
X$141369 \$82581 \$61859 \$83348 \$83876 NWELL PWELL BULK OAI21_X1
X$141371 \$82241 \$61859 \$83760 \$83481 NWELL PWELL BULK OAI21_X1
X$141374 \$61859 \$83875 \$83760 NWELL PWELL BULK NAND2_X1
X$141376 \$61859 \$83486 \$83738 NWELL PWELL BULK NAND2_X1
X$141378 \$82067 \$61859 \$83738 \$83741 NWELL PWELL BULK OAI21_X1
X$141380 \$61859 \$83497 \$83697 NWELL PWELL BULK NAND2_X1
X$141382 \$82817 \$61859 \$83697 \$84093 NWELL PWELL BULK OAI21_X1
X$141384 \$61859 \$79430 \$79941 NWELL PWELL BULK NAND2_X1
X$141386 \$79801 \$61859 \$79941 \$79940 NWELL PWELL BULK OAI21_X1
X$141388 \$78720 \$61859 \$78855 \$78858 NWELL PWELL BULK OAI21_X1
X$141390 \$61859 \$78560 \$78855 NWELL PWELL BULK NAND2_X1
X$141392 \$61859 \$77066 \$77073 NWELL PWELL BULK NAND2_X1
X$141394 \$76150 \$61859 \$77073 \$77392 NWELL PWELL BULK OAI21_X1
X$141396 \$81881 \$61859 \$82019 \$82415 NWELL PWELL BULK OAI21_X1
X$141398 \$61859 \$82254 \$82019 NWELL PWELL BULK NAND2_X1
X$141401 \$81082 \$61859 \$81014 \$80895 NWELL PWELL BULK OAI21_X1
X$141403 \$61859 \$81200 \$81014 NWELL PWELL BULK NAND2_X1
X$141406 \$61859 \$80153 \$80325 NWELL PWELL BULK NAND2_X1
X$141408 \$61859 \$77764 \$77958 NWELL PWELL BULK NAND2_X1
X$141410 \$77497 \$61859 \$77958 \$77432 NWELL PWELL BULK OAI21_X1
X$141412 \$78707 \$61859 \$78880 \$78594 NWELL PWELL BULK OAI21_X1
X$141414 \$61859 \$78713 \$78880 NWELL PWELL BULK NAND2_X1
X$141417 \$61859 \$78355 \$78353 NWELL PWELL BULK NAND2_X1
X$141419 \$77767 \$61859 \$78353 \$78352 NWELL PWELL BULK OAI21_X1
X$141422 \$80146 \$61859 \$80325 \$80336 NWELL PWELL BULK OAI21_X1
X$141424 \$79042 \$61859 \$79628 \$79414 NWELL PWELL BULK OAI21_X1
X$141427 \$61859 \$79417 \$79628 NWELL PWELL BULK NAND2_X1
X$141430 \$61859 \$76253 \$76819 NWELL PWELL BULK NAND2_X1
X$141432 \$73132 \$61859 \$74742 \$74313 NWELL PWELL BULK OAI21_X1
X$141435 \$61859 \$73139 \$73945 NWELL PWELL BULK NAND2_X1
X$141437 \$61859 \$74737 \$74742 NWELL PWELL BULK NAND2_X1
X$141440 \$61859 \$76151 \$75479 NWELL PWELL BULK NAND2_X1
X$141443 \$76159 \$61859 \$75479 \$75751 NWELL PWELL BULK OAI21_X1
X$141445 \$61859 \$76569 \$76915 NWELL PWELL BULK NAND2_X1
X$141447 \$78067 \$61859 \$78068 \$78238 NWELL PWELL BULK OAI21_X1
X$141450 \$61859 \$78349 \$78068 NWELL PWELL BULK NAND2_X1
X$141453 \$76238 \$61859 \$76915 \$76567 NWELL PWELL BULK OAI21_X1
X$141455 \$77092 \$61859 \$76819 \$76571 NWELL PWELL BULK OAI21_X1
X$141535 \$63138 \$63442 \$62246 \$61860 NWELL PWELL BULK NAND3_X4
X$141538 \$62684 \$61860 \$65619 \$65047 NWELL PWELL BULK MUX2_X1
X$141540 \$61860 \$83488 \$83487 NWELL PWELL BULK NAND2_X1
X$141543 \$61860 \$68367 \$68370 NWELL PWELL BULK NAND2_X1
X$141546 \$68372 \$61860 \$68359 \$68374 NWELL PWELL BULK OAI21_X1
X$141548 \$66307 \$61860 \$66678 \$66324 NWELL PWELL BULK OAI21_X1
X$141550 \$61860 \$68344 \$68348 NWELL PWELL BULK NAND2_X1
X$141552 \$61860 \$67627 \$68359 NWELL PWELL BULK NAND2_X1
X$141554 \$66203 \$61860 \$68348 \$68459 NWELL PWELL BULK OAI21_X1
X$141557 \$67910 \$61860 \$68370 \$67913 NWELL PWELL BULK OAI21_X1
X$141560 \$61860 \$66010 \$66678 NWELL PWELL BULK NAND2_X1
X$141562 \$69647 \$61860 \$69910 \$69911 NWELL PWELL BULK OAI21_X1
X$141564 \$61860 \$69743 \$69910 NWELL PWELL BULK NAND2_X1
X$141566 \$69748 \$61860 \$69896 \$70728 NWELL PWELL BULK OAI21_X1
X$141568 \$61860 \$69897 \$69896 NWELL PWELL BULK NAND2_X1
X$141570 \$61860 \$69645 \$70381 NWELL PWELL BULK NAND2_X1
X$141573 \$69643 \$61860 \$70381 \$69902 NWELL PWELL BULK OAI21_X1
X$141576 \$61860 \$73019 \$72293 NWELL PWELL BULK NAND2_X1
X$141578 \$71002 \$61860 \$72293 \$72438 NWELL PWELL BULK OAI21_X1
X$141580 \$72450 \$61860 \$73960 \$73134 NWELL PWELL BULK OAI21_X1
X$141582 \$61860 \$73267 \$73960 NWELL PWELL BULK NAND2_X1
X$141584 \$73132 \$61860 \$73903 \$73913 NWELL PWELL BULK OAI21_X1
X$141588 \$65031 \$61860 \$65521 \$65511 NWELL PWELL BULK OAI21_X1
X$141590 \$61860 \$65039 \$65521 NWELL PWELL BULK NAND2_X1
X$141592 \$76150 \$61860 \$77057 \$77382 NWELL PWELL BULK OAI21_X1
X$141594 \$61860 \$82070 \$81724 NWELL PWELL BULK NAND2_X1
X$141597 \$81188 \$61860 \$81724 \$81504 NWELL PWELL BULK OAI21_X1
X$141599 \$80146 \$61860 \$80505 \$80149 NWELL PWELL BULK OAI21_X1
X$141602 \$61860 \$80506 \$80505 NWELL PWELL BULK NAND2_X1
X$141605 \$61860 \$80498 \$80885 NWELL PWELL BULK NAND2_X1
X$141608 \$80355 \$61860 \$80885 \$81058 NWELL PWELL BULK OAI21_X1
X$141610 \$82581 \$61860 \$83349 \$83482 NWELL PWELL BULK OAI21_X1
X$141612 \$82067 \$61860 \$83487 \$83733 NWELL PWELL BULK OAI21_X1
X$141615 \$61860 \$83207 \$83349 NWELL PWELL BULK NAND2_X1
X$141617 \$82241 \$61860 \$83360 \$83761 NWELL PWELL BULK OAI21_X1
X$141620 \$61860 \$83205 \$83360 NWELL PWELL BULK NAND2_X1
X$141623 \$78720 \$61860 \$79222 \$78719 NWELL PWELL BULK OAI21_X1
X$141626 \$61860 \$76928 \$77057 NWELL PWELL BULK NAND2_X1
X$141628 \$61860 \$79055 \$79222 NWELL PWELL BULK NAND2_X1
X$141631 \$81082 \$61860 \$81678 \$81680 NWELL PWELL BULK OAI21_X1
X$141634 \$81881 \$61860 \$82412 \$82407 NWELL PWELL BULK OAI21_X1
X$141636 \$61860 \$81887 \$82412 NWELL PWELL BULK NAND2_X1
X$141638 \$61860 \$81516 \$81678 NWELL PWELL BULK NAND2_X1
X$141641 \$82817 \$61860 \$83107 \$83112 NWELL PWELL BULK OAI21_X1
X$141643 \$61860 \$83495 \$83107 NWELL PWELL BULK NAND2_X1
X$141645 \$79801 \$61860 \$80510 \$80706 NWELL PWELL BULK OAI21_X1
X$141647 \$61860 \$80511 \$80510 NWELL PWELL BULK NAND2_X1
X$141649 \$61860 \$78712 \$79269 NWELL PWELL BULK NAND2_X1
X$141652 \$78707 \$61860 \$79269 \$78706 NWELL PWELL BULK OAI21_X1
X$141654 \$78067 \$61860 \$78903 \$78600 NWELL PWELL BULK OAI21_X1
X$141657 \$61860 \$77762 \$77975 NWELL PWELL BULK NAND2_X1
X$141660 \$61860 \$78894 \$78903 NWELL PWELL BULK NAND2_X1
X$141663 \$77497 \$61860 \$77975 \$77504 NWELL PWELL BULK OAI21_X1
X$141665 \$79042 \$61860 \$79045 \$79043 NWELL PWELL BULK OAI21_X1
X$141668 \$61860 \$79613 \$79045 NWELL PWELL BULK NAND2_X1
X$141671 \$76159 \$61860 \$75212 \$75213 NWELL PWELL BULK OAI21_X1
X$141673 \$61860 \$75749 \$75212 NWELL PWELL BULK NAND2_X1
X$141675 \$74443 \$61860 \$75597 \$75491 NWELL PWELL BULK OAI21_X1
X$141679 \$74040 \$61860 \$74454 \$74751 NWELL PWELL BULK OAI21_X1
X$141681 \$61860 \$75596 \$75597 NWELL PWELL BULK NAND2_X1
X$141684 \$61860 \$74456 \$74454 NWELL PWELL BULK NAND2_X1
X$141686 \$72288 \$61860 \$73047 \$73050 NWELL PWELL BULK OAI21_X1
X$141688 \$61860 \$73044 \$73047 NWELL PWELL BULK NAND2_X1
X$141690 \$61860 \$74044 \$73903 NWELL PWELL BULK NAND2_X1
X$141692 \$76238 \$61860 \$76243 \$76471 NWELL PWELL BULK OAI21_X1
X$141694 \$61860 \$75881 \$76243 NWELL PWELL BULK NAND2_X1
X$141696 \$61860 \$76814 \$77082 NWELL PWELL BULK NAND2_X1
X$141699 \$77092 \$61860 \$77082 \$77091 NWELL PWELL BULK OAI21_X1
X$141702 \$61860 \$78228 \$77769 NWELL PWELL BULK NAND2_X1
X$141704 \$77767 \$61860 \$77769 \$78231 NWELL PWELL BULK OAI21_X1
X$141776 \$62240 \$62831 \$61862 \$63131 NWELL PWELL BULK MUX2_X1
X$141784 \$61865 \$62831 \$61867 \$63134 NWELL PWELL BULK MUX2_X1
X$141795 \$62731 \$61870 NWELL PWELL BULK INV_X1
X$141821 \$61885 \$62265 \$62026 NWELL PWELL BULK NOR2_X2
X$141833 \$65063 \$63154 \$61891 NWELL PWELL BULK NOR2_X1
X$141886 \$61918 \$62847 \$63015 NWELL PWELL BULK NAND2_X2
X$141889 \$63962 \$64265 \$64260 \$61918 NWELL PWELL BULK NAND3_X4
X$141891 \$61918 M1_AXI_RVALID NWELL PWELL BULK BUF_X1
X$141900 \$62371 S1_AXI_WDATA[2] NWELL PWELL BULK BUF_X1
X$141910 \$62398 \$62317 \$62168 \$61929 NWELL PWELL BULK MUX2_X1
X$141959 \$62026 \$71156 \$80530 \$80529 NWELL PWELL BULK OAI21_X1
X$141961 \$70521 \$62026 \$81284 \$81214 NWELL PWELL BULK OAI21_X1
X$141964 \$62026 \$71173 \$81532 \$80967 NWELL PWELL BULK OAI21_X1
X$141967 \$62026 \$70514 \$81973 \$81627 NWELL PWELL BULK OAI21_X1
X$141980 \$62043 S0_AXI_AWLEN[3] NWELL PWELL BULK BUF_X1
X$141997 \$66003 \$65999 \$62057 \$66222 NWELL PWELL BULK MUX2_X1
X$141999 \$65611 \$66312 \$62057 \$65888 NWELL PWELL BULK MUX2_X1
X$142001 \$62057 \$66724 \$66314 \$66649 NWELL PWELL BULK MUX2_X1
X$142003 \$62057 \$65879 \$67448 \$67441 NWELL PWELL BULK MUX2_X1
X$142024 \$62079 \$66724 \$66633 \$66726 NWELL PWELL BULK MUX2_X1
X$142027 \$66310 \$66312 \$62079 \$67432 NWELL PWELL BULK MUX2_X1
X$142030 \$65998 \$65999 \$62079 \$66237 NWELL PWELL BULK MUX2_X1
X$142032 \$62079 \$65879 \$65880 \$65882 NWELL PWELL BULK MUX2_X1
X$142042 \$62111 \$66724 \$67010 \$67617 NWELL PWELL BULK MUX2_X1
X$142045 \$67007 \$65999 \$62111 \$67416 NWELL PWELL BULK MUX2_X1
X$142047 \$62111 \$65879 \$67009 \$68290 NWELL PWELL BULK MUX2_X1
X$142050 \$65995 \$66312 \$62111 \$66620 NWELL PWELL BULK MUX2_X1
X$142066 S2_AXI_RRESP[1] \$62771 NWELL PWELL BULK BUF_X2
X$142071 \$62892 S2_AXI_AWADDR[19] NWELL PWELL BULK BUF_X1
X$142076 \$62345 S2_AXI_AWID[3] NWELL PWELL BULK BUF_X1
X$142081 \$63194 S2_AXI_AWADDR[8] NWELL PWELL BULK BUF_X1
X$142086 \$62790 \$62794 \$62455 \$62157 NWELL PWELL BULK MUX2_X1
X$142091 \$62159 \$62167 \$63063 \$63064 NWELL PWELL BULK MUX2_X1
X$142098 \$63066 \$62167 \$62162 \$63558 NWELL PWELL BULK MUX2_X1
X$142102 \$62164 \$66260 NWELL PWELL BULK BUF_X4
X$142107 \$62164 \$75816 NWELL PWELL BULK BUF_X4
X$142109 \$62164 \$64942 NWELL PWELL BULK BUF_X4
X$142111 \$62164 \$65959 NWELL PWELL BULK BUF_X4
X$142114 \$62164 \$67823 NWELL PWELL BULK BUF_X4
X$142117 \$62164 \$71474 NWELL PWELL BULK BUF_X4
X$142140 \$62780 \$62167 \$62165 \$62387 NWELL PWELL BULK MUX2_X1
X$142144 \$64695 \$62167 \$64694 \$64962 NWELL PWELL BULK MUX2_X1
X$142147 \$63070 \$62167 \$63610 \$63252 NWELL PWELL BULK MUX2_X1
X$142150 \$63071 \$62167 \$63364 \$63361 NWELL PWELL BULK MUX2_X1
X$142152 \$63897 \$62167 \$63899 \$63363 NWELL PWELL BULK MUX2_X1
X$142154 \$68402 \$62167 \$67846 \$68081 NWELL PWELL BULK MUX2_X1
X$142156 \$66259 \$62167 \$65561 \$64963 NWELL PWELL BULK MUX2_X1
X$142158 \$65562 \$62167 \$64964 \$65754 NWELL PWELL BULK MUX2_X1
X$142161 \$66690 \$62167 \$66262 \$66261 NWELL PWELL BULK MUX2_X1
X$142163 \$64852 \$62167 \$65735 \$65182 NWELL PWELL BULK MUX2_X1
X$142166 \$64341 \$62167 \$64060 \$63348 NWELL PWELL BULK MUX2_X1
X$142169 \$63356 \$62167 \$63595 \$62168 NWELL PWELL BULK MUX2_X1
X$142172 \$65549 \$62167 \$64951 \$65155 NWELL PWELL BULK MUX2_X1
X$142175 \$64845 \$62167 \$65185 \$64956 NWELL PWELL BULK MUX2_X1
X$142178 \$63351 \$62167 \$62781 \$63589 NWELL PWELL BULK MUX2_X1
X$142182 \$64481 \$62167 \$63887 \$63561 NWELL PWELL BULK MUX2_X1
X$142185 \$67718 \$62167 \$67840 \$67574 NWELL PWELL BULK MUX2_X1
X$142187 \$66256 \$62167 \$66254 \$66426 NWELL PWELL BULK MUX2_X1
X$142190 \$62171 \$62167 \$62173 \$62949 NWELL PWELL BULK MUX2_X1
X$142194 \$66964 \$62167 \$66689 \$66965 NWELL PWELL BULK MUX2_X1
X$142196 \$67843 \$62167 \$67578 \$67736 NWELL PWELL BULK MUX2_X1
X$142198 \$69196 \$62167 \$69197 \$70081 NWELL PWELL BULK MUX2_X1
X$142200 \$63513 \$62167 \$63059 \$63523 NWELL PWELL BULK MUX2_X1
X$142202 \$63879 \$62167 \$63883 \$62775 NWELL PWELL BULK MUX2_X1
X$142205 \$63532 \$62167 \$63545 \$64007 NWELL PWELL BULK MUX2_X1
X$142207 \$62329 \$62167 \$62899 \$62325 NWELL PWELL BULK MUX2_X1
X$142211 \$64082 \$62167 \$64503 \$63582 NWELL PWELL BULK MUX2_X1
X$142217 \$65553 \$62167 \$66087 \$66423 NWELL PWELL BULK MUX2_X1
X$142219 \$66961 \$62167 \$66960 \$67192 NWELL PWELL BULK MUX2_X1
X$142302 \$63210 \$62181 NWELL PWELL BULK BUF_X8
X$142312 \$72206 \$62181 \$71964 NWELL PWELL BULK OR2_X1
X$142350 \$62184 \$62794 \$62793 \$63278 NWELL PWELL BULK MUX2_X1
X$142356 \$I177963 \$62185 \$62186 \$63375 NWELL PWELL BULK DFF_X1
X$142362 \$62187 \$62794 \$62484 \$62345 NWELL PWELL BULK MUX2_X1
X$142375 \$62190 \$62800 NWELL PWELL BULK INV_X1
X$142398 \$62550 \$62206 \$62207 \$62541 NWELL PWELL BULK MUX2_X1
X$142420 \$62219 \$62618 NWELL PWELL BULK INV_X1
X$142429 \$63404 \$63054 \$63050 \$62223 NWELL PWELL BULK MUX2_X1
X$142442 \$63945 \$63102 \$63782 \$62232 NWELL PWELL BULK OAI21_X2
X$142452 \$62236 \$62831 \$62705 \$63129 NWELL PWELL BULK MUX2_X1
X$142469 \$62244 \$62831 \$63027 \$63136 NWELL PWELL BULK MUX2_X1
X$142475 \$63442 \$62246 \$62250 \$63855 NWELL PWELL BULK MUX2_X1
X$142478 \$63138 \$63443 \$62246 \$63431 NWELL PWELL BULK NAND3_X4
X$142483 \$62246 \$63145 \$63823 NWELL PWELL BULK NAND2_X1
X$142485 \$63143 \$62246 \$63832 \$63450 NWELL PWELL BULK MUX2_X1
X$142487 \$63138 \$62246 \$63143 \$63846 NWELL PWELL BULK MUX2_X1
X$142489 \$62246 \$63015 \$I241126 \$62731 NWELL PWELL BULK HA_X1
X$142494 \$62250 \$62246 \$62249 \$62737 NWELL PWELL BULK MUX2_X1
X$142497 \$63452 \$62246 \$63453 \$63963 NWELL PWELL BULK MUX2_X1
X$142512 \$62250 \$63143 \$63832 \$63145 NWELL PWELL BULK HA_X1
X$142578 \$64096 \$64094 \$62292 NWELL PWELL BULK NOR2_X1
X$142604 \$62301 S0_AXI_WID[2] NWELL PWELL BULK BUF_X1
X$142624 \$62376 S0_AXI_WSTRB[0] NWELL PWELL BULK BUF_X1
X$142629 M2_AXI_WID[2] \$63503 NWELL PWELL BULK BUF_X1
X$142634 M2_AXI_WDATA[15] \$63170 NWELL PWELL BULK BUF_X1
X$142641 \$62316 \$62317 \$62325 \$62320 NWELL PWELL BULK MUX2_X1
X$142644 \$64962 \$62317 \$64963 \$64456 NWELL PWELL BULK MUX2_X1
X$142647 \$62949 \$62317 \$63252 \$62892 NWELL PWELL BULK MUX2_X1
X$142649 \$70945 \$62317 \$70944 \$70617 NWELL PWELL BULK MUX2_X1
X$142652 \$70081 \$62317 \$68081 \$67822 NWELL PWELL BULK MUX2_X1
X$142654 \$65754 \$62317 \$66261 \$65961 NWELL PWELL BULK MUX2_X1
X$142656 \$64956 \$62317 \$65182 \$64801 NWELL PWELL BULK MUX2_X1
X$142658 \$62387 \$62317 \$63589 \$63586 NWELL PWELL BULK MUX2_X1
X$142660 \$64949 \$62317 \$65155 \$64827 NWELL PWELL BULK MUX2_X1
X$142663 \$69586 \$62317 \$68953 \$68895 NWELL PWELL BULK MUX2_X1
X$142666 \$69591 \$62317 \$69194 \$68581 NWELL PWELL BULK MUX2_X1
X$142669 \$70039 \$62317 \$69377 \$69337 NWELL PWELL BULK MUX2_X1
X$142672 \$70783 \$62317 \$71987 \$69815 NWELL PWELL BULK MUX2_X1
X$142675 \$65692 \$62317 \$65693 \$65676 NWELL PWELL BULK MUX2_X1
X$142679 \$67574 \$62317 \$67192 \$67145 NWELL PWELL BULK MUX2_X1
X$142683 \$66965 \$62317 \$67736 \$67144 NWELL PWELL BULK MUX2_X1
X$142685 \$69832 \$62317 \$70600 \$69962 NWELL PWELL BULK MUX2_X1
X$142687 \$71262 \$62317 \$71642 \$69997 NWELL PWELL BULK MUX2_X1
X$142690 \$62794 \$62317 NWELL PWELL BULK BUF_X16
X$142693 \$63523 \$62317 \$64007 \$63529 NWELL PWELL BULK MUX2_X1
X$142696 \$63064 \$62317 \$62775 \$63194 NWELL PWELL BULK MUX2_X1
X$142699 \$63561 \$62317 \$63558 \$63884 NWELL PWELL BULK MUX2_X1
X$142703 \$63348 \$62317 \$63582 \$63575 NWELL PWELL BULK MUX2_X1
X$142705 \$67570 \$62317 \$68025 \$67571 NWELL PWELL BULK MUX2_X1
X$142707 \$67135 \$62317 \$66807 \$65952 NWELL PWELL BULK MUX2_X1
X$142710 \$67562 \$62317 \$68515 \$67825 NWELL PWELL BULK MUX2_X1
X$142712 \$66949 \$62317 \$66950 \$67688 NWELL PWELL BULK MUX2_X1
X$142714 \$71820 \$62317 \$71224 \$70544 NWELL PWELL BULK MUX2_X1
X$142716 \$71062 \$62317 \$71210 \$69806 NWELL PWELL BULK MUX2_X1
X$142718 \$71066 \$62317 \$71067 \$71199 NWELL PWELL BULK MUX2_X1
X$142720 \$69351 \$62317 \$68540 \$68508 NWELL PWELL BULK MUX2_X1
X$142723 \$70407 \$62317 \$69978 \$68911 NWELL PWELL BULK MUX2_X1
X$142725 \$66426 \$62317 \$66423 \$66425 NWELL PWELL BULK MUX2_X1
X$142727 \$70416 \$62317 \$69819 \$70568 NWELL PWELL BULK MUX2_X1
X$142729 \$71233 \$62317 \$70914 \$70554 NWELL PWELL BULK MUX2_X1
X$142732 \$71082 \$62317 \$71246 \$69816 NWELL PWELL BULK MUX2_X1
X$142828 \$64947 \$62350 \$64948 \$65144 NWELL PWELL BULK MUX2_X1
X$142840 \$63057 \$62350 NWELL PWELL BULK BUF_X8
X$142932 \$62420 \$71179 NWELL PWELL BULK BUF_X4
X$142934 \$62420 \$65665 NWELL PWELL BULK BUF_X4
X$142939 \$62420 \$65657 NWELL PWELL BULK BUF_X4
X$142941 \$62420 \$78086 NWELL PWELL BULK BUF_X4
X$142944 \$62420 \$74077 NWELL PWELL BULK BUF_X4
X$142947 \$62420 \$68876 NWELL PWELL BULK BUF_X4
X$142991 \$62445 S0_AXI_AWADDR[29] NWELL PWELL BULK BUF_X1
X$143009 \$62784 \$62451 NWELL PWELL BULK BUF_X8
X$143011 \$63530 \$62451 NWELL PWELL BULK BUF_X8
X$143057 \$64789 \$63495 \$62475 NWELL PWELL BULK NOR2_X1
X$143179 \$63935 \$63098 \$62593 NWELL PWELL BULK NOR2_X1
X$143216 \$62650 \$66724 \$68799 \$69220 NWELL PWELL BULK MUX2_X1
X$143219 \$69218 \$65999 \$62650 \$69031 NWELL PWELL BULK MUX2_X1
X$143222 \$62650 \$65879 \$69610 \$70130 NWELL PWELL BULK MUX2_X1
X$143224 \$68414 \$66312 \$62650 \$68415 NWELL PWELL BULK MUX2_X1
X$143247 \$64897 \$63428 \$62684 \$65535 NWELL PWELL BULK MUX2_X1
X$143249 \$62684 \$63431 \$65537 \$65534 NWELL PWELL BULK MUX2_X1
X$143273 M0_AXI_WDATA[2] \$62696 NWELL PWELL BULK CLKBUF_X2
X$143329 \$63015 \$62735 NWELL PWELL BULK INV_X2
X$143331 \$62735 \$65471 \$65476 NWELL PWELL BULK NAND2_X1
X$143333 \$62735 \$65493 \$65497 NWELL PWELL BULK NAND2_X1
X$143335 \$62735 \$64756 \$65626 NWELL PWELL BULK NAND2_X1
X$143339 \$62735 \$64750 \$64889 NWELL PWELL BULK NAND2_X1
X$143341 \$62735 \$65053 \$65460 NWELL PWELL BULK NAND2_X1
X$143343 \$62735 \$65054 \$64884 NWELL PWELL BULK NAND2_X1
X$143375 \$72306 \$72307 \$62768 NWELL PWELL BULK NOR2_X1
X$143382 \$63884 S2_AXI_AWADDR[5] NWELL PWELL BULK BUF_X1
X$143439 \$64951 \$62784 \$64948 \$65160 NWELL PWELL BULK MUX2_X1
X$143478 \$64366 \$62794 \$64570 \$64899 NWELL PWELL BULK MUX2_X1
X$143481 \$64132 \$62794 \$63369 \$64011 NWELL PWELL BULK MUX2_X1
X$143484 \$68787 \$62794 \$68994 \$68918 NWELL PWELL BULK MUX2_X1
X$143486 \$65969 \$62794 \$66140 \$66139 NWELL PWELL BULK MUX2_X1
X$143489 \$68111 \$62794 \$67591 \$67772 NWELL PWELL BULK MUX2_X1
X$143491 \$65974 \$62794 \$66269 \$65545 NWELL PWELL BULK MUX2_X1
X$143493 \$66470 \$62794 \$66128 \$65686 NWELL PWELL BULK MUX2_X1
X$143498 \$64545 \$62794 \$64544 \$64347 NWELL PWELL BULK MUX2_X1
X$143502 \$71835 \$66260 \$I245679 \$62794 NWELL PWELL BULK DFF_X2
X$143504 \$70791 \$62794 \$71092 \$71194 NWELL PWELL BULK MUX2_X1
X$143506 \$69604 \$62794 \$68127 \$67122 NWELL PWELL BULK MUX2_X1
X$143508 \$64975 \$62794 \$65252 \$64814 NWELL PWELL BULK MUX2_X1
X$143510 \$66968 \$62794 \$67764 \$67581 NWELL PWELL BULK MUX2_X1
X$143558 \$64723 \$63110 \$62814 \$63928 NWELL PWELL BULK MUX2_X1
X$143562 \$62814 \$63052 \$63389 \$63394 NWELL PWELL BULK MUX2_X1
X$143565 \$62815 \$64390 \$65374 \$64724 NWELL PWELL BULK MUX2_X1
X$143567 \$62815 \$63054 \$63097 \$63391 NWELL PWELL BULK MUX2_X1
X$143569 \$62815 \$63110 \$63096 \$63390 NWELL PWELL BULK MUX2_X1
X$143571 \$65598 \$63408 \$62815 \$65597 NWELL PWELL BULK MUX2_X1
X$143573 S1_AXI_RID[2] \$62815 NWELL PWELL BULK CLKBUF_X2
X$143581 \$63103 \$62817 \$63098 \$63396 NWELL PWELL BULK NAND3_X1
X$143583 \$63935 \$62817 \$63102 \$63932 NWELL PWELL BULK NAND3_X1
X$143585 \$62820 \$62817 NWELL PWELL BULK INV_X2
X$143602 \$64922 \$63394 \$63098 \$62819 NWELL PWELL BULK MUX2_X2
X$143615 \$63937 \$63408 \$62822 \$64259 NWELL PWELL BULK MUX2_X1
X$143617 \$62822 \$63054 \$63111 \$63112 NWELL PWELL BULK MUX2_X1
X$143620 \$62822 \$63110 \$63403 \$63318 NWELL PWELL BULK MUX2_X1
X$143623 \$62822 \$64390 \$64913 \$64916 NWELL PWELL BULK MUX2_X1
X$143627 S1_AXI_RID[4] \$62822 NWELL PWELL BULK CLKBUF_X2
X$143634 \$63404 \$63110 \$63305 \$62823 NWELL PWELL BULK MUX2_X1
X$143637 \$63411 \$63110 \$62825 \$63049 NWELL PWELL BULK MUX2_X1
X$143641 \$62825 \$63052 \$63116 \$63782 NWELL PWELL BULK MUX2_X1
X$143651 \$70481 \$62831 \$71136 \$71137 NWELL PWELL BULK MUX2_X1
X$143654 \$69270 \$62831 \$68855 \$69505 NWELL PWELL BULK MUX2_X1
X$143657 \$68362 \$62831 \$68367 \$68452 NWELL PWELL BULK MUX2_X1
X$143659 \$66331 \$62831 \$66015 \$67028 NWELL PWELL BULK MUX2_X1
X$143662 \$66012 \$62831 \$66329 \$66875 NWELL PWELL BULK MUX2_X1
X$143664 \$69271 \$62831 \$69743 \$70485 NWELL PWELL BULK MUX2_X1
X$143667 \$63834 \$62831 \$63432 \$64316 NWELL PWELL BULK MUX2_X1
X$143669 \$63958 \$62831 \$64283 \$64279 NWELL PWELL BULK MUX2_X1
X$143671 \$65038 \$62831 \$65039 \$65618 NWELL PWELL BULK MUX2_X1
X$143674 \$64401 \$62831 \$65619 \$65046 NWELL PWELL BULK MUX2_X1
X$143677 \$75209 \$62831 \$75596 \$74877 NWELL PWELL BULK MUX2_X1
X$143679 \$71896 \$62831 \$72287 \$72617 NWELL PWELL BULK MUX2_X1
X$143682 \$67625 \$62831 \$67627 \$68456 NWELL PWELL BULK MUX2_X1
X$143684 \$67021 \$62831 \$66010 \$67488 NWELL PWELL BULK MUX2_X1
X$143686 \$67922 \$62831 \$68344 \$68338 NWELL PWELL BULK MUX2_X1
X$143688 \$65504 \$62831 \$65921 \$65929 NWELL PWELL BULK MUX2_X1
X$143690 \$62831 \$70387 NWELL PWELL BULK BUF_X16
X$143692 \$68847 \$62831 \$69112 \$69642 NWELL PWELL BULK MUX2_X1
X$143694 \$74036 \$62831 \$74037 \$74446 NWELL PWELL BULK MUX2_X1
X$143696 \$72613 \$62831 \$73267 \$73952 NWELL PWELL BULK MUX2_X1
X$143698 \$70370 \$62831 \$69897 \$70372 NWELL PWELL BULK MUX2_X1
X$143704 \$63953 \$62831 \$63429 \$63954 NWELL PWELL BULK MUX2_X1
X$143706 \$64897 \$62831 \$65537 \$65044 NWELL PWELL BULK MUX2_X1
X$143710 \$63956 \$62831 \$63133 \$63851 NWELL PWELL BULK MUX2_X1
X$143743 \$63453 \$63823 \$62836 NWELL PWELL BULK XOR2_X1
X$143753 M1_AXI_RREADY \$62847 NWELL PWELL BULK CLKBUF_X2
X$143761 \$65077 \$62856 \$62857 NWELL PWELL BULK NOR2_X1
X$143800 \$63553 S1_AXI_WDATA[1] NWELL PWELL BULK BUF_X1
X$143888 \$63015 \$64266 \$65941 NWELL PWELL BULK NAND2_X1
X$143890 \$63015 \$64756 \$64888 NWELL PWELL BULK NAND2_X1
X$143892 \$63015 \$64750 \$64890 NWELL PWELL BULK NAND2_X1
X$143894 \$63015 \$63961 \$64639 NWELL PWELL BULK NAND2_X1
X$143899 \$63015 \$63451 \$64760 NWELL PWELL BULK NAND2_X1
X$143934 \$63305 \$63052 \$63050 \$63114 NWELL PWELL BULK MUX2_X1
X$143940 \$64286 \$63052 \$64393 \$64652 NWELL PWELL BULK MUX2_X1
X$143943 \$65015 \$63052 \$65422 \$65440 NWELL PWELL BULK MUX2_X1
X$143947 \$63937 \$63052 \$64913 \$63935 NWELL PWELL BULK MUX2_X1
X$143949 \$76230 \$63052 \$76231 \$76493 NWELL PWELL BULK MUX2_X1
X$143951 \$72601 \$63052 \$73006 \$73009 NWELL PWELL BULK MUX2_X1
X$143953 \$63096 \$63052 \$63097 \$64244 NWELL PWELL BULK MUX2_X1
X$143956 \$67898 \$63052 \$68446 \$68321 NWELL PWELL BULK MUX2_X1
X$143959 \$68744 \$63052 \$68309 \$68320 NWELL PWELL BULK MUX2_X1
X$143962 \$64394 \$63052 \$64661 \$64310 NWELL PWELL BULK MUX2_X1
X$143965 \$68276 \$63052 \$69140 \$68439 NWELL PWELL BULK MUX2_X1
X$143968 \$63403 \$63052 \$63111 \$63103 NWELL PWELL BULK MUX2_X1
X$143972 \$64734 \$63052 \$65011 \$64736 NWELL PWELL BULK MUX2_X1
X$143974 \$63405 \$63052 \$63407 \$63771 NWELL PWELL BULK MUX2_X1
X$143976 \$64921 \$64919 \$63052 \$65389 NWELL PWELL BULK OAI21_X1
X$143978 \$63052 \$65601 \$65389 \$64386 NWELL PWELL BULK OAI21_X1
X$143980 \$65598 \$63052 \$65374 \$64725 NWELL PWELL BULK MUX2_X1
X$143982 \$63052 \$65370 NWELL PWELL BULK BUF_X16
X$143984 \$64999 \$63052 \$65368 \$64922 NWELL PWELL BULK MUX2_X1
X$143988 \$75872 \$63052 \$75873 \$76158 NWELL PWELL BULK MUX2_X1
X$143991 \$71528 \$63052 \$72188 \$72465 NWELL PWELL BULK MUX2_X1
X$143993 \$63416 \$63052 \$63417 \$64308 NWELL PWELL BULK MUX2_X1
X$143995 \$70299 \$63052 \$69635 \$69636 NWELL PWELL BULK MUX2_X1
X$143997 \$67597 \$63052 \$66981 \$67313 NWELL PWELL BULK MUX2_X1
X$143999 \$66284 \$63052 \$66286 \$66285 NWELL PWELL BULK MUX2_X1
X$144031 \$81825 \$63054 \$82367 \$81828 NWELL PWELL BULK MUX2_X1
X$144034 \$72570 \$63054 \$73335 \$73336 NWELL PWELL BULK MUX2_X1
X$144036 \$71861 \$63054 \$71739 \$72115 NWELL PWELL BULK MUX2_X1
X$144038 \$76896 \$63054 \$76780 \$76775 NWELL PWELL BULK MUX2_X1
X$144041 \$74838 \$63054 \$75365 \$75364 NWELL PWELL BULK MUX2_X1
X$144044 \$78052 \$63054 \$78675 \$78963 NWELL PWELL BULK MUX2_X1
X$144047 \$77172 \$63054 \$78039 \$78038 NWELL PWELL BULK MUX2_X1
X$144049 \$78994 \$63054 \$79922 \$79764 NWELL PWELL BULK MUX2_X1
X$144052 \$81829 \$63054 \$82387 \$82380 NWELL PWELL BULK MUX2_X1
X$144056 \$81444 \$63054 \$82432 \$82430 NWELL PWELL BULK MUX2_X1
X$144059 \$66980 \$63054 \$67320 \$67322 NWELL PWELL BULK MUX2_X1
X$144062 \$79194 \$63054 \$79581 \$79939 NWELL PWELL BULK MUX2_X1
X$144065 \$78643 \$63054 \$79933 \$79352 NWELL PWELL BULK MUX2_X1
X$144072 \$65010 \$63054 \$65422 \$65874 NWELL PWELL BULK MUX2_X1
X$144074 \$71791 \$63054 \$71790 \$71888 NWELL PWELL BULK MUX2_X1
X$144076 \$64920 \$63054 \$65007 \$65397 NWELL PWELL BULK MUX2_X1
X$144078 \$63120 \$63054 \$63417 \$63415 NWELL PWELL BULK MUX2_X1
X$144080 \$72248 \$63054 \$73803 \$73799 NWELL PWELL BULK MUX2_X1
X$144083 \$66710 \$63054 \$67809 \$67351 NWELL PWELL BULK MUX2_X1
X$144086 \$64611 \$63385 \$64995 \$63054 NWELL PWELL BULK NAND3_X4
X$144089 \$78686 \$63054 \$78964 \$78966 NWELL PWELL BULK MUX2_X1
X$144091 \$63411 \$63054 \$63116 \$63787 NWELL PWELL BULK MUX2_X1
X$144094 \$64723 \$63054 \$63389 \$63388 NWELL PWELL BULK MUX2_X1
X$144097 \$65002 \$63054 \$64727 \$65004 NWELL PWELL BULK MUX2_X1
X$144101 \$67618 \$63054 \$68742 \$68743 NWELL PWELL BULK MUX2_X1
X$144103 \$75780 \$63054 \$76156 \$76155 NWELL PWELL BULK MUX2_X1
X$144105 \$67890 \$63054 \$71049 \$70761 NWELL PWELL BULK MUX2_X1
X$144107 \$73436 \$63054 \$73830 \$73826 NWELL PWELL BULK MUX2_X1
X$144110 \$71121 \$63054 \$72158 \$72513 NWELL PWELL BULK MUX2_X1
X$144113 \$68713 \$63054 \$70720 \$69859 NWELL PWELL BULK MUX2_X1
X$144115 \$79777 \$63054 \$80006 \$80000 NWELL PWELL BULK MUX2_X1
X$144118 \$80982 \$63054 \$80988 \$80989 NWELL PWELL BULK MUX2_X1
X$144120 \$81441 \$63054 \$82208 \$82398 NWELL PWELL BULK MUX2_X1
X$144122 \$81462 \$63054 \$82561 \$82770 NWELL PWELL BULK MUX2_X1
X$144124 \$80466 \$63054 \$81120 \$81122 NWELL PWELL BULK MUX2_X1
X$144127 \$81172 \$63054 \$82798 \$82568 NWELL PWELL BULK MUX2_X1
X$144129 \$80110 \$63054 \$81458 \$81722 NWELL PWELL BULK MUX2_X1
X$144132 \$69621 \$63054 \$70195 \$70192 NWELL PWELL BULK MUX2_X1
X$144134 \$79783 \$63054 \$80413 \$80411 NWELL PWELL BULK MUX2_X1
X$144136 \$73994 \$63054 \$75383 \$75059 NWELL PWELL BULK MUX2_X1
X$144139 \$75844 \$63054 \$77600 \$77860 NWELL PWELL BULK MUX2_X1
X$144197 \$63586 S2_AXI_AWADDR[20] NWELL PWELL BULK BUF_X1
X$144202 \$63529 S2_AXI_AWADDR[3] NWELL PWELL BULK BUF_X1
X$144226 \$71200 \$63057 \$71580 NWELL PWELL BULK OR2_X1
X$144311 \$63387 \$63093 \$63714 NWELL PWELL BULK XNOR2_X2
X$144332 \$68320 \$63098 \$68321 \$67900 NWELL PWELL BULK MUX2_X1
X$144334 \$68439 \$63098 \$69636 \$69637 NWELL PWELL BULK MUX2_X1
X$144336 \$66711 \$63098 \$67358 \$67361 NWELL PWELL BULK MUX2_X1
X$144339 \$63098 \$64652 \$63945 NWELL PWELL BULK OR2_X1
X$144342 \$63098 \$63771 \$63770 NWELL PWELL BULK OR2_X1
X$144344 \$63098 \$63102 NWELL PWELL BULK INV_X4
X$144347 \$63098 \$64736 \$65442 NWELL PWELL BULK OR2_X1
X$144350 \$65385 \$65005 \$63098 \$64921 NWELL PWELL BULK NOR3_X1
X$144352 \$63098 \$64725 \$64384 NWELL PWELL BULK OR2_X1
X$144357 \$64922 \$63098 \$63736 NWELL PWELL BULK NOR2_X1
X$144361 \$63098 \$66985 NWELL PWELL BULK BUF_X16
X$144364 \$76158 \$63098 \$76493 \$75876 NWELL PWELL BULK MUX2_X1
X$144366 \$73009 \$63098 \$72465 \$72602 NWELL PWELL BULK MUX2_X1
X$144368 \$63098 \$64310 \$63797 NWELL PWELL BULK OR2_X1
X$144371 \$66300 \$66229 \$63098 \$66599 NWELL PWELL BULK NOR3_X1
X$144373 \$66599 \$63098 \$66302 \$65601 NWELL PWELL BULK AOI21_X1
X$144375 \$69493 \$63098 \$69111 \$68246 NWELL PWELL BULK MUX2_X1
X$144406 \$64727 \$65007 \$63102 \$64919 NWELL PWELL BULK NOR3_X1
X$144410 \$63394 \$63102 \$63742 NWELL PWELL BULK NOR2_X1
X$144434 \$72570 \$63110 \$71864 \$72476 NWELL PWELL BULK MUX2_X1
X$144437 \$81829 \$63110 \$81982 \$81979 NWELL PWELL BULK MUX2_X1
X$144440 \$75844 \$63110 \$77166 \$77018 NWELL PWELL BULK MUX2_X1
X$144443 \$79783 \$63110 \$80471 \$80746 NWELL PWELL BULK MUX2_X1
X$144447 \$80982 \$63110 \$80835 \$80979 NWELL PWELL BULK MUX2_X1
X$144449 \$81825 \$63110 \$82696 \$82366 NWELL PWELL BULK MUX2_X1
X$144453 \$79194 \$63110 \$79199 \$79355 NWELL PWELL BULK MUX2_X1
X$144456 \$78643 \$63110 \$79562 \$79561 NWELL PWELL BULK MUX2_X1
X$144459 \$65839 \$63385 \$64995 \$63110 NWELL PWELL BULK NAND3_X4
X$144462 \$74838 \$63110 \$75046 \$75048 NWELL PWELL BULK MUX2_X1
X$144464 \$66980 \$63110 \$66910 \$66704 NWELL PWELL BULK MUX2_X1
X$144469 \$65010 \$63110 \$65015 \$64738 NWELL PWELL BULK MUX2_X1
X$144472 \$63120 \$63110 \$63416 \$63119 NWELL PWELL BULK MUX2_X1
X$144475 \$73436 \$63110 \$74007 \$74284 NWELL PWELL BULK MUX2_X1
X$144478 \$68713 \$63110 \$69240 \$69775 NWELL PWELL BULK MUX2_X1
X$144481 \$67890 \$63110 \$69764 \$70288 NWELL PWELL BULK MUX2_X1
X$144484 \$66710 \$63110 \$66709 \$66988 NWELL PWELL BULK MUX2_X1
X$144486 \$75780 \$63110 \$76494 \$76228 NWELL PWELL BULK MUX2_X1
X$144494 \$67618 \$63110 \$67788 \$68316 NWELL PWELL BULK MUX2_X1
X$144496 \$71791 \$63110 \$71027 \$71028 NWELL PWELL BULK MUX2_X1
X$144499 \$65002 \$63110 \$65989 \$66593 NWELL PWELL BULK MUX2_X1
X$144501 \$64920 \$63110 \$65990 \$65606 NWELL PWELL BULK MUX2_X1
X$144503 \$71121 \$63110 \$71412 \$71411 NWELL PWELL BULK MUX2_X1
X$144505 \$72248 \$63110 \$73113 \$73791 NWELL PWELL BULK MUX2_X1
X$144507 \$78052 \$63110 \$79020 \$79282 NWELL PWELL BULK MUX2_X1
X$144509 \$78686 \$63110 \$78054 \$78053 NWELL PWELL BULK MUX2_X1
X$144512 \$76896 \$63110 \$77103 \$77099 NWELL PWELL BULK MUX2_X1
X$144515 \$81441 \$63110 \$82001 \$82005 NWELL PWELL BULK MUX2_X1
X$144517 \$81462 \$63110 \$82461 \$82453 NWELL PWELL BULK MUX2_X1
X$144519 \$81172 \$63110 \$82132 \$82507 NWELL PWELL BULK MUX2_X1
X$144521 \$80466 \$63110 \$82791 \$82785 NWELL PWELL BULK MUX2_X1
X$144523 \$79777 \$63110 \$79370 \$79638 NWELL PWELL BULK MUX2_X1
X$144526 \$80110 \$63110 \$81453 \$81454 NWELL PWELL BULK MUX2_X1
X$144528 \$77172 \$63110 \$78651 \$78649 NWELL PWELL BULK MUX2_X1
X$144530 \$81444 \$63110 \$82213 \$82740 NWELL PWELL BULK MUX2_X1
X$144532 \$71861 \$63110 \$72467 \$72469 NWELL PWELL BULK MUX2_X1
X$144534 \$69621 \$63110 \$69227 \$69465 NWELL PWELL BULK MUX2_X1
X$144536 \$73994 \$63110 \$74660 \$74661 NWELL PWELL BULK MUX2_X1
X$144539 \$78994 \$63110 \$79762 \$79918 NWELL PWELL BULK MUX2_X1
X$144629 \$63120 \$64390 \$64661 \$64902 NWELL PWELL BULK MUX2_X1
X$144633 \$64394 \$63408 \$63120 \$64655 NWELL PWELL BULK MUX2_X1
X$144637 S1_AXI_RID[1] \$63120 NWELL PWELL BULK CLKBUF_X2
X$144652 S0_AXI_RRESP[1] \$63126 NWELL PWELL BULK CLKBUF_X2
X$144667 \$63954 \$63955 \$63129 \$65033 NWELL PWELL BULK MUX2_X1
X$144672 \$64316 \$63955 \$63131 \$64667 NWELL PWELL BULK MUX2_X1
X$144682 \$64279 \$63136 \$63955 \$64043 NWELL PWELL BULK MUX2_X2
X$144690 \$63138 \$64266 \$64260 NWELL PWELL BULK XNOR2_X2
X$144793 \$63204 \$63203 \$63544 NWELL PWELL BULK NOR2_X2
X$144815 \$63355 \$63210 NWELL PWELL BULK BUF_X8
X$144883 \$63278 S2_AXI_AWID[2] NWELL PWELL BULK BUF_X1
X$144925 S2_AXI_RDATA[5] \$64018 NWELL PWELL BULK CLKBUF_X2
X$144930 \$64456 S2_AXI_AWADDR[22] NWELL PWELL BULK BUF_X1
X$144950 \$65549 \$63355 \$64948 \$65716 NWELL PWELL BULK MUX2_X1
X$145005 \$I177971 \$63907 \$63374 \$63375 NWELL PWELL BULK DFF_X1
X$145007 \$I177824 \$64970 \$64968 \$63375 NWELL PWELL BULK DFF_X1
X$145010 \$I177961 \$65567 \$65766 \$63375 NWELL PWELL BULK DFF_X1
X$145013 \$I177797 \$64964 \$64965 \$63375 NWELL PWELL BULK DFF_X1
X$145015 \$I177664 \$68982 \$68611 \$63375 NWELL PWELL BULK DFF_X1
X$145018 \$I177901 \$66698 \$67255 \$63375 NWELL PWELL BULK DFF_X1
X$145021 \$I176125 \$66267 \$66490 \$63375 NWELL PWELL BULK DFF_X1
X$145023 \$I175015 \$65570 \$65774 \$63375 NWELL PWELL BULK DFF_X1
X$145025 \$I176376 \$66972 \$67260 \$63375 NWELL PWELL BULK DFF_X1
X$145027 \$I176078 \$66152 \$66493 \$63375 NWELL PWELL BULK DFF_X1
X$145029 \$I175016 \$65572 \$65787 \$63375 NWELL PWELL BULK DFF_X1
X$145032 \$I176401 \$64906 \$65265 \$63375 NWELL PWELL BULK DFF_X1
X$145035 \$I178636 \$64976 \$64977 \$63375 NWELL PWELL BULK DFF_X1
X$145037 \$I177962 \$64973 \$64971 \$63375 NWELL PWELL BULK DFF_X1
X$145041 \$I176645 \$67846 \$68083 \$63375 NWELL PWELL BULK DFF_X1
X$145043 \$I175018 \$65759 \$65226 \$63375 NWELL PWELL BULK DFF_X1
X$145045 \$I177948 \$66265 \$66263 \$63375 NWELL PWELL BULK DFF_X1
X$145048 \$I177947 \$67225 \$67582 \$63375 NWELL PWELL BULK DFF_X1
X$145051 \$I177662 \$66262 \$66692 \$63375 NWELL PWELL BULK DFF_X1
X$145054 \$I177784 \$67585 \$67756 \$63375 NWELL PWELL BULK DFF_X1
X$145056 \$I177949 \$65565 \$66127 \$63375 NWELL PWELL BULK DFF_X1
X$145059 \$I176466 \$65967 \$65765 \$63375 NWELL PWELL BULK DFF_X1
X$145061 \$I176091 \$69207 \$69415 \$63375 NWELL PWELL BULK DFF_X1
X$145063 \$I177920 \$66971 \$67244 \$63375 NWELL PWELL BULK DFF_X1
X$145065 \$I177910 \$68108 \$68628 \$63375 NWELL PWELL BULK DFF_X1
X$145069 \$I176113 \$67588 \$67587 \$63375 NWELL PWELL BULK DFF_X1
X$145071 \$I177938 \$66970 \$67767 \$63375 NWELL PWELL BULK DFF_X1
X$145073 \$I177918 \$69205 \$69203 \$63375 NWELL PWELL BULK DFF_X1
X$145075 \$I177731 \$68405 \$68615 \$63375 NWELL PWELL BULK DFF_X1
X$145111 \$63385 \$63706 \$63709 NWELL PWELL BULK XNOR2_X2
X$145113 \$64716 \$65839 \$63385 \$64390 NWELL PWELL BULK OR3_X4
X$145115 \$63385 \$64611 \$64716 \$63408 NWELL PWELL BULK NOR3_X4
X$145117 \$64716 \$63385 \$65982 NWELL PWELL BULK NAND2_X1
X$145119 \$65848 \$64993 \$I245603 \$63385 NWELL PWELL BULK DFF_X2
X$145129 \$64716 \$63387 \$64720 NWELL PWELL BULK NAND2_X1
X$145156 \$64386 \$63400 \$63409 \$63401 NWELL PWELL BULK AND3_X1
X$145165 \$63405 \$63408 \$63404 \$64272 NWELL PWELL BULK MUX2_X1
X$145170 \$63404 \$64390 \$63407 \$64737 NWELL PWELL BULK MUX2_X1
X$145175 S1_AXI_RLAST \$63404 NWELL PWELL BULK CLKBUF_X2
X$145196 \$75871 \$63408 \$75780 \$75781 NWELL PWELL BULK MUX2_X1
X$145198 \$68442 \$63408 \$67618 \$68748 NWELL PWELL BULK MUX2_X1
X$145200 \$64999 \$63408 \$64723 \$65850 NWELL PWELL BULK MUX2_X1
X$145205 \$66300 \$63408 \$65002 \$66928 NWELL PWELL BULK MUX2_X1
X$145207 \$66229 \$63408 \$64920 \$65604 NWELL PWELL BULK MUX2_X1
X$145215 \$64286 \$63408 \$63411 \$64284 NWELL PWELL BULK MUX2_X1
X$145218 \$64734 \$63408 \$65010 \$64911 NWELL PWELL BULK MUX2_X1
X$145220 \$67598 \$63408 NWELL PWELL BULK BUF_X8
X$145225 \$72472 \$63408 \$71791 \$72478 NWELL PWELL BULK MUX2_X1
X$145228 \$68268 \$63408 \$67890 \$67614 NWELL PWELL BULK MUX2_X1
X$145230 \$65596 \$63408 \$66710 \$66572 NWELL PWELL BULK MUX2_X1
X$145232 \$67885 \$63408 NWELL PWELL BULK BUF_X8
X$145260 \$63411 \$64390 \$64393 \$65447 NWELL PWELL BULK MUX2_X1
X$145264 S1_AXI_RID[0] \$63411 NWELL PWELL BULK CLKBUF_X2
X$145287 S0_AXI_RDATA[6] \$63419 NWELL PWELL BULK CLKBUF_X2
X$145317 \$69517 \$63428 \$68372 \$68852 NWELL PWELL BULK AOI21_X1
X$145320 \$69269 \$63428 NWELL PWELL BULK BUF_X8
X$145323 \$63428 \$66331 \$66870 NWELL PWELL BULK NOR2_X1
X$145325 \$63428 \$66012 \$66674 NWELL PWELL BULK NOR2_X1
X$145328 \$66674 \$63428 \$66307 \$66325 NWELL PWELL BULK AOI21_X1
X$145331 \$63428 \$68847 \$68450 NWELL PWELL BULK NOR2_X1
X$145334 \$68450 \$63428 \$67910 \$69125 NWELL PWELL BULK AOI21_X1
X$145337 \$75880 \$63428 \$76238 \$75878 NWELL PWELL BULK AOI21_X1
X$145340 \$63428 \$74036 \$74789 NWELL PWELL BULK NOR2_X1
X$145343 \$74789 \$63428 \$74443 \$74792 NWELL PWELL BULK AOI21_X1
X$145346 \$63428 \$70481 \$71019 NWELL PWELL BULK NOR2_X1
X$145349 \$71019 \$63428 \$69748 \$70831 NWELL PWELL BULK AOI21_X1
X$145352 \$72285 \$63428 \$72450 \$73059 NWELL PWELL BULK AOI21_X1
X$145354 \$63428 \$71896 \$72285 NWELL PWELL BULK NOR2_X1
X$145359 \$64744 \$63428 \$65031 \$65030 NWELL PWELL BULK AOI21_X1
X$145362 \$63428 \$65504 \$64744 NWELL PWELL BULK NOR2_X1
X$145365 \$66870 \$63428 \$66203 \$66664 NWELL PWELL BULK AOI21_X1
X$145368 \$63428 \$78698 \$78924 NWELL PWELL BULK NOR2_X1
X$145370 \$63428 \$77499 \$77441 NWELL PWELL BULK NOR2_X1
X$145372 \$77441 \$63428 \$77497 \$77201 NWELL PWELL BULK AOI21_X1
X$145374 \$63428 \$76239 \$75880 NWELL PWELL BULK NOR2_X1
X$145377 \$78924 \$63428 \$78067 \$78930 NWELL PWELL BULK AOI21_X1
X$145416 \$63431 \$82590 \$82440 NWELL PWELL BULK NAND2_X1
X$145419 \$66307 \$63431 \$67496 \$67023 NWELL PWELL BULK OAI21_X1
X$145421 \$63431 \$66329 \$67496 NWELL PWELL BULK NAND2_X1
X$145423 \$68372 \$63431 \$68457 \$69501 NWELL PWELL BULK OAI21_X1
X$145425 \$63431 \$68855 \$68457 NWELL PWELL BULK NAND2_X1
X$145428 \$69647 \$63431 \$69649 \$69906 NWELL PWELL BULK OAI21_X1
X$145431 \$63431 \$69907 \$69649 NWELL PWELL BULK NAND2_X1
X$145434 \$63431 \$70482 \$69900 NWELL PWELL BULK NAND2_X1
X$145436 \$67910 \$63431 \$68850 \$69521 NWELL PWELL BULK OAI21_X1
X$145439 \$63431 \$69112 \$68850 NWELL PWELL BULK NAND2_X1
X$145442 \$69643 \$63431 \$69900 \$69898 NWELL PWELL BULK OAI21_X1
X$145444 \$63431 \$71136 \$71138 NWELL PWELL BULK NAND2_X1
X$145446 \$69748 \$63431 \$71138 \$71450 NWELL PWELL BULK OAI21_X1
X$145448 \$72450 \$63431 \$72615 \$71897 NWELL PWELL BULK OAI21_X1
X$145450 \$63431 \$72287 \$72615 NWELL PWELL BULK NAND2_X1
X$145452 \$63431 \$71413 \$71415 NWELL PWELL BULK NAND2_X1
X$145454 \$71002 \$63431 \$71415 \$71750 NWELL PWELL BULK OAI21_X1
X$145456 \$72288 \$63431 \$73034 \$73040 NWELL PWELL BULK OAI21_X1
X$145459 \$63431 \$72620 \$73034 NWELL PWELL BULK NAND2_X1
X$145463 \$65031 \$63431 \$65034 \$65919 NWELL PWELL BULK OAI21_X1
X$145466 \$63431 \$65921 \$65034 NWELL PWELL BULK NAND2_X1
X$145469 \$63431 \$66015 \$66200 NWELL PWELL BULK NAND2_X1
X$145471 \$66203 \$63431 \$66200 \$66014 NWELL PWELL BULK OAI21_X1
X$145473 \$76150 \$63431 \$75892 \$76449 NWELL PWELL BULK OAI21_X1
X$145475 \$63431 \$75893 \$75892 NWELL PWELL BULK NAND2_X1
X$145477 \$82241 \$63431 \$82452 \$82245 NWELL PWELL BULK OAI21_X1
X$145479 \$63431 \$82865 \$82452 NWELL PWELL BULK NAND2_X1
X$145481 \$81188 \$63431 \$82086 \$81741 NWELL PWELL BULK OAI21_X1
X$145483 \$63431 \$81191 \$82086 NWELL PWELL BULK NAND2_X1
X$145486 \$63431 \$80889 \$80754 NWELL PWELL BULK NAND2_X1
X$145489 \$80146 \$63431 \$80754 \$80501 NWELL PWELL BULK OAI21_X1
X$145492 \$82067 \$63431 \$82440 \$82838 NWELL PWELL BULK OAI21_X1
X$145495 \$63431 \$80794 \$80800 NWELL PWELL BULK NAND2_X1
X$145497 \$80355 \$63431 \$80800 \$80878 NWELL PWELL BULK OAI21_X1
X$145499 \$63431 \$82246 \$82843 NWELL PWELL BULK NAND2_X1
X$145502 \$82581 \$63431 \$82843 \$82450 NWELL PWELL BULK OAI21_X1
X$145505 \$78720 \$63431 \$79246 \$79249 NWELL PWELL BULK OAI21_X1
X$145507 \$63431 \$79422 \$79246 NWELL PWELL BULK NAND2_X1
X$145509 \$63431 \$83493 \$84126 NWELL PWELL BULK NAND2_X1
X$145511 \$82817 \$63431 \$84126 \$84133 NWELL PWELL BULK OAI21_X1
X$145513 \$63431 \$80156 \$80708 NWELL PWELL BULK NAND2_X1
X$145515 \$79801 \$63431 \$80708 \$80724 NWELL PWELL BULK OAI21_X1
X$145517 \$63431 \$82031 \$81885 NWELL PWELL BULK NAND2_X1
X$145519 \$81082 \$63431 \$81701 \$81707 NWELL PWELL BULK OAI21_X1
X$145521 \$63431 \$80893 \$81701 NWELL PWELL BULK NAND2_X1
X$145523 \$81881 \$63431 \$81885 \$82591 NWELL PWELL BULK OAI21_X1
X$145525 \$63431 \$78345 \$78918 NWELL PWELL BULK NAND2_X1
X$145527 \$78067 \$63431 \$78918 \$78928 NWELL PWELL BULK OAI21_X1
X$145529 \$78707 \$63431 \$79271 \$79799 NWELL PWELL BULK OAI21_X1
X$145531 \$63431 \$79040 \$79271 NWELL PWELL BULK NAND2_X1
X$145534 \$76238 \$63431 \$76913 \$77117 NWELL PWELL BULK OAI21_X1
X$145536 \$63431 \$79420 \$79594 NWELL PWELL BULK NAND2_X1
X$145539 \$79042 \$63431 \$79594 \$79976 NWELL PWELL BULK OAI21_X1
X$145542 \$63431 \$74891 \$74889 NWELL PWELL BULK NAND2_X1
X$145544 \$74443 \$63431 \$74447 \$74781 NWELL PWELL BULK OAI21_X1
X$145546 \$63431 \$74037 \$74447 NWELL PWELL BULK NAND2_X1
X$145548 \$74040 \$63431 \$74881 \$75485 NWELL PWELL BULK OAI21_X1
X$145551 \$73132 \$63431 \$74889 \$75600 NWELL PWELL BULK OAI21_X1
X$145554 \$63431 \$75098 \$74881 NWELL PWELL BULK NAND2_X1
X$145557 \$63431 \$76565 \$76913 NWELL PWELL BULK NAND2_X1
X$145559 \$77497 \$63431 \$77672 \$77500 NWELL PWELL BULK OAI21_X1
X$145561 \$63431 \$77669 \$77672 NWELL PWELL BULK NAND2_X1
X$145563 \$76159 \$63431 \$76917 \$77106 NWELL PWELL BULK OAI21_X1
X$145565 \$63431 \$76823 \$76917 NWELL PWELL BULK NAND2_X1
X$145567 \$63431 \$77211 \$77208 NWELL PWELL BULK NAND2_X1
X$145569 \$77092 \$63431 \$77208 \$77656 NWELL PWELL BULK OAI21_X1
X$145571 \$77767 \$63431 \$77506 \$77424 NWELL PWELL BULK OAI21_X1
X$145573 \$63431 \$77507 \$77506 NWELL PWELL BULK NAND2_X1
X$145654 \$63442 \$63443 NWELL PWELL BULK INV_X1
X$145658 \$63442 \$63961 \$64265 NWELL PWELL BULK XNOR2_X2
X$145676 \$63452 \$63451 \$63962 NWELL PWELL BULK XNOR2_X2
X$145764 M2_AXI_WSTRB[0] \$64042 NWELL PWELL BULK CLKBUF_X2
X$145769 M0_AXI_WDATA[17] \$63992 NWELL PWELL BULK BUF_X1
X$145774 \$64043 M1_AXI_RID[3] NWELL PWELL BULK BUF_X1
X$145823 \$71468 \$63530 \$71469 NWELL PWELL BULK OR2_X1
X$145859 \$63537 S1_AXI_WDATA[3] NWELL PWELL BULK BUF_X1
X$145869 \$63544 \$71173 \$78105 \$78124 NWELL PWELL BULK OAI21_X1
X$145872 \$70521 \$63544 \$79087 \$79086 NWELL PWELL BULK OAI21_X1
X$145875 \$63544 \$70514 \$79085 \$79455 NWELL PWELL BULK OAI21_X1
X$145878 \$63544 \$71156 \$78401 \$78766 NWELL PWELL BULK OAI21_X1
X$145919 \$63575 S2_AXI_AWADDR[30] NWELL PWELL BULK BUF_X1
X$145996 \$63666 S0_AXI_AWLEN[7] NWELL PWELL BULK BUF_X1
X$146014 \$63673 S0_AXI_AWID[6] NWELL PWELL BULK BUF_X1
X$146045 \$63695 S0_AXI_AWID[5] NWELL PWELL BULK BUF_X1
X$146117 \$63791 S1_AXI_WDATA[21] NWELL PWELL BULK BUF_X1
X$146171 \$64347 S2_AXI_AWID[0] NWELL PWELL BULK BUF_X1
X$146176 \$64011 S2_AXI_AWID[5] NWELL PWELL BULK BUF_X1
X$146257 \$64187 \$63919 NWELL PWELL BULK INV_X1
X$146294 \$65929 \$63955 \$65618 \$65927 NWELL PWELL BULK MUX2_X1
X$146303 \$83709 \$63955 \$84112 \$83704 NWELL PWELL BULK MUX2_X1
X$146306 \$82418 \$63955 \$82788 \$83210 NWELL PWELL BULK MUX2_X1
X$146308 \$81693 \$63955 \$81674 \$82026 NWELL PWELL BULK MUX2_X1
X$146310 \$82827 \$63955 \$84139 \$84716 NWELL PWELL BULK MUX2_X1
X$146313 \$79969 \$63955 \$79418 \$79972 NWELL PWELL BULK MUX2_X1
X$146315 \$78230 \$63955 \$78357 \$78867 NWELL PWELL BULK MUX2_X1
X$146318 \$79413 \$63955 \$79265 \$79639 NWELL PWELL BULK MUX2_X1
X$146321 \$76472 \$63955 \$76465 \$76851 NWELL PWELL BULK MUX2_X1
X$146323 \$73021 \$63955 \$72624 \$73254 NWELL PWELL BULK MUX2_X1
X$146326 \$77397 \$63955 \$76573 \$77396 NWELL PWELL BULK MUX2_X1
X$146328 \$74892 \$63955 \$75081 \$75461 NWELL PWELL BULK MUX2_X1
X$146331 \$75482 \$63955 \$75480 \$75750 NWELL PWELL BULK MUX2_X1
X$146334 \$76250 \$63955 \$75886 \$76824 NWELL PWELL BULK MUX2_X1
X$146336 \$82917 \$63955 \$84741 \$84745 NWELL PWELL BULK MUX2_X1
X$146339 \$66875 \$63955 \$67488 \$67768 NWELL PWELL BULK MUX2_X1
X$146343 \$69505 \$63955 \$68456 \$69745 NWELL PWELL BULK MUX2_X1
X$146346 \$67028 \$63955 \$68338 \$68690 NWELL PWELL BULK MUX2_X1
X$146348 \$69908 \$63955 \$70485 \$70708 NWELL PWELL BULK MUX2_X1
X$146351 \$69642 \$63955 \$68452 \$70376 NWELL PWELL BULK MUX2_X1
X$146353 \$72617 \$63955 \$73952 \$73950 NWELL PWELL BULK MUX2_X1
X$146357 \$71536 \$63955 \$71756 \$84724 NWELL PWELL BULK MUX2_X1
X$146360 \$72442 \$63955 \$73923 \$73261 NWELL PWELL BULK MUX2_X1
X$146362 \$71137 \$63955 \$70372 \$72167 NWELL PWELL BULK MUX2_X1
X$146366 \$65044 \$63955 \$65046 \$65516 NWELL PWELL BULK MUX2_X1
X$146369 \$81192 \$63955 \$82447 \$83208 NWELL PWELL BULK MUX2_X1
X$146373 \$81019 \$63955 \$80731 \$80891 NWELL PWELL BULK MUX2_X1
X$146376 \$80880 \$63955 \$81045 \$81063 NWELL PWELL BULK MUX2_X1
X$146379 \$82586 \$63955 \$84170 \$83744 NWELL PWELL BULK MUX2_X1
X$146383 \$80158 \$63955 \$80309 \$80313 NWELL PWELL BULK MUX2_X1
X$146385 \$79424 \$63955 \$79574 \$79425 NWELL PWELL BULK MUX2_X1
X$146388 \$76927 \$63955 \$77215 \$77649 NWELL PWELL BULK MUX2_X1
X$146391 \$78701 \$63955 \$78702 \$79288 NWELL PWELL BULK MUX2_X1
X$146393 \$74446 \$63955 \$74877 \$75764 NWELL PWELL BULK MUX2_X1
X$146396 \$77503 \$63955 \$77966 \$79037 NWELL PWELL BULK MUX2_X1
X$146528 \$65175 S2_AXI_WDATA[16] NWELL PWELL BULK BUF_X1
X$146533 \$66384 S2_AXI_WDATA[20] NWELL PWELL BULK BUF_X1
X$146538 \$65666 S2_AXI_WDATA[31] NWELL PWELL BULK BUF_X1
X$146712 \$64179 \$64183 \$64591 NWELL PWELL BULK NOR2_X2
X$146747 \$64604 \$64213 \$64211 \$65065 NWELL PWELL BULK DFF_X1
X$146769 \$71008 \$70449 \$64222 NWELL PWELL BULK NOR2_X1
X$146850 \$64814 S2_AXI_AWLEN[2] NWELL PWELL BULK BUF_X1
X$146855 \$64801 S2_AXI_AWADDR[15] NWELL PWELL BULK BUF_X1
X$146904 \$64611 \$64377 \$64610 NWELL PWELL BULK XNOR2_X2
X$146908 \$64723 \$64390 \$65368 \$64381 NWELL PWELL BULK MUX2_X1
X$146917 \$78052 \$64390 \$78279 \$78334 NWELL PWELL BULK MUX2_X1
X$146919 \$78994 \$64390 \$79547 \$79175 NWELL PWELL BULK MUX2_X1
X$146921 \$81829 \$64390 \$81638 \$81315 NWELL PWELL BULK MUX2_X1
X$146924 \$71861 \$64390 \$73425 \$73767 NWELL PWELL BULK MUX2_X1
X$146927 \$73994 \$64390 \$73415 \$73756 NWELL PWELL BULK MUX2_X1
X$146929 \$79777 \$64390 \$80019 \$80012 NWELL PWELL BULK MUX2_X1
X$146931 \$80982 \$64390 \$81620 \$81619 NWELL PWELL BULK MUX2_X1
X$146933 \$79194 \$64390 \$79201 \$78646 NWELL PWELL BULK MUX2_X1
X$146936 \$81444 \$64390 \$81675 \$81663 NWELL PWELL BULK MUX2_X1
X$146939 \$74838 \$64390 \$76037 \$75738 NWELL PWELL BULK MUX2_X1
X$146942 \$81441 \$64390 \$81657 \$81340 NWELL PWELL BULK MUX2_X1
X$146945 \$78643 \$64390 \$79189 \$78845 NWELL PWELL BULK MUX2_X1
X$146950 \$65010 \$64390 \$65011 \$65414 NWELL PWELL BULK MUX2_X1
X$146952 \$71791 \$64390 \$73003 \$73282 NWELL PWELL BULK MUX2_X1
X$146954 \$65002 \$64390 \$65385 \$65003 NWELL PWELL BULK MUX2_X1
X$146961 \$72248 \$64390 \$71757 \$71511 NWELL PWELL BULK MUX2_X1
X$146963 \$72570 \$64390 \$73786 \$73775 NWELL PWELL BULK MUX2_X1
X$146966 \$68713 \$64390 \$69099 \$69096 NWELL PWELL BULK MUX2_X1
X$146971 \$64920 \$64390 \$65005 \$65382 NWELL PWELL BULK MUX2_X1
X$146973 \$67618 \$64390 \$67619 \$67895 NWELL PWELL BULK MUX2_X1
X$146977 \$67890 \$64390 \$67892 \$67891 NWELL PWELL BULK MUX2_X1
X$146979 \$66710 \$64390 \$66932 \$66298 NWELL PWELL BULK MUX2_X1
X$146982 \$71121 \$64390 \$73303 \$73304 NWELL PWELL BULK MUX2_X1
X$146984 \$73436 \$64390 \$74851 \$75437 NWELL PWELL BULK MUX2_X1
X$146986 \$78686 \$64390 \$79310 \$79305 NWELL PWELL BULK MUX2_X1
X$146990 \$76896 \$64390 \$77953 \$77735 NWELL PWELL BULK MUX2_X1
X$146994 \$77172 \$64390 \$77173 \$77331 NWELL PWELL BULK MUX2_X1
X$146996 \$81825 \$64390 \$82689 \$82680 NWELL PWELL BULK MUX2_X1
X$146998 \$75780 \$64390 \$76825 \$76821 NWELL PWELL BULK MUX2_X1
X$147000 \$80466 \$64390 \$80467 \$81114 NWELL PWELL BULK MUX2_X1
X$147002 \$79783 \$64390 \$80123 \$80422 NWELL PWELL BULK MUX2_X1
X$147004 \$81172 \$64390 \$81411 \$81409 NWELL PWELL BULK MUX2_X1
X$147006 \$81462 \$64390 \$82083 \$82073 NWELL PWELL BULK MUX2_X1
X$147008 \$80110 \$64390 \$80690 \$80692 NWELL PWELL BULK MUX2_X1
X$147010 \$69621 \$64390 \$71365 \$71362 NWELL PWELL BULK MUX2_X1
X$147012 \$66980 \$64390 \$67310 \$67304 NWELL PWELL BULK MUX2_X1
X$147015 \$75844 \$64390 \$76678 \$76676 NWELL PWELL BULK MUX2_X1
X$147077 \$I178882 \$64393 \$65447 \$65608 NWELL PWELL BULK DFF_X1
X$147291 \$64591 \$70514 \$73776 \$74227 NWELL PWELL BULK OAI21_X1
X$147293 \$70521 \$64591 \$74484 \$74993 NWELL PWELL BULK OAI21_X1
X$147295 \$64591 \$71156 \$74607 \$74611 NWELL PWELL BULK OAI21_X1
X$147298 \$64591 \$71173 \$74067 \$73768 NWELL PWELL BULK OAI21_X1
X$147331 \$64715 \$64993 \$I245650 \$64611 NWELL PWELL BULK DFF_X2
X$147335 \$64716 \$64611 \$64717 NWELL PWELL BULK NAND2_X1
X$147337 \$64611 \$65839 NWELL PWELL BULK INV_X1
X$147374 \$64667 M1_AXI_RID[2] NWELL PWELL BULK BUF_X1
X$147400 \$64827 S2_AXI_AWBURST[1] NWELL PWELL BULK BUF_X1
X$147402 \$64899 S2_AXI_AWLEN[1] NWELL PWELL BULK BUF_X1
X$147407 \$I179077 \$64687 \$65127 \$64942 NWELL PWELL BULK DFF_X1
X$147411 \$64687 \$65119 \$64943 \$65693 NWELL PWELL BULK MUX2_X1
X$147429 \$64705 \$64706 \$64979 NWELL PWELL BULK NOR2_X1
X$147454 \$64716 \$65981 \$65979 NWELL PWELL BULK NAND2_X1
X$147456 \$64716 \$64995 NWELL PWELL BULK INV_X4
X$147459 \$64716 \$66708 \$66924 NWELL PWELL BULK NAND2_X1
X$147462 \$67603 \$67342 \$64716 NWELL PWELL BULK NAND2_X4
X$147473 S1_AXI_RID[5] \$64723 NWELL PWELL BULK BUF_X2
X$147515 \$64750 \$64756 \$65471 \$65053 NWELL PWELL BULK HA_X1
X$147557 \$65378 \$64770 \$65381 \$65065 NWELL PWELL BULK DFF_X1
X$147591 \$65100 S1_AXI_WID[2] NWELL PWELL BULK BUF_X1
X$147596 \$65136 S1_AXI_WDATA[31] NWELL PWELL BULK BUF_X1
X$147727 \$64898 \$65913 \$65485 \$65028 NWELL PWELL BULK DFF_X1
X$147774 S1_AXI_RID[6] \$64920 NWELL PWELL BULK CLKBUF_X2
X$147806 \$65545 S2_AXI_AWLEN[0] NWELL PWELL BULK BUF_X1
X$147811 \$65952 S2_AXI_AWSIZE[1] NWELL PWELL BULK BUF_X1
X$147816 S2_AXI_RDATA[8] \$65678 NWELL PWELL BULK CLKBUF_X2
X$147821 \$65686 S2_AXI_AWADDR[14] NWELL PWELL BULK BUF_X1
X$147828 \$64938 \$65119 \$64940 \$65692 NWELL PWELL BULK MUX2_X1
X$147831 \$I174982 \$64938 \$65115 \$64942 NWELL PWELL BULK DFF_X1
X$147839 \$I179067 \$64947 \$65144 \$64942 NWELL PWELL BULK DFF_X1
X$147842 \$I179116 \$64943 \$64944 \$64942 NWELL PWELL BULK DFF_X1
X$147845 \$I179094 \$64951 \$65160 \$64942 NWELL PWELL BULK DFF_X1
X$147847 \$I176714 \$67113 \$66248 \$64942 NWELL PWELL BULK DFF_X1
X$147851 \$I175542 \$66058 \$66394 \$64942 NWELL PWELL BULK DFF_X1
X$147855 \$I175460 \$68018 \$67833 \$64942 NWELL PWELL BULK DFF_X1
X$147858 \$I175579 \$68011 \$67832 \$64942 NWELL PWELL BULK DFF_X1
X$147861 \$I176446 \$66685 \$66951 \$64942 NWELL PWELL BULK DFF_X1
X$147864 \$I178354 \$66954 \$67164 \$64942 NWELL PWELL BULK DFF_X1
X$147866 \$I177707 \$67126 \$67116 \$64942 NWELL PWELL BULK DFF_X1
X$147868 \$I175575 \$68388 \$68000 \$64942 NWELL PWELL BULK DFF_X1
X$147870 \$I178286 \$67565 \$67991 \$64942 NWELL PWELL BULK DFF_X1
X$147873 \$I175582 \$66684 \$67137 \$64942 NWELL PWELL BULK DFF_X1
X$147875 \$I176455 \$65955 \$66250 \$64942 NWELL PWELL BULK DFF_X1
X$147878 \$I175468 \$66252 \$66412 \$64942 NWELL PWELL BULK DFF_X1
X$147880 \$I178387 \$65956 \$65548 \$64942 NWELL PWELL BULK DFF_X1
X$147883 \$I178392 \$69188 \$69359 \$64942 NWELL PWELL BULK DFF_X1
X$147885 \$I175470 \$69186 \$68930 \$64942 NWELL PWELL BULK DFF_X1
X$147888 \$I177769 \$68037 \$68032 \$64942 NWELL PWELL BULK DFF_X1
X$147891 \$I177691 \$67718 \$67720 \$64942 NWELL PWELL BULK DFF_X1
X$147894 \$I177770 \$66254 \$66077 \$64942 NWELL PWELL BULK DFF_X1
X$147897 \$I177775 \$66961 \$67188 \$64942 NWELL PWELL BULK DFF_X1
X$147900 \$I174981 \$65549 \$65716 \$64942 NWELL PWELL BULK DFF_X1
X$147902 \$I174979 \$65553 \$65720 \$64942 NWELL PWELL BULK DFF_X1
X$147905 \$I176559 \$68396 \$68395 \$64942 NWELL PWELL BULK DFF_X1
X$147907 \$I177692 \$66256 \$66832 \$64942 NWELL PWELL BULK DFF_X1
X$147910 \$I177689 \$67836 \$68392 \$64942 NWELL PWELL BULK DFF_X1
X$147913 \$I177766 \$69360 \$68771 \$64942 NWELL PWELL BULK DFF_X1
X$147943 \$64947 \$65119 \$65956 \$64949 NWELL PWELL BULK MUX2_X1
X$148012 \$65585 \$65818 \$64984 \$64993 NWELL PWELL BULK DFF_X1
X$148015 \$64985 \$64986 \$64987 \$65023 NWELL PWELL BULK MUX2_X2
X$148019 \$78831 \$78030 \$64987 \$78836 NWELL PWELL BULK MUX2_X2
X$148021 \$72567 \$72849 \$64987 \$72281 NWELL PWELL BULK MUX2_X2
X$148023 \$83634 \$82887 \$64987 \$81393 NWELL PWELL BULK MUX2_X2
X$148025 \$82694 \$83433 \$64987 \$82224 NWELL PWELL BULK MUX2_X2
X$148027 \$72451 \$72090 \$64987 \$71803 NWELL PWELL BULK MUX2_X2
X$148030 \$72806 \$72818 \$64987 \$72890 NWELL PWELL BULK MUX2_X2
X$148032 \$67301 \$67302 \$64987 \$67307 NWELL PWELL BULK MUX2_X2
X$148035 \$76865 \$76866 \$64987 \$76232 NWELL PWELL BULK MUX2_X2
X$148038 \$80591 \$80078 \$64987 \$80131 NWELL PWELL BULK MUX2_X2
X$148040 \$82659 \$82872 \$64987 \$80871 NWELL PWELL BULK MUX2_X2
X$148043 \$81582 \$81943 \$64987 \$81586 NWELL PWELL BULK MUX2_X2
X$148045 \$78982 \$80075 \$64987 \$79217 NWELL PWELL BULK MUX2_X2
X$148048 \$68144 \$68146 \$64987 \$68148 NWELL PWELL BULK MUX2_X2
X$148050 \$68651 \$69788 \$64987 \$68809 NWELL PWELL BULK MUX2_X2
X$148052 \$76018 \$75729 \$64987 \$74427 NWELL PWELL BULK MUX2_X2
X$148054 \$74202 \$74410 \$64987 \$72866 NWELL PWELL BULK MUX2_X2
X$148057 \$82539 \$64987 \$82351 \$80853 NWELL PWELL BULK MUX2_X1
X$148059 \$70173 \$64987 \$69852 \$69868 NWELL PWELL BULK MUX2_X1
X$148061 \$68185 \$64987 \$68422 \$67607 NWELL PWELL BULK MUX2_X1
X$148064 \$82969 \$82871 \$64987 \$82230 NWELL PWELL BULK MUX2_X2
X$148067 \$81913 \$81920 \$64987 \$81801 NWELL PWELL BULK MUX2_X2
X$148069 \$82962 \$82963 \$64987 \$82234 NWELL PWELL BULK MUX2_X2
X$148071 \$79469 \$79327 \$64987 \$78657 NWELL PWELL BULK MUX2_X2
X$148074 \$78625 \$79486 \$64987 \$78650 NWELL PWELL BULK MUX2_X2
X$148076 \$76630 \$77152 \$64987 \$76526 NWELL PWELL BULK MUX2_X2
X$148078 \$78130 \$78425 \$64987 \$76899 NWELL PWELL BULK MUX2_X2
X$148081 \$81251 \$81422 \$64987 \$81157 NWELL PWELL BULK MUX2_X2
X$148083 \$80564 \$80565 \$64987 \$79393 NWELL PWELL BULK MUX2_X2
X$148090 \$74608 \$74402 \$64987 \$73909 NWELL PWELL BULK MUX2_X2
X$148092 \$75709 \$75552 \$64987 \$75574 NWELL PWELL BULK MUX2_X2
X$148094 \$76980 \$77262 \$64987 \$76867 NWELL PWELL BULK MUX2_X2
X$148097 \$78117 \$77696 \$64987 \$77726 NWELL PWELL BULK MUX2_X2
X$148099 \$72562 \$64987 \$72836 \$72255 NWELL PWELL BULK MUX2_X1
X$148149 \$64991 \$64989 \$64990 \$65316 NWELL PWELL BULK AOI21_X1
X$148151 \$64989 \$66184 \$65832 \$65831 \$65830 NWELL PWELL BULK FA_X1
X$148154 \$65587 \$64990 \$65830 \$66182 NWELL PWELL BULK MUX2_X1
X$148159 \$64990 \$65832 \$64991 NWELL PWELL BULK NOR2_X1
X$148161 \$66186 \$64990 \$66705 NWELL PWELL BULK NOR2_X1
X$148168 \$64992 \$66184 \$66186 NWELL PWELL BULK XOR2_X1
X$148171 \$64995 \$65338 \$I241146 \$64992 NWELL PWELL BULK HA_X1
X$148173 \$64992 \$65831 NWELL PWELL BULK INV_X1
X$148179 \$I178617 \$69079 \$68696 \$64993 NWELL PWELL BULK DFF_X1
X$148181 \$I179199 \$66296 \$66566 \$64993 NWELL PWELL BULK DFF_X1
X$148185 \$66288 \$65981 \$66198 \$64993 NWELL PWELL BULK DFF_X1
X$148187 \$I176688 \$69041 \$69038 \$64993 NWELL PWELL BULK DFF_X1
X$148190 \$I175592 \$67330 \$66915 \$64993 NWELL PWELL BULK DFF_X1
X$148193 \$68673 \$68177 \$68165 \$64993 NWELL PWELL BULK DFF_X1
X$148196 \$68684 \$68180 \$67872 \$64993 NWELL PWELL BULK DFF_X1
X$148198 \$66286 \$67320 \$67322 \$64993 NWELL PWELL BULK DFF_X1
X$148201 \$69615 \$69616 \$70161 \$64993 NWELL PWELL BULK DFF_X1
X$148204 \$69223 \$69225 \$69454 \$64993 NWELL PWELL BULK DFF_X1
X$148206 \$68681 \$69054 \$69050 \$64993 NWELL PWELL BULK DFF_X1
X$148209 \$67354 \$66709 \$66988 \$64993 NWELL PWELL BULK DFF_X1
X$148212 \$I178570 \$67876 \$68197 \$64993 NWELL PWELL BULK DFF_X1
X$148214 \$I175584 \$68423 \$68194 \$64993 NWELL PWELL BULK DFF_X1
X$148216 \$65587 \$65830 \$65586 \$64993 NWELL PWELL BULK DFF_X1
X$148219 \$66284 \$66910 \$66704 \$64993 NWELL PWELL BULK DFF_X1
X$148221 \$I178317 \$66708 \$66923 \$64993 NWELL PWELL BULK DFF_X1
X$148224 \$66981 \$67310 \$67304 \$64993 NWELL PWELL BULK DFF_X1
X$148226 \$I174809 \$69481 \$69787 \$64993 NWELL PWELL BULK DFF_X1
X$148228 \$I177705 \$68201 \$68424 \$64993 NWELL PWELL BULK DFF_X1
X$148231 \$I177704 \$69067 \$69065 \$64993 NWELL PWELL BULK DFF_X1
X$148234 \$I174883 \$65581 \$65811 \$64993 NWELL PWELL BULK DFF_X1
X$148237 \$67298 \$66898 \$66899 \$64993 NWELL PWELL BULK DFF_X1
X$148239 \$I176734 \$68416 \$67867 \$64993 NWELL PWELL BULK DFF_X1
X$148242 \$67597 \$67868 \$68158 \$64993 NWELL PWELL BULK DFF_X1
X$148245 \$67595 \$68153 \$67866 \$64993 NWELL PWELL BULK DFF_X1
X$148250 \$66175 \$66172 \$65583 \$64993 NWELL PWELL BULK DFF_X1
X$148273 \$64995 \$66296 \$65349 NWELL PWELL BULK NAND2_X1
X$148276 \$64995 \$66563 \$66564 NWELL PWELL BULK NAND2_X1
X$148280 \$64995 \$65981 \$66204 NWELL PWELL BULK NAND2_X1
X$148282 \$64995 \$66708 \$65345 NWELL PWELL BULK NAND2_X1
X$148285 \$64995 \$66554 \$66292 NWELL PWELL BULK NAND2_X1
X$148288 \$64995 \$66288 \$66289 NWELL PWELL BULK NAND2_X1
X$148300 \$I174890 \$64999 \$65850 \$65008 NWELL PWELL BULK DFF_X1
X$148314 S1_AXI_RID[7] \$65002 NWELL PWELL BULK CLKBUF_X2
X$148323 \$I174992 \$65385 \$65003 \$65008 NWELL PWELL BULK DFF_X1
X$148327 \$I178683 \$65005 \$65382 \$65008 NWELL PWELL BULK DFF_X1
X$148333 \$I178869 \$65007 \$65397 \$65008 NWELL PWELL BULK DFF_X1
X$148342 \$67353 \$67809 \$67351 \$65008 NWELL PWELL BULK DFF_X1
X$148344 \$I176049 \$66300 \$66928 \$65008 NWELL PWELL BULK DFF_X1
X$148347 \$I174871 \$65598 \$65597 \$65008 NWELL PWELL BULK DFF_X1
X$148350 \$65986 \$66932 \$66298 \$65008 NWELL PWELL BULK DFF_X1
X$148353 \$66212 \$65596 \$66572 \$65008 NWELL PWELL BULK DFF_X1
X$148356 \$69492 \$69238 \$68711 \$65008 NWELL PWELL BULK DFF_X1
X$148358 \$I178060 \$70201 \$70202 \$65008 NWELL PWELL BULK DFF_X1
X$148360 \$I178015 \$68701 \$68697 \$65008 NWELL PWELL BULK DFF_X1
X$148362 \$69494 \$69099 \$69096 \$65008 NWELL PWELL BULK DFF_X1
X$148365 \$I178283 \$65990 \$65606 \$65008 NWELL PWELL BULK DFF_X1
X$148367 \$67384 \$67382 \$67380 \$65008 NWELL PWELL BULK DFF_X1
X$148370 \$I176030 \$65989 \$66593 \$65008 NWELL PWELL BULK DFF_X1
X$148373 \$I178196 \$66229 \$65604 \$65008 NWELL PWELL BULK DFF_X1
X$148377 \$67371 \$66714 \$67364 \$65008 NWELL PWELL BULK DFF_X1
X$148379 \$67372 \$66995 \$66993 \$65008 NWELL PWELL BULK DFF_X1
X$148382 \$71771 \$71412 \$71411 \$65008 NWELL PWELL BULK DFF_X1
X$148384 \$71513 \$70822 \$71403 \$65008 NWELL PWELL BULK DFF_X1
X$148386 \$69241 \$69240 \$69775 \$65008 NWELL PWELL BULK DFF_X1
X$148388 \$I178230 \$68816 \$68740 \$65008 NWELL PWELL BULK DFF_X1
X$148392 \$70460 \$70461 \$70715 \$65008 NWELL PWELL BULK DFF_X1
X$148394 \$69627 \$69778 \$70206 \$65008 NWELL PWELL BULK DFF_X1
X$148396 \$71512 \$71057 \$71396 \$65008 NWELL PWELL BULK DFF_X1
X$148399 \$69773 \$70235 \$69861 \$65008 NWELL PWELL BULK DFF_X1
X$148402 \$69863 \$70733 \$70250 \$65008 NWELL PWELL BULK DFF_X1
X$148404 \$69242 \$70720 \$69859 \$65008 NWELL PWELL BULK DFF_X1
X$148406 \$71052 \$70466 \$70741 \$65008 NWELL PWELL BULK DFF_X1
X$148438 S1_AXI_RID[3] \$65010 NWELL PWELL BULK CLKBUF_X2
X$148447 \$I178842 \$65011 \$65414 \$65608 NWELL PWELL BULK DFF_X1
X$148477 \$65899 \$65026 \$65620 NWELL PWELL BULK OR2_X1
X$148479 \$I177485 \$67906 \$68345 \$65028 NWELL PWELL BULK DFF_X1
X$148481 \$I177487 \$66662 \$66732 \$65028 NWELL PWELL BULK DFF_X1
X$148483 \$I179254 \$66322 \$66734 \$65028 NWELL PWELL BULK DFF_X1
X$148487 \$I177490 \$67909 \$67773 \$65028 NWELL PWELL BULK DFF_X1
X$148490 \$I174299 \$65880 \$65882 \$65028 NWELL PWELL BULK DFF_X1
X$148493 \$I174317 \$65611 \$65888 \$65028 NWELL PWELL BULK DFF_X1
X$148496 \$I176421 \$66314 \$66649 \$65028 NWELL PWELL BULK DFF_X1
X$148498 \$I177477 \$66319 \$66005 \$65028 NWELL PWELL BULK DFF_X1
X$148500 \$68446 \$68742 \$68743 \$65028 NWELL PWELL BULK DFF_X1
X$148502 \$68309 \$67619 \$67895 \$65028 NWELL PWELL BULK DFF_X1
X$148505 \$67898 \$67788 \$68316 \$65028 NWELL PWELL BULK DFF_X1
X$148507 \$I174827 \$66003 \$66222 \$65028 NWELL PWELL BULK DFF_X1
X$148510 \$I175724 \$66633 \$66726 \$65028 NWELL PWELL BULK DFF_X1
X$148513 \$I174501 \$67448 \$67441 \$65028 NWELL PWELL BULK DFF_X1
X$148515 \$I176969 \$67625 \$68375 \$65028 NWELL PWELL BULK DFF_X1
X$148517 \$I179253 \$68362 \$68355 \$65028 NWELL PWELL BULK DFF_X1
X$148520 \$I177530 \$66329 \$67023 \$65028 NWELL PWELL BULK DFF_X1
X$148522 \$I176957 \$67021 \$66323 \$65028 NWELL PWELL BULK DFF_X1
X$148524 \$I176967 \$66010 \$66324 \$65028 NWELL PWELL BULK DFF_X1
X$148527 \$I177523 \$66012 \$66325 \$65028 NWELL PWELL BULK DFF_X1
X$148530 \$I179266 \$66008 \$66210 \$65028 NWELL PWELL BULK DFF_X1
X$148533 \$I174294 \$65921 \$65919 \$65028 NWELL PWELL BULK DFF_X1
X$148535 \$I175091 \$68847 \$69125 \$65028 NWELL PWELL BULK DFF_X1
X$148538 \$I177538 \$68367 \$67913 \$65028 NWELL PWELL BULK DFF_X1
X$148541 \$I177441 \$69112 \$69521 \$65028 NWELL PWELL BULK DFF_X1
X$148543 \$I175987 \$70478 \$69886 \$65028 NWELL PWELL BULK DFF_X1
X$148545 \$I174380 \$68737 \$68839 \$65028 NWELL PWELL BULK DFF_X1
X$148547 \$I179261 \$68448 \$68736 \$65028 NWELL PWELL BULK DFF_X1
X$148549 \$I177577 \$65504 \$65030 \$65028 NWELL PWELL BULK DFF_X1
X$148603 \$65033 M1_AXI_RLAST NWELL PWELL BULK BUF_X1
X$148624 \$I176634 \$65619 \$65047 \$65931 NWELL PWELL BULK DFF_X1
X$148627 \$I179182 \$65621 \$65048 \$65049 NWELL PWELL BULK DFF_X1
X$148629 \$I176056 \$66741 \$67033 \$65049 NWELL PWELL BULK DFF_X1
X$148631 \$I175269 \$67927 \$68296 \$65049 NWELL PWELL BULK DFF_X1
X$148633 \$I176820 \$69278 \$69489 \$65049 NWELL PWELL BULK DFF_X1
X$148636 \$I176610 \$66017 \$65624 \$65049 NWELL PWELL BULK DFF_X1
X$148638 \$I176229 \$68465 \$68311 \$65049 NWELL PWELL BULK DFF_X1
X$148642 \$I174794 \$70690 \$70691 \$65049 NWELL PWELL BULK DFF_X1
X$148644 \$I176175 \$68683 \$68856 \$65049 NWELL PWELL BULK DFF_X1
X$148646 \$I177924 \$70699 \$70488 \$65049 NWELL PWELL BULK DFF_X1
X$148649 \$I178118 \$65950 \$65623 \$65049 NWELL PWELL BULK DFF_X1
X$148654 \$I177944 \$65944 \$66197 \$65049 NWELL PWELL BULK DFF_X1
X$148656 \$I175762 \$71908 \$72298 \$65049 NWELL PWELL BULK DFF_X1
X$148659 \$I177148 \$72138 \$71907 \$65049 NWELL PWELL BULK DFF_X1
X$148661 \$I175431 \$70842 \$71405 \$65049 NWELL PWELL BULK DFF_X1
X$148664 \$I175760 \$70981 \$71393 \$65049 NWELL PWELL BULK DFF_X1
X$148666 \$I176978 \$71150 \$71737 \$65049 NWELL PWELL BULK DFF_X1
X$148668 \$I176604 \$71740 \$71408 \$65049 NWELL PWELL BULK DFF_X1
X$148670 \$I175713 \$73881 \$73016 \$65049 NWELL PWELL BULK DFF_X1
X$148672 \$I177940 \$72294 \$72432 \$65049 NWELL PWELL BULK DFF_X1
X$148674 \$I174820 \$69920 \$70383 \$65049 NWELL PWELL BULK DFF_X1
X$148676 \$I176221 \$69913 \$70400 \$65049 NWELL PWELL BULK DFF_X1
X$148679 \$I174915 \$69283 \$69282 \$65049 NWELL PWELL BULK DFF_X1
X$148681 \$I174810 \$69919 \$69917 \$65049 NWELL PWELL BULK DFF_X1
X$148683 \$I176874 \$70976 \$70971 \$65049 NWELL PWELL BULK DFF_X1
X$148686 \$I174863 \$69656 \$70357 \$65049 NWELL PWELL BULK DFF_X1
X$148689 \$I177144 \$73480 \$73248 \$65049 NWELL PWELL BULK DFF_X1
X$148691 \$I175409 \$72297 \$72625 \$65049 NWELL PWELL BULK DFF_X1
X$148693 \$I177638 \$74726 \$73887 \$65049 NWELL PWELL BULK DFF_X1
X$148696 \$I177125 \$74460 \$73479 \$65049 NWELL PWELL BULK DFF_X1
X$148699 \$I177936 \$73477 \$73891 \$65049 NWELL PWELL BULK DFF_X1
X$148728 \$65054 \$65460 \$65932 NWELL PWELL BULK XNOR2_X1
X$148737 \$65639 \$65348 \$65062 \$65065 NWELL PWELL BULK DFF_X1
X$148741 \$66508 \$65809 \$66116 \$65065 NWELL PWELL BULK DFF_X1
X$148744 \$66511 \$65076 \$65288 \$65065 NWELL PWELL BULK DFF_X1
X$148746 \$66362 \$66534 \$66535 \$65065 NWELL PWELL BULK DFF_X1
X$148749 \$66524 \$66365 \$66525 \$65065 NWELL PWELL BULK DFF_X1
X$148752 \$I176190 \$67943 \$67942 \$65065 NWELL PWELL BULK DFF_X1
X$148754 \$I176200 \$68189 \$67725 \$65065 NWELL PWELL BULK DFF_X1
X$148757 \$I178527 \$67651 \$67650 \$65065 NWELL PWELL BULK DFF_X1
X$148759 \$66367 \$66759 \$66837 \$65065 NWELL PWELL BULK DFF_X1
X$148761 \$I176254 \$67944 \$68173 \$65065 NWELL PWELL BULK DFF_X1
X$148763 \$I176631 \$67519 \$66746 \$65065 NWELL PWELL BULK DFF_X1
X$148766 \$67538 \$66587 \$66352 \$65065 NWELL PWELL BULK DFF_X1
X$148769 \$I176848 \$67938 \$68637 \$65065 NWELL PWELL BULK DFF_X1
X$148772 \$I177424 \$68482 \$68484 \$65065 NWELL PWELL BULK DFF_X1
X$148775 \$I176762 \$68869 \$69288 \$65065 NWELL PWELL BULK DFF_X1
X$148777 \$I175570 \$70211 \$69934 \$65065 NWELL PWELL BULK DFF_X1
X$148779 \$I176338 \$69301 \$68985 \$65065 NWELL PWELL BULK DFF_X1
X$148781 \$65843 \$66030 \$66129 \$65065 NWELL PWELL BULK DFF_X1
X$148783 \$66137 \$66355 \$66577 \$65065 NWELL PWELL BULK DFF_X1
X$148785 \$65845 \$65644 \$65854 \$65065 NWELL PWELL BULK DFF_X1
X$148790 \$I174604 \$69291 \$69007 \$65065 NWELL PWELL BULK DFF_X1
X$148792 \$66033 \$67427 \$67428 \$65065 NWELL PWELL BULK DFF_X1
X$148794 \$66027 \$65636 \$66026 \$65065 NWELL PWELL BULK DFF_X1
X$148796 \$67460 \$67062 \$67061 \$65065 NWELL PWELL BULK DFF_X1
X$148799 \$67449 \$67434 \$67436 \$65065 NWELL PWELL BULK DFF_X1
X$148804 \$I177146 \$65068 \$65343 \$65065 NWELL PWELL BULK DFF_X1
X$148807 \$65315 \$65301 \$65310 \$65065 NWELL PWELL BULK DFF_X1
X$148810 \$65329 \$65072 \$65336 \$65065 NWELL PWELL BULK DFF_X1
X$148856 \$I177117 \$65239 \$65083 \$65657 NWELL PWELL BULK DFF_X1
X$148861 \$66056 \$65178 \$65090 \$65665 NWELL PWELL BULK DFF_X1
X$148863 \$65092 \$65180 \$65177 NWELL PWELL BULK NOR2_X2
X$148870 \$65128 \$65100 NWELL PWELL BULK BUF_X1
X$148873 \$65725 S1_AXI_WID[5] NWELL PWELL BULK BUF_X1
X$148878 M0_AXI_WDATA[23] \$66047 NWELL PWELL BULK BUF_X1
X$148883 \$65208 S1_AXI_WSTRB[2] NWELL PWELL BULK BUF_X1
X$148888 \$65128 S1_AXI_WID[6] NWELL PWELL BULK BUF_X1
X$148901 \$70068 \$65119 \$70424 \$70600 NWELL PWELL BULK MUX2_X1
X$148903 \$66685 \$65119 \$65955 \$66950 NWELL PWELL BULK MUX2_X1
X$148908 \$68055 \$65119 \$68778 \$69194 NWELL PWELL BULK MUX2_X1
X$148910 \$71074 \$65119 \$70025 \$70783 NWELL PWELL BULK MUX2_X1
X$148912 \$66954 \$65119 \$66252 \$67570 NWELL PWELL BULK MUX2_X1
X$148914 \$69813 \$65119 \$69981 \$69978 NWELL PWELL BULK MUX2_X1
X$148918 \$71070 \$65119 \$71071 \$71224 NWELL PWELL BULK MUX2_X1
X$148920 \$71200 \$65119 \$71814 \$71062 NWELL PWELL BULK MUX2_X1
X$148923 \$72206 \$65119 \$71468 \$71210 NWELL PWELL BULK MUX2_X1
X$148926 \$69182 \$65119 \$69184 \$69351 NWELL PWELL BULK MUX2_X1
X$148928 \$70015 \$65119 \$70414 \$70416 NWELL PWELL BULK MUX2_X1
X$148931 \$70426 \$65119 \$70933 \$71262 NWELL PWELL BULK MUX2_X1
X$148935 \$71482 \$65119 \$72006 \$69832 NWELL PWELL BULK MUX2_X1
X$148937 \$71833 \$65119 \$72220 \$71642 NWELL PWELL BULK MUX2_X1
X$148941 \$66684 \$65119 \$66058 \$66807 NWELL PWELL BULK MUX2_X1
X$148944 \$67113 \$65119 \$67126 \$67135 NWELL PWELL BULK MUX2_X1
X$148946 \$67565 \$65119 \$67830 \$66949 NWELL PWELL BULK MUX2_X1
X$148948 \$70579 \$65119 \$70916 \$70914 NWELL PWELL BULK MUX2_X1
X$148950 \$69360 \$65119 \$69190 \$69586 NWELL PWELL BULK MUX2_X1
X$148953 \$69193 \$65119 \$68399 \$69377 NWELL PWELL BULK MUX2_X1
X$148955 \$69823 \$65119 \$69589 \$70039 NWELL PWELL BULK MUX2_X1
X$148957 \$69590 \$65119 \$69592 \$69591 NWELL PWELL BULK MUX2_X1
X$148959 \$71978 \$65119 \$72212 \$71820 NWELL PWELL BULK MUX2_X1
X$148961 \$71817 \$65119 \$71818 \$71066 NWELL PWELL BULK MUX2_X1
X$148963 \$69967 \$65119 \$70408 \$70407 NWELL PWELL BULK MUX2_X1
X$148965 \$68388 \$65119 \$68908 \$68515 NWELL PWELL BULK MUX2_X1
X$148968 \$67561 \$65119 \$69332 \$67562 NWELL PWELL BULK MUX2_X1
X$148971 \$70779 \$65119 \$70780 \$71067 NWELL PWELL BULK MUX2_X1
X$148973 \$68767 \$65119 \$68011 \$68540 NWELL PWELL BULK MUX2_X1
X$148975 \$68018 \$65119 \$67836 \$68025 NWELL PWELL BULK MUX2_X1
X$148977 \$69186 \$65119 \$69188 \$69819 NWELL PWELL BULK MUX2_X1
X$148980 \$68037 \$65119 \$68396 \$68953 NWELL PWELL BULK MUX2_X1
X$148982 \$71479 \$65119 \$70923 \$71246 NWELL PWELL BULK MUX2_X1
X$148984 \$71621 \$65119 \$71078 \$71233 NWELL PWELL BULK MUX2_X1
X$148986 \$71827 \$65119 \$72370 \$71082 NWELL PWELL BULK MUX2_X1
X$148988 \$72720 \$65119 \$71985 \$71987 NWELL PWELL BULK MUX2_X1
X$149075 \$65706 \$65158 \$65170 \$65665 NWELL PWELL BULK DFF_X1
X$149091 \$72032 \$70862 \$71935 \$65175 NWELL PWELL BULK MUX2_X1
X$149100 \$65177 \$71156 \$71186 \$71598 NWELL PWELL BULK OAI21_X1
X$149102 \$65177 \$71173 \$71582 \$71950 NWELL PWELL BULK OAI21_X1
X$149104 \$65177 \$70514 \$70531 \$70530 NWELL PWELL BULK OAI21_X1
X$149108 \$70521 \$65177 \$71207 \$70551 NWELL PWELL BULK OAI21_X1
X$149130 \$I174978 \$65185 \$65734 \$65959 NWELL PWELL BULK DFF_X1
X$149173 \$66482 \$65769 \$65254 \$65657 NWELL PWELL BULK DFF_X1
X$149265 \$72853 \$65370 \$71863 \$72568 NWELL PWELL BULK MUX2_X1
X$149268 \$73416 \$65370 \$73417 \$73418 NWELL PWELL BULK MUX2_X1
X$149270 \$79579 \$65370 \$78998 \$78869 NWELL PWELL BULK MUX2_X1
X$149273 \$81971 \$65370 \$82361 \$82370 NWELL PWELL BULK MUX2_X1
X$149275 \$81321 \$65370 \$81322 \$81640 NWELL PWELL BULK MUX2_X1
X$149277 \$79566 \$65370 \$79353 \$79191 NWELL PWELL BULK MUX2_X1
X$149280 \$80618 \$65370 \$80446 \$80995 NWELL PWELL BULK MUX2_X1
X$149283 \$81301 \$65370 \$81618 \$81308 NWELL PWELL BULK MUX2_X1
X$149286 \$71865 \$65370 \$72864 \$72870 NWELL PWELL BULK MUX2_X1
X$149289 \$74422 \$65370 \$73428 \$73110 NWELL PWELL BULK MUX2_X1
X$149293 \$66212 \$65370 \$65986 \$66711 NWELL PWELL BULK MUX2_X1
X$149295 \$65370 \$69237 NWELL PWELL BULK BUF_X16
X$149297 \$67354 \$65370 \$67353 \$67358 NWELL PWELL BULK MUX2_X1
X$149299 \$81991 \$65370 \$82206 \$81438 NWELL PWELL BULK MUX2_X1
X$149302 \$82705 \$65370 \$82205 \$82704 NWELL PWELL BULK MUX2_X1
X$149304 \$78519 \$65370 \$78648 \$78524 NWELL PWELL BULK MUX2_X1
X$149307 \$73770 \$65370 \$73424 \$73108 NWELL PWELL BULK MUX2_X1
X$149309 \$69468 \$65370 \$70200 \$69791 NWELL PWELL BULK MUX2_X1
X$149312 \$70701 \$65370 \$70814 \$69470 NWELL PWELL BULK MUX2_X1
X$149314 \$78501 \$65370 \$78848 \$78504 NWELL PWELL BULK MUX2_X1
X$149317 \$74664 \$65370 \$75063 \$73420 NWELL PWELL BULK MUX2_X1
X$149319 \$75357 \$65370 \$75183 \$75366 NWELL PWELL BULK MUX2_X1
X$149321 \$76404 \$65370 \$76518 \$76519 NWELL PWELL BULK MUX2_X1
X$149323 \$75050 \$65370 \$74842 \$75372 NWELL PWELL BULK MUX2_X1
X$149325 \$80286 \$65370 \$80291 \$79350 NWELL PWELL BULK MUX2_X1
X$149327 \$77167 \$65370 \$77468 \$77168 NWELL PWELL BULK MUX2_X1
X$149329 \$79177 \$65370 \$78642 \$79553 NWELL PWELL BULK MUX2_X1
X$149408 \$I174991 \$65422 \$65874 \$65608 NWELL PWELL BULK DFF_X1
X$149470 \$65516 M1_AXI_RID[1] NWELL PWELL BULK BUF_X1
X$149479 \$I177644 \$65537 \$65534 \$65931 NWELL PWELL BULK DFF_X1
X$149491 \$66139 S2_AXI_AWID[1] NWELL PWELL BULK BUF_X1
X$149496 \$65676 S2_AXI_AWADDR[9] NWELL PWELL BULK BUF_X1
X$149501 \$65961 S2_AXI_AWADDR[26] NWELL PWELL BULK BUF_X1
X$149523 \$I177781 \$65735 \$65559 \$65959 NWELL PWELL BULK DFF_X1
X$149530 \$I176225 \$65561 \$66108 \$66260 NWELL PWELL BULK DFF_X1
X$149537 \$I174988 \$65562 \$65750 \$66260 NWELL PWELL BULK DFF_X1
X$149568 \$I174884 \$65575 \$65797 \$66974 NWELL PWELL BULK DFF_X1
X$149573 S2_AXI_RID[7] \$65578 NWELL PWELL BULK BUF_X2
X$149614 \$67313 \$66285 \$66985 \$65588 NWELL PWELL BULK MUX2_X2
X$149639 \$I174989 \$65994 \$65607 \$65608 NWELL PWELL BULK DFF_X1
X$149643 \$70299 \$69764 \$70288 \$65608 NWELL PWELL BULK DFF_X1
X$149646 \$69635 \$71049 \$70761 \$65608 NWELL PWELL BULK DFF_X1
X$149649 \$I178204 \$68824 \$69522 \$65608 NWELL PWELL BULK DFF_X1
X$149651 \$69867 \$70264 \$69632 \$65608 NWELL PWELL BULK DFF_X1
X$149653 \$68828 \$69150 \$68440 \$65608 NWELL PWELL BULK DFF_X1
X$149656 \$70312 \$70306 \$70476 \$65608 NWELL PWELL BULK DFF_X1
X$149658 \$68754 \$65608 NWELL PWELL BULK BUF_X4
X$149661 \$69156 \$69549 \$69249 \$65608 NWELL PWELL BULK DFF_X1
X$149663 \$68744 \$68442 \$68748 \$65608 NWELL PWELL BULK DFF_X1
X$149666 \$I175881 \$65993 \$66614 \$65608 NWELL PWELL BULK DFF_X1
X$149671 \$I178119 \$67010 \$67617 \$65608 NWELL PWELL BULK DFF_X1
X$149673 \$I178129 \$66310 \$67432 \$65608 NWELL PWELL BULK DFF_X1
X$149675 \$I178219 \$67007 \$67416 \$65608 NWELL PWELL BULK DFF_X1
X$149677 \$69140 \$67892 \$67891 \$65608 NWELL PWELL BULK DFF_X1
X$149680 \$I175793 \$68438 \$68436 \$65608 NWELL PWELL BULK DFF_X1
X$149682 \$I178140 \$66303 \$66716 \$65608 NWELL PWELL BULK DFF_X1
X$149684 \$I175891 \$67002 \$67395 \$65608 NWELL PWELL BULK DFF_X1
X$149687 \$68262 \$67613 \$67798 \$65608 NWELL PWELL BULK DFF_X1
X$149689 \$68276 \$68268 \$67614 \$65608 NWELL PWELL BULK DFF_X1
X$149691 \$I175747 \$71039 \$70319 \$65608 NWELL PWELL BULK DFF_X1
X$149694 \$70307 \$69759 \$69758 \$65608 NWELL PWELL BULK DFF_X1
X$149697 \$I178130 \$65998 \$66237 \$65608 NWELL PWELL BULK DFF_X1
X$149700 \$I178173 \$67009 \$68290 \$65608 NWELL PWELL BULK DFF_X1
X$149702 \$I175819 \$65995 \$66620 \$65608 NWELL PWELL BULK DFF_X1
X$149706 \$I178424 \$71789 \$71788 \$65608 NWELL PWELL BULK DFF_X1
X$149708 \$I175362 \$71420 \$71419 \$65608 NWELL PWELL BULK DFF_X1
X$149711 \$I175666 \$69511 \$69509 \$65608 NWELL PWELL BULK DFF_X1
X$149739 \$66003 \$65992 \$65611 \$66215 NWELL PWELL BULK MUX2_X1
X$149776 \$I178783 \$67639 \$67734 \$65629 NWELL PWELL BULK DFF_X1
X$149778 \$I176089 \$67933 \$67931 \$65629 NWELL PWELL BULK DFF_X1
X$149780 \$I175452 \$67545 \$67045 \$65629 NWELL PWELL BULK DFF_X1
X$149783 \$I175756 \$68473 \$68861 \$65629 NWELL PWELL BULK DFF_X1
X$149785 \$I179048 \$68860 \$69048 \$65629 NWELL PWELL BULK DFF_X1
X$149788 \$70302 \$70304 \$70305 \$65629 NWELL PWELL BULK DFF_X1
X$149790 \$I174872 \$67042 \$67740 \$65629 NWELL PWELL BULK DFF_X1
X$149793 \$I178494 \$67636 \$67745 \$65629 NWELL PWELL BULK DFF_X1
X$149795 \$65630 \$65906 \$65908 \$65629 NWELL PWELL BULK DFF_X1
X$149797 \$66022 \$66625 \$66341 \$65629 NWELL PWELL BULK DFF_X1
X$149799 \$68859 \$69062 \$69472 \$65629 NWELL PWELL BULK DFF_X1
X$149802 \$69734 \$70334 \$69737 \$65629 NWELL PWELL BULK DFF_X1
X$149804 \$68470 \$69285 \$68665 \$65629 NWELL PWELL BULK DFF_X1
X$149806 \$69662 \$70664 \$70496 \$65629 NWELL PWELL BULK DFF_X1
X$149809 \$I176565 \$74258 \$74269 \$65629 NWELL PWELL BULK DFF_X1
X$149811 \$I176578 \$74469 \$74267 \$65629 NWELL PWELL BULK DFF_X1
X$149813 \$I177192 \$74677 \$74254 \$65629 NWELL PWELL BULK DFF_X1
X$149816 \$I176882 \$72632 \$73852 \$65629 NWELL PWELL BULK DFF_X1
X$149818 \$I177047 \$72955 \$72960 \$65629 NWELL PWELL BULK DFF_X1
X$149820 \$I177193 \$75722 \$75724 \$65629 NWELL PWELL BULK DFF_X1
X$149823 \$I176888 \$76103 \$75419 \$65629 NWELL PWELL BULK DFF_X1
X$149826 \$71378 \$70844 \$71373 \$65629 NWELL PWELL BULK DFF_X1
X$149829 \$72633 \$73242 \$72951 \$65629 NWELL PWELL BULK DFF_X1
X$149831 \$72902 \$65629 NWELL PWELL BULK BUF_X4
X$149833 \$71730 \$72135 \$72131 \$65629 NWELL PWELL BULK DFF_X1
X$149836 \$I176928 \$74906 \$74472 \$65629 NWELL PWELL BULK DFF_X1
X$149838 \$75411 \$75225 \$74903 \$65629 NWELL PWELL BULK DFF_X1
X$149840 \$I176933 \$75615 \$75401 \$65629 NWELL PWELL BULK DFF_X1
X$149842 \$I177211 \$74055 \$73846 \$65629 NWELL PWELL BULK DFF_X1
X$149845 \$I177454 \$72630 \$72628 \$65629 NWELL PWELL BULK DFF_X1
X$149847 \$I175354 \$72302 \$72408 \$65629 NWELL PWELL BULK DFF_X1
X$149890 \$66147 \$65633 \$66604 NWELL PWELL BULK NOR2_X2
X$149907 \$65782 \$65656 \$65783 \$65657 NWELL PWELL BULK DFF_X1
X$149909 \$I174594 \$65798 \$65806 \$65657 NWELL PWELL BULK DFF_X1
X$149911 \$I175172 \$66372 \$66112 \$65657 NWELL PWELL BULK DFF_X1
X$149913 \$I175144 \$67367 \$67071 \$65657 NWELL PWELL BULK DFF_X1
X$149916 \$69941 \$70155 \$70153 \$65657 NWELL PWELL BULK DFF_X1
X$149918 \$70609 \$70605 \$69939 \$65657 NWELL PWELL BULK DFF_X1
X$149920 \$I178967 \$68133 \$68595 \$65657 NWELL PWELL BULK DFF_X1
X$149922 \$I174667 \$65663 \$65757 \$65657 NWELL PWELL BULK DFF_X1
X$149925 \$I174668 \$66040 \$66376 \$65657 NWELL PWELL BULK DFF_X1
X$149927 \$68098 \$67696 \$67699 \$65657 NWELL PWELL BULK DFF_X1
X$149929 \$I179034 \$67086 \$67701 \$65657 NWELL PWELL BULK DFF_X1
X$149932 \$I175143 \$67256 \$67702 \$65657 NWELL PWELL BULK DFF_X1
X$149935 \$I178996 \$68958 \$68576 \$65657 NWELL PWELL BULK DFF_X1
X$149938 \$I179078 \$67078 \$67653 \$65657 NWELL PWELL BULK DFF_X1
X$149941 \$I178934 \$69677 \$69945 \$65657 NWELL PWELL BULK DFF_X1
X$149944 \$I178469 \$70516 \$70513 \$65657 NWELL PWELL BULK DFF_X1
X$149946 \$I178992 \$68491 \$68590 \$65657 NWELL PWELL BULK DFF_X1
X$149949 \$I178936 \$68881 \$69303 \$65657 NWELL PWELL BULK DFF_X1
X$149951 \$I175307 \$67948 \$68592 \$65657 NWELL PWELL BULK DFF_X1
X$149954 \$I178938 \$69717 \$70137 \$65657 NWELL PWELL BULK DFF_X1
X$149957 \$66375 \$66093 \$66089 \$65657 NWELL PWELL BULK DFF_X1
X$149961 \$I175122 \$67076 \$67073 \$65657 NWELL PWELL BULK DFF_X1
X$149965 \$66038 \$66098 \$66099 \$65657 NWELL PWELL BULK DFF_X1
X$149967 \$I178988 \$69308 \$69946 \$65657 NWELL PWELL BULK DFF_X1
X$149970 \$I174254 \$69384 \$69714 \$65657 NWELL PWELL BULK DFF_X1
X$149972 \$I175262 \$72027 \$72362 \$65657 NWELL PWELL BULK DFF_X1
X$149974 \$I178472 \$70522 \$70518 \$65657 NWELL PWELL BULK DFF_X1
X$149977 \$I178995 \$68884 \$68954 \$65657 NWELL PWELL BULK DFF_X1
X$150004 \$I174899 \$70860 \$71248 \$65665 NWELL PWELL BULK DFF_X1
X$150006 \$69313 \$69952 \$70075 \$65665 NWELL PWELL BULK DFF_X1
X$150008 \$69315 \$69685 \$70043 \$65665 NWELL PWELL BULK DFF_X1
X$150010 \$69343 \$69688 \$69707 \$65665 NWELL PWELL BULK DFF_X1
X$150013 \$69355 \$69356 \$69316 \$65665 NWELL PWELL BULK DFF_X1
X$150016 \$69338 \$68914 \$69346 \$65665 NWELL PWELL BULK DFF_X1
X$150018 \$68495 \$67959 \$68558 \$65665 NWELL PWELL BULK DFF_X1
X$150021 \$68547 \$68541 \$68544 \$65665 NWELL PWELL BULK DFF_X1
X$150024 \$69369 \$69368 \$69374 \$65665 NWELL PWELL BULK DFF_X1
X$150028 \$67165 \$66794 \$66793 \$65665 NWELL PWELL BULK DFF_X1
X$150030 \$I178468 \$70524 \$70523 \$65665 NWELL PWELL BULK DFF_X1
X$150033 \$I174435 \$70527 \$70526 \$65665 NWELL PWELL BULK DFF_X1
X$150035 \$66810 \$66379 \$66443 \$65665 NWELL PWELL BULK DFF_X1
X$150037 \$68091 \$68568 \$68093 \$65665 NWELL PWELL BULK DFF_X1
X$150040 \$68094 \$68493 \$68105 \$65665 NWELL PWELL BULK DFF_X1
X$150043 \$I174397 \$70547 \$70551 \$65665 NWELL PWELL BULK DFF_X1
X$150045 \$67969 \$67970 \$67979 \$65665 NWELL PWELL BULK DFF_X1
X$150047 \$67092 \$67209 \$67090 \$65665 NWELL PWELL BULK DFF_X1
X$150049 \$67124 \$67107 \$67106 \$65665 NWELL PWELL BULK DFF_X1
X$150052 \$65667 \$65730 \$65731 \$65665 NWELL PWELL BULK DFF_X1
X$150055 \$68079 \$67658 \$68058 \$65665 NWELL PWELL BULK DFF_X1
X$150057 \$66444 \$66071 \$66073 \$65665 NWELL PWELL BULK DFF_X1
X$150060 \$66438 \$66062 \$65745 \$65665 NWELL PWELL BULK DFF_X1
X$150063 \$66395 \$66053 \$66410 \$65665 NWELL PWELL BULK DFF_X1
X$150067 \$67101 \$67159 \$67163 \$65665 NWELL PWELL BULK DFF_X1
X$150070 \$67996 \$67997 \$68002 \$65665 NWELL PWELL BULK DFF_X1
X$150072 \$69379 \$69948 \$69712 \$65665 NWELL PWELL BULK DFF_X1
X$150074 \$69312 \$69311 \$69681 \$65665 NWELL PWELL BULK DFF_X1
X$150095 \$71169 \$70862 \$72066 \$65666 NWELL PWELL BULK MUX2_X1
X$150108 \$66051 S1_AXI_WID[4] NWELL PWELL BULK BUF_X1
X$150113 \$66049 S2_AXI_WDATA[29] NWELL PWELL BULK BUF_X1
X$150118 \$66415 S2_AXI_WDATA[5] NWELL PWELL BULK BUF_X1
X$150265 \$66123 \$65826 \$66031 NWELL PWELL BULK NOR2_X2
X$150308 \$74843 \$65879 \$74420 \$74418 NWELL PWELL BULK MUX2_X1
X$150311 \$82552 \$65879 \$83662 \$83440 NWELL PWELL BULK MUX2_X1
X$150314 \$81840 \$65879 \$82218 \$82556 NWELL PWELL BULK MUX2_X1
X$150316 \$80098 \$65879 \$82890 \$82731 NWELL PWELL BULK MUX2_X1
X$150319 \$81146 \$65879 \$81142 \$81271 NWELL PWELL BULK MUX2_X1
X$150322 \$77367 \$65879 \$83261 \$83255 NWELL PWELL BULK MUX2_X1
X$150325 \$76515 \$65879 \$77714 \$77846 NWELL PWELL BULK MUX2_X1
X$150328 \$79979 \$65879 \$83077 \$83074 NWELL PWELL BULK MUX2_X1
X$150331 \$73106 \$65879 \$74636 \$74222 NWELL PWELL BULK MUX2_X1
X$150334 \$74026 \$65879 \$74032 \$74357 NWELL PWELL BULK MUX2_X1
X$150337 \$68817 \$65879 \$68824 \$69522 NWELL PWELL BULK MUX2_X1
X$150345 \$69885 \$65879 \$70478 \$69886 NWELL PWELL BULK MUX2_X1
X$150348 \$79404 \$65879 \$79409 \$79654 NWELL PWELL BULK MUX2_X1
X$150350 \$81483 \$65879 \$82236 \$82833 NWELL PWELL BULK MUX2_X1
X$150352 \$80771 \$65879 \$83782 \$84190 NWELL PWELL BULK MUX2_X1
X$150354 \$67477 \$65879 \$67906 \$68345 NWELL PWELL BULK MUX2_X1
X$150356 \$66007 \$65879 \$66008 \$66210 NWELL PWELL BULK MUX2_X1
X$150360 \$69260 \$65879 \$69265 \$69543 NWELL PWELL BULK MUX2_X1
X$150362 \$69892 \$65879 \$69893 \$70352 NWELL PWELL BULK MUX2_X1
X$150365 \$67878 \$65879 \$69079 \$68696 NWELL PWELL BULK MUX2_X1
X$150367 \$81493 \$65879 \$81185 \$81378 NWELL PWELL BULK MUX2_X1
X$150369 \$71515 \$65879 \$71420 \$71419 NWELL PWELL BULK MUX2_X1
X$150372 \$70817 \$65879 \$70818 \$71048 NWELL PWELL BULK MUX2_X1
X$150375 \$82831 \$65879 \$83151 \$82915 NWELL PWELL BULK MUX2_X1
X$150377 \$73999 \$65879 \$74847 \$74425 NWELL PWELL BULK MUX2_X1
X$150379 \$82562 \$65879 \$83134 \$83132 NWELL PWELL BULK MUX2_X1
X$150381 \$77655 \$65879 \$82559 \$82757 NWELL PWELL BULK MUX2_X1
X$150383 \$83140 \$65879 \$83192 \$83762 NWELL PWELL BULK MUX2_X1
X$150387 \$67873 \$65879 \$67876 \$68197 NWELL PWELL BULK MUX2_X1
X$150390 \$81806 \$65879 \$83390 \$83802 NWELL PWELL BULK MUX2_X1
X$150393 \$79336 \$65879 \$79883 \$79747 NWELL PWELL BULK MUX2_X1
X$150395 \$78298 \$65879 \$78300 \$78146 NWELL PWELL BULK MUX2_X1
X$150398 \$76995 \$65879 \$77278 \$77276 NWELL PWELL BULK MUX2_X1
X$150400 \$77169 \$65879 \$77469 \$77605 NWELL PWELL BULK MUX2_X1
X$150464 \$65880 \$65992 \$66633 \$66000 NWELL PWELL BULK MUX2_X1
X$150501 \$65916 S1_AXI_WDATA[8] NWELL PWELL BULK BUF_X1
X$150522 \$65927 M1_AXI_RDATA[6] NWELL PWELL BULK BUF_X1
X$150530 \$I176649 \$66331 \$66664 \$65931 NWELL PWELL BULK DFF_X1
X$150532 \$I177016 \$67922 \$67628 \$65931 NWELL PWELL BULK DFF_X1
X$150535 \$I174596 \$67627 \$68374 \$65931 NWELL PWELL BULK DFF_X1
X$150537 \$I177935 \$67631 \$68317 \$65931 NWELL PWELL BULK DFF_X1
X$150540 \$I177939 \$67029 \$67508 \$65931 NWELL PWELL BULK DFF_X1
X$150545 \$I174619 \$69743 \$69911 \$65931 NWELL PWELL BULK DFF_X1
X$150547 \$I174583 \$69907 \$69906 \$65931 NWELL PWELL BULK DFF_X1
X$150549 \$I174476 \$68462 \$69080 \$65931 NWELL PWELL BULK DFF_X1
X$150552 \$I177475 \$69271 \$69742 \$65931 NWELL PWELL BULK DFF_X1
X$150554 \$I177533 \$68344 \$68459 \$65931 NWELL PWELL BULK DFF_X1
X$150557 \$I174453 \$68855 \$69501 \$65931 NWELL PWELL BULK DFF_X1
X$150560 \$I175039 \$69897 \$70728 \$65931 NWELL PWELL BULK DFF_X1
X$150563 \$I176357 \$69270 \$68852 \$65931 NWELL PWELL BULK DFF_X1
X$150566 \$I177445 \$69645 \$69902 \$65931 NWELL PWELL BULK DFF_X1
X$150568 \$I174462 \$70482 \$69898 \$65931 NWELL PWELL BULK DFF_X1
X$150571 \$I177521 \$69905 \$69903 \$65931 NWELL PWELL BULK DFF_X1
X$150573 \$I174857 \$71011 \$71434 \$65931 NWELL PWELL BULK DFF_X1
X$150575 \$I174892 \$73256 \$73259 \$65931 NWELL PWELL BULK DFF_X1
X$150578 \$I178575 \$71760 \$71898 \$65931 NWELL PWELL BULK DFF_X1
X$150580 \$I178572 \$73044 \$73050 \$65931 NWELL PWELL BULK DFF_X1
X$150582 \$I178461 \$71413 \$71750 \$65931 NWELL PWELL BULK DFF_X1
X$150584 \$I179267 \$71903 \$71901 \$65931 NWELL PWELL BULK DFF_X1
X$150586 \$I175281 \$71141 \$71422 \$65931 NWELL PWELL BULK DFF_X1
X$150588 \$I174895 \$73019 \$72438 \$65931 NWELL PWELL BULK DFF_X1
X$150590 \$I175100 \$74044 \$73913 \$65931 NWELL PWELL BULK DFF_X1
X$150592 \$I174770 \$72620 \$73040 \$65931 NWELL PWELL BULK DFF_X1
X$150598 \$I176505 \$66015 \$66014 \$65931 NWELL PWELL BULK DFF_X1
X$150600 \$I179127 \$74737 \$74313 \$65931 NWELL PWELL BULK DFF_X1
X$150649 \$67688 S2_AXI_AWADDR[6] NWELL PWELL BULK BUF_X1
X$150671 \$I178161 \$66964 \$68063 \$65959 NWELL PWELL BULK DFF_X1
X$150673 \$I178157 \$66259 \$66104 \$65959 NWELL PWELL BULK DFF_X1
X$150675 \$I175812 \$70068 \$70065 \$65959 NWELL PWELL BULK DFF_X1
X$150677 \$I177783 \$70424 \$70928 \$65959 NWELL PWELL BULK DFF_X1
X$150680 \$75681 \$75975 \$75680 \$65959 NWELL PWELL BULK DFF_X1
X$150682 \$I175841 \$74383 \$74137 \$65959 NWELL PWELL BULK DFF_X1
X$150685 \$I178156 \$68055 \$68583 \$65959 NWELL PWELL BULK DFF_X1
X$150688 \$I178383 \$70916 \$70786 \$65959 NWELL PWELL BULK DFF_X1
X$150691 \$I177759 \$69589 \$70040 \$65959 NWELL PWELL BULK DFF_X1
X$150694 \$I176544 \$69823 \$70589 \$65959 NWELL PWELL BULK DFF_X1
X$150696 \$I178384 \$70923 \$70422 \$65959 NWELL PWELL BULK DFF_X1
X$150699 \$I178162 \$69590 \$69827 \$65959 NWELL PWELL BULK DFF_X1
X$150702 \$I176538 \$69193 \$68962 \$65959 NWELL PWELL BULK DFF_X1
X$150704 \$I177696 \$68399 \$68574 \$65959 NWELL PWELL BULK DFF_X1
X$150706 \$I178166 \$66689 \$67203 \$65959 NWELL PWELL BULK DFF_X1
X$150709 \$I176542 \$70579 \$70582 \$65959 NWELL PWELL BULK DFF_X1
X$150711 \$I177768 \$70025 \$70026 \$65959 NWELL PWELL BULK DFF_X1
X$150714 \$I177690 \$69190 \$69191 \$65959 NWELL PWELL BULK DFF_X1
X$150716 \$I176552 \$67840 \$68046 \$65959 NWELL PWELL BULK DFF_X1
X$150718 \$I176570 \$66960 \$67201 \$65959 NWELL PWELL BULK DFF_X1
X$150724 \$I176568 \$66087 \$66257 \$65959 NWELL PWELL BULK DFF_X1
X$150726 \$I178404 \$71479 \$71633 \$65959 NWELL PWELL BULK DFF_X1
X$150728 \$I178167 \$73631 \$74132 \$65959 NWELL PWELL BULK DFF_X1
X$150731 \$I178403 \$72370 \$72741 \$65959 NWELL PWELL BULK DFF_X1
X$150734 \$I178406 \$72534 \$73629 \$65959 NWELL PWELL BULK DFF_X1
X$150736 \$I178401 \$71078 \$71476 \$65959 NWELL PWELL BULK DFF_X1
X$150738 \$I175501 \$71621 \$71993 \$65959 NWELL PWELL BULK DFF_X1
X$150741 \$I178405 \$71827 \$72215 \$65959 NWELL PWELL BULK DFF_X1
X$150779 \$65981 \$66708 \$66554 \$66563 NWELL PWELL BULK HA_X1
X$150794 \$65989 \$65990 \$66302 NWELL PWELL BULK NOR2_X1
X$150807 \$75564 \$65992 \$75845 \$75765 NWELL PWELL BULK MUX2_X1
X$150810 \$67876 \$65992 \$68201 \$68426 NWELL PWELL BULK MUX2_X1
X$150812 \$71456 \$65992 \$71785 \$71459 NWELL PWELL BULK MUX2_X1
X$150815 \$69893 \$65992 \$70745 \$71131 NWELL PWELL BULK MUX2_X1
X$150817 \$69265 \$65992 \$69266 \$70348 NWELL PWELL BULK MUX2_X1
X$150820 \$68737 \$65992 \$68448 \$68844 NWELL PWELL BULK MUX2_X1
X$150823 \$74871 \$65992 \$75133 \$75516 NWELL PWELL BULK MUX2_X1
X$150826 \$66662 \$65992 \$66319 \$66320 NWELL PWELL BULK MUX2_X1
X$150829 \$67906 \$65992 \$67909 \$69133 NWELL PWELL BULK MUX2_X1
X$150833 \$66008 \$65992 \$66322 \$66881 NWELL PWELL BULK MUX2_X1
X$150836 \$68824 \$65992 \$68438 \$69526 NWELL PWELL BULK MUX2_X1
X$150838 \$67009 \$65992 \$67010 \$67791 NWELL PWELL BULK MUX2_X1
X$150840 \$74847 \$65992 \$74004 \$75094 NWELL PWELL BULK MUX2_X1
X$150842 \$69079 \$65992 \$68701 \$69233 NWELL PWELL BULK MUX2_X1
X$150845 \$67448 \$65992 \$66314 \$67459 NWELL PWELL BULK MUX2_X1
X$150847 \$74032 \$65992 \$74342 \$74033 NWELL PWELL BULK MUX2_X1
X$150849 \$70478 \$65992 \$71031 \$71439 NWELL PWELL BULK MUX2_X1
X$150852 \$69638 \$65992 \$69750 \$69891 NWELL PWELL BULK MUX2_X1
X$150854 \$65994 \$65992 \$65993 \$67399 NWELL PWELL BULK MUX2_X1
X$150856 \$67007 \$65992 \$65995 \$67796 NWELL PWELL BULK MUX2_X1
X$150858 \$66303 \$65992 \$67002 \$67403 NWELL PWELL BULK MUX2_X1
X$150861 \$68816 \$65992 \$69511 \$69527 NWELL PWELL BULK MUX2_X1
X$150863 \$69481 \$65992 \$70201 \$69485 NWELL PWELL BULK MUX2_X1
X$150865 \$71807 \$65992 \$71039 \$71126 NWELL PWELL BULK MUX2_X1
X$150868 \$65998 \$65992 \$66310 \$66901 NWELL PWELL BULK MUX2_X1
X$150870 \$72257 \$65992 \$72930 \$72933 NWELL PWELL BULK MUX2_X1
X$150872 \$71420 \$65992 \$71789 \$72259 NWELL PWELL BULK MUX2_X1
X$150874 \$70818 \$65992 \$71388 \$71509 NWELL PWELL BULK MUX2_X1
X$150877 \$74424 \$65992 \$74002 \$75092 NWELL PWELL BULK MUX2_X1
X$150879 \$71507 \$65992 \$70815 \$71743 NWELL PWELL BULK MUX2_X1
X$150882 \$68423 \$65992 \$69067 \$69071 NWELL PWELL BULK MUX2_X1
X$150884 \$74420 \$65992 \$75393 \$76055 NWELL PWELL BULK MUX2_X1
X$150886 \$69217 \$65992 NWELL PWELL BULK BUF_X16
X$150953 \$71507 \$65999 \$70817 \$72121 NWELL PWELL BULK MUX2_X1
X$150956 \$69638 \$65999 \$69260 \$69755 NWELL PWELL BULK MUX2_X1
X$150958 \$71456 \$65999 \$69892 \$71452 NWELL PWELL BULK MUX2_X1
X$150960 \$74871 \$65999 \$74026 \$75138 NWELL PWELL BULK MUX2_X1
X$150966 \$69481 \$65999 \$67878 \$69787 NWELL PWELL BULK MUX2_X1
X$150968 \$66662 \$65999 \$66007 \$66732 NWELL PWELL BULK MUX2_X1
X$150972 \$68737 \$65999 \$67477 \$68839 NWELL PWELL BULK MUX2_X1
X$150976 \$72257 \$65999 \$71515 \$72510 NWELL PWELL BULK MUX2_X1
X$150978 \$71807 \$65999 \$69885 \$71808 NWELL PWELL BULK MUX2_X1
X$150980 \$65999 \$71495 NWELL PWELL BULK BUF_X8
X$150983 \$68423 \$65999 \$67873 \$68194 NWELL PWELL BULK MUX2_X1
X$151014 \$68816 \$65999 \$68817 \$68740 NWELL PWELL BULK MUX2_X1
X$151016 \$66901 \$66727 \$66000 \$67435 NWELL PWELL BULK MUX2_X1
X$151025 \$66319 \$66312 \$66007 \$66005 NWELL PWELL BULK MUX2_X1
X$151029 \$66007 \$66724 \$66322 \$66734 NWELL PWELL BULK MUX2_X1
X$151075 M2_AXI_WSTRB[1] \$66021 NWELL PWELL BULK CLKBUF_X2
X$151096 \$66031 \$71173 \$79451 \$79121 NWELL PWELL BULK OAI21_X1
X$151099 \$70521 \$66031 \$78460 \$78801 NWELL PWELL BULK OAI21_X1
X$151102 \$66031 \$70514 \$78474 \$78473 NWELL PWELL BULK OAI21_X1
X$151105 \$66031 \$71156 \$79081 \$79482 NWELL PWELL BULK OAI21_X1
X$151147 \$66397 S2_AXI_WDATA[3] NWELL PWELL BULK BUF_X1
X$151152 \$73517 \$70862 \$73173 \$66049 NWELL PWELL BULK MUX2_X1
X$151326 \$66192 M2_AXI_RDATA[6] NWELL PWELL BULK BUF_X1
X$151370 \$66215 \$66727 \$67459 \$67468 NWELL PWELL BULK MUX2_X1
X$151389 \$67122 S2_AXI_AWLEN[5] NWELL PWELL BULK BUF_X1
X$151394 \$67581 S2_AXI_AWLEN[7] NWELL PWELL BULK BUF_X1
X$151399 \$67571 S2_AXI_AWSIZE[2] NWELL PWELL BULK BUF_X1
X$151431 \$I176197 \$70429 \$70614 \$66260 NWELL PWELL BULK DFF_X1
X$151434 \$I177736 \$69839 \$70432 \$66260 NWELL PWELL BULK DFF_X1
X$151436 \$I177657 \$69835 \$70085 \$66260 NWELL PWELL BULK DFF_X1
X$151438 \$I177647 \$68402 \$68603 \$66260 NWELL PWELL BULK DFF_X1
X$151441 \$I176719 \$71086 \$71268 \$66260 NWELL PWELL BULK DFF_X1
X$151445 \$I177648 \$71089 \$71651 \$66260 NWELL PWELL BULK DFF_X1
X$151448 \$I176169 \$69760 \$69598 \$66260 NWELL PWELL BULK DFF_X1
X$151451 \$I176201 \$69398 \$69767 \$66260 NWELL PWELL BULK DFF_X1
X$151456 \$I177660 \$67578 \$68077 \$66260 NWELL PWELL BULK DFF_X1
X$151458 \$I176191 \$67843 \$68060 \$66260 NWELL PWELL BULK DFF_X1
X$151463 \$I176174 \$70426 \$70606 \$66260 NWELL PWELL BULK DFF_X1
X$151465 \$I176180 \$69592 \$70070 \$66260 NWELL PWELL BULK DFF_X1
X$151469 \$I177646 \$69196 \$69392 \$66260 NWELL PWELL BULK DFF_X1
X$151471 \$I177927 \$66690 \$67215 \$66260 NWELL PWELL BULK DFF_X1
X$151474 \$I176256 \$69197 \$68977 \$66260 NWELL PWELL BULK DFF_X1
X$151476 \$I176184 \$68778 \$68968 \$66260 NWELL PWELL BULK DFF_X1
X$151479 \$I176662 \$70933 \$71084 \$66260 NWELL PWELL BULK DFF_X1
X$151482 \$I176622 \$72220 \$72386 \$66260 NWELL PWELL BULK DFF_X1
X$151485 \$I176615 \$71833 \$72382 \$66260 NWELL PWELL BULK DFF_X1
X$151488 \$I177584 \$71482 \$72004 \$66260 NWELL PWELL BULK DFF_X1
X$151490 \$I176674 \$73085 \$72221 \$66260 NWELL PWELL BULK DFF_X1
X$151492 \$I177579 \$74384 \$74814 \$66260 NWELL PWELL BULK DFF_X1
X$151494 \$I176627 \$73369 \$73635 \$66260 NWELL PWELL BULK DFF_X1
X$151496 \$I176617 \$73084 \$73083 \$66260 NWELL PWELL BULK DFF_X1
X$151498 \$I177583 \$72006 \$72374 \$66260 NWELL PWELL BULK DFF_X1
X$151500 \$I176628 \$73643 \$73376 \$66260 NWELL PWELL BULK DFF_X1
X$151548 \$I177987 \$66271 \$66273 \$66974 NWELL PWELL BULK DFF_X1
X$151573 \$66296 \$66564 \$66565 NWELL PWELL BULK XOR2_X1
X$151608 \$69067 \$66312 \$67873 \$69065 NWELL PWELL BULK MUX2_X1
X$151611 \$69750 \$66312 \$69260 \$69640 NWELL PWELL BULK MUX2_X1
X$151613 \$68448 \$66312 \$67477 \$68736 NWELL PWELL BULK MUX2_X1
X$151615 \$71785 \$66312 \$69892 \$71891 NWELL PWELL BULK MUX2_X1
X$151618 \$75133 \$66312 \$74026 \$74872 NWELL PWELL BULK MUX2_X1
X$151621 \$71039 \$66312 \$69885 \$70319 NWELL PWELL BULK MUX2_X1
X$151625 \$70201 \$66312 \$67878 \$70202 NWELL PWELL BULK MUX2_X1
X$151635 \$72930 \$66312 \$71515 \$73121 NWELL PWELL BULK MUX2_X1
X$151637 \$70804 \$71104 \$70803 \$66312 NWELL PWELL BULK NOR3_X4
X$151640 \$74626 \$66312 NWELL PWELL BULK BUF_X8
X$151642 \$70815 \$66312 \$70817 \$71034 NWELL PWELL BULK MUX2_X1
X$151672 \$69511 \$66312 \$68817 \$69509 NWELL PWELL BULK MUX2_X1
X$151692 \$66320 \$66727 \$66881 \$67908 NWELL PWELL BULK MUX2_X1
X$151763 \$72814 \$70862 \$73169 \$66384 NWELL PWELL BULK MUX2_X1
X$151770 \$67146 S2_AXI_WSTRB[2] NWELL PWELL BULK BUF_X1
X$151775 \$66409 S1_AXI_WDATA[30] NWELL PWELL BULK BUF_X1
X$151780 M0_AXI_WDATA[1] \$67664 NWELL PWELL BULK BUF_X1
X$151797 \$75934 \$70862 \$76638 \$66397 NWELL PWELL BULK MUX2_X1
X$151816 \$70913 \$70862 \$70858 \$66415 NWELL PWELL BULK MUX2_X1
X$151824 \$66418 S1_AXI_WDATA[5] NWELL PWELL BULK BUF_X1
X$151832 \$66425 S2_AXI_AWADDR[18] NWELL PWELL BULK BUF_X1
X$151941 \$66598 \$67048 \$70959 NWELL PWELL BULK NOR2_X2
X$151950 \$70521 \$66604 \$78372 \$78509 NWELL PWELL BULK OAI21_X1
X$151952 \$66604 \$71156 \$78375 \$78497 NWELL PWELL BULK OAI21_X1
X$151955 \$66604 \$71173 \$78809 \$78496 NWELL PWELL BULK OAI21_X1
X$151957 \$66604 \$70514 \$78188 \$78194 NWELL PWELL BULK OAI21_X1
X$152029 \$67144 S2_AXI_AWADDR[25] NWELL PWELL BULK BUF_X1
X$152034 \$67772 S2_AXI_AWLEN[4] NWELL PWELL BULK BUF_X1
X$152071 \$66976 \$66886 \$66700 \$66974 NWELL PWELL BULK DFF_X1
X$152076 \$67330 \$66705 \$67328 NWELL PWELL BULK XNOR2_X1
X$152094 S1_AXI_RDATA[3] \$66710 NWELL PWELL BULK CLKBUF_X2
X$152110 \$74843 \$66724 \$75393 \$75395 NWELL PWELL BULK MUX2_X1
X$152112 \$82562 \$66724 \$83461 \$83187 NWELL PWELL BULK MUX2_X1
X$152115 \$71515 \$66724 \$71789 \$71788 NWELL PWELL BULK MUX2_X1
X$152117 \$77169 \$66724 \$77875 \$77719 NWELL PWELL BULK MUX2_X1
X$152120 \$82552 \$66724 \$84071 \$84064 NWELL PWELL BULK MUX2_X1
X$152123 \$81146 \$66724 \$81144 \$81433 NWELL PWELL BULK MUX2_X1
X$152126 \$76995 \$66724 \$77285 \$77279 NWELL PWELL BULK MUX2_X1
X$152129 \$79336 \$66724 \$79503 \$79129 NWELL PWELL BULK MUX2_X1
X$152135 \$78298 \$66724 \$78635 \$78439 NWELL PWELL BULK MUX2_X1
X$152138 \$67873 \$66724 \$68201 \$68424 NWELL PWELL BULK MUX2_X1
X$152141 \$77367 \$66724 \$83823 \$84240 NWELL PWELL BULK MUX2_X1
X$152144 \$83140 \$66724 \$83195 \$83411 NWELL PWELL BULK MUX2_X1
X$152147 \$69892 \$66724 \$70745 \$70480 NWELL PWELL BULK MUX2_X1
X$152153 \$73999 \$66724 \$74004 \$74694 NWELL PWELL BULK MUX2_X1
X$152155 \$70817 \$66724 \$71388 \$71745 NWELL PWELL BULK MUX2_X1
X$152157 \$69885 \$66724 \$71031 \$71127 NWELL PWELL BULK MUX2_X1
X$152160 \$67878 \$66724 \$68701 \$68697 NWELL PWELL BULK MUX2_X1
X$152163 \$81493 \$66724 \$81499 \$81750 NWELL PWELL BULK MUX2_X1
X$152166 \$81806 \$66724 \$84670 \$84224 NWELL PWELL BULK MUX2_X1
X$152169 \$82831 \$66724 \$83773 \$83871 NWELL PWELL BULK MUX2_X1
X$152171 \$80771 \$66724 \$83860 \$84644 NWELL PWELL BULK MUX2_X1
X$152175 \$67477 \$66724 \$67909 \$67773 NWELL PWELL BULK MUX2_X1
X$152178 \$69260 \$66724 \$69266 \$68836 NWELL PWELL BULK MUX2_X1
X$152180 \$74026 \$66724 \$74342 \$74788 NWELL PWELL BULK MUX2_X1
X$152182 \$68817 \$66724 \$68438 \$68436 NWELL PWELL BULK MUX2_X1
X$152187 \$79404 \$66724 \$80141 \$79999 NWELL PWELL BULK MUX2_X1
X$152189 \$76515 \$66724 \$77163 \$77297 NWELL PWELL BULK MUX2_X1
X$152192 \$77655 \$66724 \$83111 \$83109 NWELL PWELL BULK MUX2_X1
X$152194 \$81840 \$66724 \$82898 \$82750 NWELL PWELL BULK MUX2_X1
X$152196 \$80098 \$66724 \$82892 \$83052 NWELL PWELL BULK MUX2_X1
X$152198 \$79979 \$66724 \$83450 \$83448 NWELL PWELL BULK MUX2_X1
X$152201 \$81483 \$66724 \$82237 \$82468 NWELL PWELL BULK MUX2_X1
X$152203 \$73106 \$66724 \$74218 \$73734 NWELL PWELL BULK MUX2_X1
X$152286 \$83051 \$66727 \$83345 \$83358 NWELL PWELL BULK MUX2_X1
X$152288 \$83671 \$66727 \$84251 \$84069 NWELL PWELL BULK MUX2_X1
X$152292 \$84524 \$66727 \$84526 \$84533 NWELL PWELL BULK MUX2_X1
X$152294 \$83452 \$66727 \$83377 \$83718 NWELL PWELL BULK MUX2_X1
X$152297 \$71126 \$66727 \$71439 \$71796 NWELL PWELL BULK MUX2_X1
X$152300 \$77722 \$66727 \$78201 \$78216 NWELL PWELL BULK MUX2_X1
X$152304 \$84617 \$66727 \$83858 \$84648 NWELL PWELL BULK MUX2_X1
X$152307 \$69071 \$66727 \$68426 \$68806 NWELL PWELL BULK MUX2_X1
X$152309 \$79889 \$66727 \$79890 \$80080 NWELL PWELL BULK MUX2_X1
X$152311 \$84558 \$66727 \$83454 \$84562 NWELL PWELL BULK MUX2_X1
X$152313 \$75180 \$66727 \$75181 \$75351 NWELL PWELL BULK MUX2_X1
X$152315 \$71459 \$66727 \$71131 \$71783 NWELL PWELL BULK MUX2_X1
X$152318 \$68844 \$66727 \$69133 \$69536 NWELL PWELL BULK MUX2_X1
X$152320 \$69891 \$66727 \$70348 \$70346 NWELL PWELL BULK MUX2_X1
X$152324 \$71743 \$66727 \$71509 \$72132 NWELL PWELL BULK MUX2_X1
X$152326 \$82095 \$66727 \$81877 \$81876 NWELL PWELL BULK MUX2_X1
X$152328 \$84702 \$66727 \$84700 \$84229 NWELL PWELL BULK MUX2_X1
X$152333 \$75516 \$66727 \$74033 \$75512 NWELL PWELL BULK MUX2_X1
X$152336 \$67403 \$66727 \$67399 \$67408 NWELL PWELL BULK MUX2_X1
X$152338 \$69527 \$66727 \$69526 \$69765 NWELL PWELL BULK MUX2_X1
X$152341 \$67796 \$66727 \$67791 \$68281 NWELL PWELL BULK MUX2_X1
X$152344 \$69485 \$66727 \$69233 \$69780 NWELL PWELL BULK MUX2_X1
X$152346 \$80491 \$66727 \$80142 \$80876 NWELL PWELL BULK MUX2_X1
X$152348 \$72933 \$66727 \$72259 \$73297 NWELL PWELL BULK MUX2_X1
X$152350 \$75092 \$66727 \$75094 \$75431 NWELL PWELL BULK MUX2_X1
X$152352 \$84165 \$66727 \$83462 \$83854 NWELL PWELL BULK MUX2_X1
X$152354 \$71850 \$66974 \$I245621 \$66727 NWELL PWELL BULK DFF_X2
X$152357 \$83166 \$66727 \$82846 \$83788 NWELL PWELL BULK MUX2_X1
X$152359 \$84227 \$66727 \$83476 \$83809 NWELL PWELL BULK MUX2_X1
X$152362 \$69609 \$66727 \$70136 \$70143 NWELL PWELL BULK MUX2_X1
X$152364 \$83198 \$66727 \$83790 \$84210 NWELL PWELL BULK MUX2_X1
X$152366 \$79130 \$66727 \$79132 \$79509 NWELL PWELL BULK MUX2_X1
X$152368 \$77831 \$66727 \$77830 \$77708 NWELL PWELL BULK MUX2_X1
X$152370 \$82330 \$66727 \$82334 \$82537 NWELL PWELL BULK MUX2_X1
X$152372 \$82991 \$66727 \$83975 \$83827 NWELL PWELL BULK MUX2_X1
X$152374 \$75765 \$66727 \$76055 \$77721 NWELL PWELL BULK MUX2_X1
X$152377 \$77164 \$66727 \$77165 \$77604 NWELL PWELL BULK MUX2_X1
X$152492 \$67681 S2_AXI_WID[7] NWELL PWELL BULK BUF_X1
X$152613 \$67145 S2_AXI_AWADDR[21] NWELL PWELL BULK BUF_X1
X$152666 \$I177988 \$67856 \$68114 \$66974 NWELL PWELL BULK DFF_X1
X$152668 \$67593 \$67860 \$68135 \$66974 NWELL PWELL BULK DFF_X1
X$152670 \$I177905 \$69781 \$69213 \$66974 NWELL PWELL BULK DFF_X1
X$152673 \$71854 \$72070 \$71498 \$66974 NWELL PWELL BULK DFF_X1
X$152675 \$71111 \$71704 \$71703 \$66974 NWELL PWELL BULK DFF_X1
X$152678 \$I176589 \$73097 \$72552 \$66974 NWELL PWELL BULK DFF_X1
X$152681 \$I176586 \$72231 \$71850 \$66974 NWELL PWELL BULK DFF_X1
X$152686 \$71493 \$66974 \$I245683 \$70987 NWELL PWELL BULK DFF_X2
X$152688 \$I177679 \$68799 \$69220 \$66974 NWELL PWELL BULK DFF_X1
X$152691 \$I177677 \$70450 \$70671 \$66974 NWELL PWELL BULK DFF_X1
X$152693 \$70446 \$66974 \$I245634 \$70804 NWELL PWELL BULK DFF_X2
X$152696 \$71000 \$70447 \$70659 \$66974 NWELL PWELL BULK DFF_X1
X$152698 \$I177682 \$68414 \$68415 \$66974 NWELL PWELL BULK DFF_X1
X$152701 \$I176480 \$69610 \$70130 \$66974 NWELL PWELL BULK DFF_X1
X$152703 \$I176465 \$69612 \$70154 \$66974 NWELL PWELL BULK DFF_X1
X$152705 \$71499 \$70809 \$71707 \$66974 NWELL PWELL BULK DFF_X1
X$152708 \$I176739 \$70453 \$70677 \$66974 NWELL PWELL BULK DFF_X1
X$152710 \$72552 \$66974 \$I245682 \$69217 NWELL PWELL BULK DFF_X2
X$152712 \$72805 \$72555 \$72799 \$66974 NWELL PWELL BULK DFF_X1
X$152715 \$68754 \$66974 NWELL PWELL BULK BUF_X4
X$152718 \$67861 \$68410 \$68409 \$66974 NWELL PWELL BULK DFF_X1
X$152720 \$68143 \$68141 \$68138 \$66974 NWELL PWELL BULK DFF_X1
X$152722 \$66977 \$67273 \$67784 \$66974 NWELL PWELL BULK DFF_X1
X$152726 \$69843 \$69841 \$69842 \$66974 NWELL PWELL BULK DFF_X1
X$152728 \$I176680 \$69218 \$69031 \$66974 NWELL PWELL BULK DFF_X1
X$152731 \$69608 \$68794 \$69216 \$66974 NWELL PWELL BULK DFF_X1
X$152734 \$68412 \$68649 \$68653 \$66974 NWELL PWELL BULK DFF_X1
X$152763 S1_AXI_RDATA[6] \$66980 NWELL PWELL BULK CLKBUF_X2
X$152769 \$67868 \$67598 \$66980 \$68158 NWELL PWELL BULK MUX2_X1
X$152780 \$75193 \$66985 \$74853 \$74856 NWELL PWELL BULK MUX2_X1
X$152782 \$82370 \$66985 \$82704 \$81842 NWELL PWELL BULK MUX2_X1
X$152784 \$73108 \$72568 \$66985 \$72605 NWELL PWELL BULK MUX2_X2
X$152786 \$73418 \$66985 \$73420 \$72572 NWELL PWELL BULK MUX2_X1
X$152788 \$82123 \$66985 \$82124 \$81852 NWELL PWELL BULK MUX2_X1
X$152790 \$72587 \$66985 \$71875 \$72590 NWELL PWELL BULK MUX2_X1
X$152793 \$76519 \$66985 \$77168 \$76527 NWELL PWELL BULK MUX2_X1
X$152796 \$78524 \$66985 \$78869 \$78318 NWELL PWELL BULK MUX2_X1
X$152798 \$78504 \$66985 \$79191 \$78321 NWELL PWELL BULK MUX2_X1
X$152801 \$73110 \$66985 \$72870 \$71799 NWELL PWELL BULK MUX2_X1
X$152803 \$72250 \$66985 \$72891 \$72573 NWELL PWELL BULK MUX2_X1
X$152807 \$79401 \$66985 \$79028 \$79402 NWELL PWELL BULK MUX2_X1
X$152810 \$81470 \$66985 \$81782 \$81482 NWELL PWELL BULK MUX2_X1
X$152812 \$79372 \$66985 \$79261 \$79375 NWELL PWELL BULK MUX2_X1
X$152815 \$78679 \$66985 \$78973 \$79022 NWELL PWELL BULK MUX2_X1
X$152818 \$76898 \$66985 \$77115 \$76549 NWELL PWELL BULK MUX2_X1
X$152820 \$77474 \$66985 \$78233 \$77924 NWELL PWELL BULK MUX2_X1
X$152822 \$80838 \$66985 \$82012 \$81476 NWELL PWELL BULK MUX2_X1
X$152825 \$81640 \$66985 \$81438 \$80844 NWELL PWELL BULK MUX2_X1
X$152828 \$81308 \$66985 \$80995 \$80848 NWELL PWELL BULK MUX2_X1
X$152830 \$81843 \$66985 \$82222 \$81860 NWELL PWELL BULK MUX2_X1
X$152832 \$80372 \$66985 \$80111 \$76215 NWELL PWELL BULK MUX2_X1
X$152834 \$82037 \$66985 \$82214 \$82215 NWELL PWELL BULK MUX2_X1
X$152836 \$80414 \$66985 \$80758 \$80130 NWELL PWELL BULK MUX2_X1
X$152839 \$69470 \$66985 \$69791 \$69158 NWELL PWELL BULK MUX2_X1
X$152841 \$75366 \$66985 \$75372 \$75189 NWELL PWELL BULK MUX2_X1
X$152844 \$79553 \$66985 \$79350 \$79005 NWELL PWELL BULK MUX2_X1
X$152905 S0_AXI_RDATA[3] \$66992 NWELL PWELL BULK CLKBUF_X2
X$152966 \$68256 \$68731 \$67030 NWELL PWELL BULK OR2_X2
X$153071 \$70521 \$67088 \$75295 \$75254 NWELL PWELL BULK OAI21_X1
X$153074 \$67237 \$67229 \$67088 NWELL PWELL BULK NOR2_X2
X$153076 \$67088 \$70514 \$76296 \$75928 NWELL PWELL BULK OAI21_X1
X$153079 \$67088 \$71156 \$76602 \$76951 NWELL PWELL BULK OAI21_X1
X$153081 \$67088 \$71173 \$76662 \$76952 NWELL PWELL BULK OAI21_X1
X$153110 \$72329 \$70862 \$73190 \$67108 NWELL PWELL BULK MUX2_X1
X$153113 \$67108 S2_AXI_WDATA[30] NWELL PWELL BULK BUF_X1
X$153120 \$67149 S2_AXI_WDATA[4] NWELL PWELL BULK BUF_X1
X$153164 \$73181 \$70862 \$73524 \$67146 NWELL PWELL BULK MUX2_X1
X$153171 \$73530 \$70862 \$73531 \$67149 NWELL PWELL BULK MUX2_X1
X$153265 \$67286 \$67951 \$69944 NWELL PWELL BULK NOR2_X2
X$153318 \$67330 \$67603 NWELL PWELL BULK INV_X2
X$153322 S1_AXI_RVALID \$67342 NWELL PWELL BULK CLKBUF_X2
X$153397 \$67408 M0_AXI_RLAST NWELL PWELL BULK BUF_X1
X$153427 \$67435 M0_AXI_RID[2] NWELL PWELL BULK BUF_X1
X$153462 \$67468 M0_AXI_RID[3] NWELL PWELL BULK BUF_X1
X$153528 \$67825 S2_AXI_AWADDR[7] NWELL PWELL BULK BUF_X1
X$153533 \$68508 S2_AXI_AWSIZE[0] NWELL PWELL BULK BUF_X1
X$153538 \$69337 S2_AXI_AWADDR[23] NWELL PWELL BULK BUF_X1
X$153544 \$I175577 \$67561 \$67977 \$67823 NWELL PWELL BULK DFF_X1
X$153604 \$79164 \$67598 \$78994 \$78640 NWELL PWELL BULK MUX2_X1
X$153607 \$73421 \$67598 \$71861 \$73332 NWELL PWELL BULK MUX2_X1
X$153609 \$81148 \$67598 \$80982 \$81296 NWELL PWELL BULK MUX2_X1
X$153611 \$81332 \$67598 \$81441 \$81331 NWELL PWELL BULK MUX2_X1
X$153613 \$77724 \$67598 \$77172 \$77889 NWELL PWELL BULK MUX2_X1
X$153616 \$75038 \$67598 \$74838 \$75353 NWELL PWELL BULK MUX2_X1
X$153620 \$81312 \$67598 \$81829 \$81002 NWELL PWELL BULK MUX2_X1
X$153623 \$81834 \$67598 \$81444 \$82016 NWELL PWELL BULK MUX2_X1
X$153625 \$70183 \$67598 \$69621 \$70181 NWELL PWELL BULK MUX2_X1
X$153628 \$81824 \$67598 \$81825 \$81969 NWELL PWELL BULK MUX2_X1
X$153630 \$74421 \$67598 \$72570 \$74257 NWELL PWELL BULK MUX2_X1
X$153633 \$76400 \$67598 \$75844 \$76043 NWELL PWELL BULK MUX2_X1
X$153635 \$73993 \$67598 \$73994 \$74645 NWELL PWELL BULK MUX2_X1
X$153637 \$78513 \$67598 \$79194 \$78511 NWELL PWELL BULK MUX2_X1
X$153640 \$78843 \$67598 \$78643 \$78487 NWELL PWELL BULK MUX2_X1
X$153672 S2_AXI_RDATA[3] \$67599 NWELL PWELL BULK BUF_X1
X$153687 \$67603 S1_AXI_RREADY NWELL PWELL BULK BUF_X1
X$153716 \$68226 \$67612 \$67629 NWELL PWELL BULK OR2_X2
X$153729 S1_AXI_RRESP[1] \$67618 NWELL PWELL BULK CLKBUF_X2
X$153793 \$67643 \$67644 \$68223 NWELL PWELL BULK NOR2_X2
X$153824 \$68045 \$67660 \$68888 NWELL PWELL BULK NOR2_X1
X$153840 \$68521 S2_AXI_WID[2] NWELL PWELL BULK BUF_X1
X$153845 \$68923 S2_AXI_WDATA[13] NWELL PWELL BULK BUF_X1
X$153850 M0_AXI_WID[2] \$67954 NWELL PWELL BULK BUF_X1
X$153855 \$74964 \$70862 \$75630 \$67681 NWELL PWELL BULK MUX2_X1
X$153859 \$67681 \$67968 NWELL PWELL BULK BUF_X1
X$153904 \$67730 \$67937 \$68220 NWELL PWELL BULK NOR2_X2
X$153931 \$67927 \$68283 \$67751 \$68468 NWELL PWELL BULK MUX2_X1
X$153944 \$67757 M2_AXI_RDATA[8] NWELL PWELL BULK BUF_X1
X$153957 \$67768 M1_AXI_RDATA[3] NWELL PWELL BULK BUF_X1
X$154003 \$67822 S2_AXI_AWADDR[27] NWELL PWELL BULK BUF_X1
X$154008 \$69962 S2_AXI_AWADDR[12] NWELL PWELL BULK BUF_X1
X$154013 \$68581 S2_AXI_AWADDR[28] NWELL PWELL BULK BUF_X1
X$154023 \$I175684 \$72212 \$72211 \$67823 NWELL PWELL BULK DFF_X1
X$154025 \$I175547 \$69184 \$70001 \$67823 NWELL PWELL BULK DFF_X1
X$154028 \$I178390 \$70414 \$70903 \$67823 NWELL PWELL BULK DFF_X1
X$154031 \$I178368 \$70015 \$70019 \$67823 NWELL PWELL BULK DFF_X1
X$154033 \$I178389 \$70780 \$70896 \$67823 NWELL PWELL BULK DFF_X1
X$154038 \$I178421 \$71468 \$71469 \$67823 NWELL PWELL BULK DFF_X1
X$154041 \$I178322 \$71818 \$71972 \$67823 NWELL PWELL BULK DFF_X1
X$154044 \$I178320 \$71817 \$72208 \$67823 NWELL PWELL BULK DFF_X1
X$154046 \$I178391 \$70408 \$70406 \$67823 NWELL PWELL BULK DFF_X1
X$154048 \$I178394 \$69813 \$70410 \$67823 NWELL PWELL BULK DFF_X1
X$154051 \$I178302 \$69967 \$69964 \$67823 NWELL PWELL BULK DFF_X1
X$154053 \$I177706 \$68908 \$69180 \$67823 NWELL PWELL BULK DFF_X1
X$154056 \$I178301 \$69332 \$69329 \$67823 NWELL PWELL BULK DFF_X1
X$154059 \$I175551 \$70779 \$70556 \$67823 NWELL PWELL BULK DFF_X1
X$154061 \$I178299 \$69981 \$69814 \$67823 NWELL PWELL BULK DFF_X1
X$154063 \$I178329 \$67830 \$68530 \$67823 NWELL PWELL BULK DFF_X1
X$154065 \$I178338 \$69182 \$69344 \$67823 NWELL PWELL BULK DFF_X1
X$154067 \$I178287 \$68767 \$69185 \$67823 NWELL PWELL BULK DFF_X1
X$154069 \$72524 \$73072 \$72520 \$67823 NWELL PWELL BULK DFF_X1
X$154071 \$73075 \$73571 \$73576 \$67823 NWELL PWELL BULK DFF_X1
X$154073 \$I178255 \$71200 \$71580 \$67823 NWELL PWELL BULK DFF_X1
X$154075 \$I175648 \$71814 \$71960 \$67823 NWELL PWELL BULK DFF_X1
X$154077 \$73073 \$73549 \$73551 \$67823 NWELL PWELL BULK DFF_X1
X$154080 \$74936 \$74938 \$75265 \$67823 NWELL PWELL BULK DFF_X1
X$154082 \$75639 \$75939 \$75937 \$67823 NWELL PWELL BULK DFF_X1
X$154084 \$74935 \$73967 \$74095 \$67823 NWELL PWELL BULK DFF_X1
X$154087 \$I178229 \$72206 \$71964 \$67823 NWELL PWELL BULK DFF_X1
X$154090 \$73076 \$73574 \$73201 \$67823 NWELL PWELL BULK DFF_X1
X$154093 \$74520 \$74510 \$74516 \$67823 NWELL PWELL BULK DFF_X1
X$154156 \$I177903 \$67852 \$68408 \$69210 NWELL PWELL BULK DFF_X1
X$154201 \$80066 \$67885 \$78686 \$80060 NWELL PWELL BULK MUX2_X1
X$154204 \$77378 \$67885 \$76896 \$77375 NWELL PWELL BULK MUX2_X1
X$154206 \$79782 \$67885 \$79783 \$80044 NWELL PWELL BULK MUX2_X1
X$154209 \$78593 \$67885 \$78052 \$78283 NWELL PWELL BULK MUX2_X1
X$154211 \$81460 \$67885 \$81462 \$81394 NWELL PWELL BULK MUX2_X1
X$154214 \$80377 \$67885 \$79777 \$80113 NWELL PWELL BULK MUX2_X1
X$154216 \$72254 \$67885 \$71121 \$72912 NWELL PWELL BULK MUX2_X1
X$154219 \$72139 \$67885 \$72248 \$71869 NWELL PWELL BULK MUX2_X1
X$154221 \$69238 \$67885 \$68713 \$68711 NWELL PWELL BULK MUX2_X1
X$154224 \$75812 \$67885 \$73436 \$76091 NWELL PWELL BULK MUX2_X1
X$154226 \$81170 \$67885 \$80466 \$81753 NWELL PWELL BULK MUX2_X1
X$154229 \$81412 \$67885 \$81172 \$81764 NWELL PWELL BULK MUX2_X1
X$154232 \$80362 \$67885 \$80110 \$80369 NWELL PWELL BULK MUX2_X1
X$154263 S1_AXI_RDATA[25] \$67890 NWELL PWELL BULK BUF_X1
X$154300 \$67908 M0_AXI_RDATA[6] NWELL PWELL BULK BUF_X1
X$154340 \$67928 \$68283 \$67929 \$68674 NWELL PWELL BULK MUX2_X1
X$154396 \$67945 \$68149 \$69671 NWELL PWELL BULK NOR2_X1
X$154440 \$67963 \$71156 \$75269 \$75276 NWELL PWELL BULK MUX2_X1
X$154443 \$67963 \$70514 \$74931 \$74929 NWELL PWELL BULK MUX2_X1
X$154446 \$67963 \$71173 \$74506 \$74089 NWELL PWELL BULK MUX2_X1
X$154449 \$67963 \$70521 \$74503 \$74096 NWELL PWELL BULK MUX2_X1
X$154455 \$67968 S2_AXI_WID[3] NWELL PWELL BULK BUF_X1
X$154467 \$68500 S2_AXI_WDATA[0] NWELL PWELL BULK BUF_X1
X$154472 \$69322 S2_AXI_WDATA[10] NWELL PWELL BULK BUF_X1
X$154517 \$68013 \$71156 \$76317 \$76309 NWELL PWELL BULK MUX2_X1
X$154520 \$68013 \$70514 \$75634 \$75970 NWELL PWELL BULK MUX2_X1
X$154524 \$68013 \$70521 \$76308 \$76606 NWELL PWELL BULK MUX2_X1
X$154527 \$68013 \$71173 \$76610 \$76965 NWELL PWELL BULK MUX2_X1
X$154727 \$68220 \$70514 \$80948 \$80536 NWELL PWELL BULK OAI21_X1
X$154730 \$68220 \$71173 \$81218 \$81613 NWELL PWELL BULK OAI21_X1
X$154732 \$68220 \$71156 \$81948 \$81219 NWELL PWELL BULK OAI21_X1
X$154734 \$70521 \$68220 \$79824 \$79884 NWELL PWELL BULK OAI21_X1
X$154746 \$68223 \$70514 \$83227 \$83253 NWELL PWELL BULK OAI21_X1
X$154748 \$70521 \$68223 \$83944 \$84286 NWELL PWELL BULK OAI21_X1
X$154750 \$68223 \$71173 \$82278 \$82709 NWELL PWELL BULK OAI21_X1
X$154753 \$68223 \$71156 \$82274 \$82328 NWELL PWELL BULK OAI21_X1
X$154807 \$68281 M0_AXI_RID[1] NWELL PWELL BULK BUF_X1
X$154812 \$69919 \$68283 \$69920 \$69921 NWELL PWELL BULK MUX2_X1
X$154814 \$70976 \$68283 \$71150 \$71736 NWELL PWELL BULK MUX2_X1
X$154821 \$82929 \$68283 \$83073 \$84279 NWELL PWELL BULK MUX2_X1
X$154823 \$83502 \$68283 \$83506 \$83504 NWELL PWELL BULK MUX2_X1
X$154825 \$78528 \$68283 \$78370 \$79182 NWELL PWELL BULK MUX2_X1
X$154828 \$77519 \$68283 \$77224 \$77872 NWELL PWELL BULK MUX2_X1
X$154831 \$78516 \$68283 \$78371 \$79507 NWELL PWELL BULK MUX2_X1
X$154834 \$79200 \$68283 \$79527 \$79433 NWELL PWELL BULK MUX2_X1
X$154836 \$78537 \$68283 \$78535 \$79531 NWELL PWELL BULK MUX2_X1
X$154839 \$82604 \$68283 \$82606 \$82933 NWELL PWELL BULK MUX2_X1
X$154842 \$83891 \$68283 \$83514 \$84485 NWELL PWELL BULK MUX2_X1
X$154844 \$83656 \$68283 \$83511 \$83510 NWELL PWELL BULK MUX2_X1
X$154846 \$82763 \$68283 \$82600 \$82601 NWELL PWELL BULK MUX2_X1
X$154848 \$77324 \$68283 \$77523 \$77857 NWELL PWELL BULK MUX2_X1
X$154851 \$80524 \$68283 \$80525 \$80643 NWELL PWELL BULK MUX2_X1
X$154854 \$81523 \$68283 \$81643 \$81977 NWELL PWELL BULK MUX2_X1
X$154857 \$83894 \$68283 \$83516 \$83617 NWELL PWELL BULK MUX2_X1
X$154859 \$74469 \$68283 \$74677 \$75224 NWELL PWELL BULK MUX2_X1
X$154861 \$72632 \$68283 \$72955 \$73850 NWELL PWELL BULK MUX2_X1
X$154864 \$76103 \$68283 \$75722 \$76102 NWELL PWELL BULK MUX2_X1
X$154866 \$72630 \$68283 \$72302 \$73147 NWELL PWELL BULK MUX2_X1
X$154869 \$69283 \$68283 \$69656 \$70356 NWELL PWELL BULK MUX2_X1
X$154872 \$71908 \$68283 \$70981 \$72996 NWELL PWELL BULK MUX2_X1
X$154875 \$74900 \$68283 \$75423 \$74902 NWELL PWELL BULK MUX2_X1
X$154878 \$74047 \$68283 \$74258 \$74048 NWELL PWELL BULK MUX2_X1
X$154880 \$77345 \$68283 \$77025 \$77222 NWELL PWELL BULK MUX2_X1
X$154882 \$76762 \$68283 \$76268 \$77328 NWELL PWELL BULK MUX2_X1
X$154884 \$76933 \$68283 \$76263 \$77632 NWELL PWELL BULK MUX2_X1
X$154886 \$79437 \$68283 \$79066 \$79919 NWELL PWELL BULK MUX2_X1
X$154888 \$79506 \$68283 \$79441 \$80253 NWELL PWELL BULK MUX2_X1
X$154890 \$80621 \$68283 \$80527 \$80624 NWELL PWELL BULK MUX2_X1
X$154892 \$81525 \$68283 \$81212 \$82347 NWELL PWELL BULK MUX2_X1
X$154895 \$82348 \$68283 \$82935 \$83273 NWELL PWELL BULK MUX2_X1
X$154898 \$81892 \$68283 \$80990 \$81985 NWELL PWELL BULK MUX2_X1
X$154900 \$80167 \$68283 \$80521 \$80666 NWELL PWELL BULK MUX2_X1
X$154902 \$79925 \$68283 \$80281 \$80518 NWELL PWELL BULK MUX2_X1
X$154905 \$81206 \$68283 \$81662 \$82261 NWELL PWELL BULK MUX2_X1
X$154983 \$68341 \$68336 \$68331 NWELL PWELL BULK OR2_X1
X$154986 \$68462 \$68463 \$68331 \$69080 NWELL PWELL BULK MUX2_X1
X$155069 \$68895 S2_AXI_AWADDR[4] NWELL PWELL BULK BUF_X1
X$155074 \$68918 S2_AXI_AWLEN[3] NWELL PWELL BULK BUF_X1
X$155120 \$69218 \$69217 \$68414 \$69609 NWELL PWELL BULK MUX2_X1
X$155177 \$72294 \$68463 \$71537 \$72432 NWELL PWELL BULK MUX2_X1
X$155181 \$77345 \$68463 \$76533 \$77348 NWELL PWELL BULK MUX2_X1
X$155183 \$77216 \$68463 \$76930 \$77370 NWELL PWELL BULK MUX2_X1
X$155186 \$78840 \$68463 \$79059 \$78725 NWELL PWELL BULK MUX2_X1
X$155189 \$81206 \$68463 \$80993 \$80996 NWELL PWELL BULK MUX2_X1
X$155192 \$79925 \$68463 \$80165 \$79930 NWELL PWELL BULK MUX2_X1
X$155194 \$76142 \$68463 \$74896 \$75887 NWELL PWELL BULK MUX2_X1
X$155197 \$70699 \$68463 \$69912 \$70488 NWELL PWELL BULK MUX2_X1
X$155199 \$73477 \$68463 \$73478 \$73891 NWELL PWELL BULK MUX2_X1
X$155203 \$76444 \$68463 \$75897 \$76578 NWELL PWELL BULK MUX2_X1
X$155205 \$79200 \$68463 \$78366 \$79555 NWELL PWELL BULK MUX2_X1
X$155207 \$82256 \$68463 \$81673 \$82257 NWELL PWELL BULK MUX2_X1
X$155209 \$79812 \$68463 \$80161 \$80302 NWELL PWELL BULK MUX2_X1
X$155211 \$77775 \$68463 \$77512 \$77904 NWELL PWELL BULK MUX2_X1
X$155213 \$78360 \$68463 \$78223 \$78359 NWELL PWELL BULK MUX2_X1
X$155253 \$I176729 \$68479 \$68650 \$69020 NWELL PWELL BULK DFF_X1
X$155288 \$70868 \$70862 \$71603 \$68497 NWELL PWELL BULK MUX2_X1
X$155290 \$68497 S2_AXI_WDATA[1] NWELL PWELL BULK BUF_X1
X$155292 \$76371 \$70862 \$76299 \$68498 NWELL PWELL BULK MUX2_X1
X$155294 \$68498 \$68521 NWELL PWELL BULK BUF_X1
X$155296 \$68498 S2_AXI_WID[6] NWELL PWELL BULK BUF_X1
X$155304 \$70879 \$70862 \$71196 \$68500 NWELL PWELL BULK MUX2_X1
X$155311 \$69699 S2_AXI_WDATA[24] NWELL PWELL BULK BUF_X1
X$155392 \$I176232 \$68610 \$68983 \$68876 NWELL PWELL BULK DFF_X1
X$155436 \$I175988 \$68658 \$68863 \$69020 NWELL PWELL BULK DFF_X1
X$155450 \$68666 S1_AXI_WDATA[12] NWELL PWELL BULK BUF_X1
X$155466 \$68675 M2_AXI_RDATA[3] NWELL PWELL BULK BUF_X1
X$155484 \$68690 M1_AXI_RRESP[1] NWELL PWELL BULK BUF_X1
X$155517 S1_AXI_RDATA[8] \$68713 NWELL PWELL BULK CLKBUF_X2
X$155567 \$68754 \$76370 NWELL PWELL BULK BUF_X4
X$155569 \$68754 \$71123 NWELL PWELL BULK BUF_X4
X$155572 \$68754 \$69210 NWELL PWELL BULK BUF_X4
X$155575 \$68754 \$72541 NWELL PWELL BULK BUF_X4
X$155577 \$68754 \$76468 NWELL PWELL BULK BUF_X4
X$155580 \$68754 \$80086 NWELL PWELL BULK BUF_X4
X$155582 \$68754 \$78674 NWELL PWELL BULK BUF_X4
X$155585 \$68754 \$79245 NWELL PWELL BULK BUF_X4
X$155590 \$68754 \$69618 NWELL PWELL BULK BUF_X4
X$155593 \$68754 \$70810 NWELL PWELL BULK BUF_X4
X$155596 \$68754 \$77572 NWELL PWELL BULK BUF_X4
X$155600 \$68754 \$76525 NWELL PWELL BULK BUF_X4
X$155605 \$68754 \$76202 NWELL PWELL BULK BUF_X4
X$155631 \$69806 S2_AXI_AWID[7] NWELL PWELL BULK BUF_X1
X$155636 \$69997 S2_AXI_AWADDR[29] NWELL PWELL BULK BUF_X1
X$155641 \$68911 S2_AXI_AWADDR[1] NWELL PWELL BULK BUF_X1
X$155665 \$69785 \$68792 \$69435 \$69210 NWELL PWELL BULK DFF_X1
X$155676 \$69610 \$69217 \$68799 \$70136 NWELL PWELL BULK MUX2_X1
X$155680 \$68803 \$69463 \$68802 \$69618 NWELL PWELL BULK DFF_X1
X$155685 \$68806 M0_AXI_RDATA[8] NWELL PWELL BULK BUF_X1
X$155726 \$I176411 \$69266 \$68836 \$69541 NWELL PWELL BULK DFF_X1
X$155772 \$I178890 \$68873 \$69292 \$68876 NWELL PWELL BULK DFF_X1
X$155777 \$I176241 \$68875 \$69295 \$68876 NWELL PWELL BULK DFF_X1
X$155782 \$I176112 \$69414 \$69724 \$68876 NWELL PWELL BULK DFF_X1
X$155785 \$70929 \$71292 \$71296 \$68876 NWELL PWELL BULK DFF_X1
X$155788 \$I178856 \$69672 \$70171 \$68876 NWELL PWELL BULK DFF_X1
X$155790 \$I177426 \$70856 \$71164 \$68876 NWELL PWELL BULK DFF_X1
X$155795 \$70207 \$70501 \$70500 \$68876 NWELL PWELL BULK DFF_X1
X$155798 \$70505 \$70504 \$70624 \$68876 NWELL PWELL BULK DFF_X1
X$155801 \$I178784 \$69296 \$69293 \$68876 NWELL PWELL BULK DFF_X1
X$155807 \$69937 \$70939 \$70622 \$68876 NWELL PWELL BULK DFF_X1
X$155810 \$70507 \$70852 \$71325 \$68876 NWELL PWELL BULK DFF_X1
X$155813 \$I175261 \$73506 \$73735 \$68876 NWELL PWELL BULK DFF_X1
X$155815 \$I175300 \$71931 \$72053 \$68876 NWELL PWELL BULK DFF_X1
X$155817 \$I175050 \$71637 \$71170 \$68876 NWELL PWELL BULK DFF_X1
X$155820 \$I179299 \$73511 \$73225 \$68876 NWELL PWELL BULK DFF_X1
X$155823 \$I179301 \$71934 \$72810 \$68876 NWELL PWELL BULK DFF_X1
X$155825 \$I175264 \$72666 \$72665 \$68876 NWELL PWELL BULK DFF_X1
X$155827 \$I178954 \$74073 \$74071 \$68876 NWELL PWELL BULK DFF_X1
X$155829 \$70511 \$71286 \$71289 \$68876 NWELL PWELL BULK DFF_X1
X$155832 \$71681 \$72101 \$72384 \$68876 NWELL PWELL BULK DFF_X1
X$155834 \$72839 \$73754 \$73159 \$68876 NWELL PWELL BULK DFF_X1
X$155836 \$72655 \$72377 \$72380 \$68876 NWELL PWELL BULK DFF_X1
X$155838 \$I175103 \$71168 \$71165 \$68876 NWELL PWELL BULK DFF_X1
X$155842 \$I178966 \$72815 \$73742 \$68876 NWELL PWELL BULK DFF_X1
X$155845 \$I175064 \$72073 \$72829 \$68876 NWELL PWELL BULK DFF_X1
X$155847 \$73162 \$73752 \$73160 \$68876 NWELL PWELL BULK DFF_X1
X$155849 \$I177275 \$71925 \$72314 \$68876 NWELL PWELL BULK DFF_X1
X$155851 \$I178953 \$72659 \$72318 \$68876 NWELL PWELL BULK DFF_X1
X$155853 \$72845 \$71678 \$71922 \$68876 NWELL PWELL BULK DFF_X1
X$155892 \$68888 \$71156 \$71990 \$71944 NWELL PWELL BULK OAI21_X1
X$155894 \$68888 \$71173 \$71986 \$72350 NWELL PWELL BULK OAI21_X1
X$155896 \$68888 \$70514 \$70865 \$70526 NWELL PWELL BULK OAI21_X1
X$155898 \$70521 \$68888 \$70891 \$70864 NWELL PWELL BULK OAI21_X1
X$155904 \$69987 S2_AXI_WID[4] NWELL PWELL BULK BUF_X1
X$155909 \$69986 S2_AXI_WDATA[23] NWELL PWELL BULK BUF_X1
X$155914 \$68903 S2_AXI_WDATA[17] NWELL PWELL BULK BUF_X1
X$155923 \$70861 \$70862 \$71570 \$68903 NWELL PWELL BULK MUX2_X1
X$155956 M0_AXI_WDATA[19] \$68922 NWELL PWELL BULK BUF_X1
X$155964 \$76293 \$70862 \$75651 \$68923 NWELL PWELL BULK MUX2_X1
X$156027 \$I176742 \$69933 \$70252 \$69020 NWELL PWELL BULK DFF_X1
X$156030 \$70850 \$71339 \$70849 \$69020 NWELL PWELL BULK DFF_X1
X$156033 \$70256 \$70644 \$70652 \$69020 NWELL PWELL BULK DFF_X1
X$156037 \$70261 \$70268 \$70275 \$69020 NWELL PWELL BULK DFF_X1
X$156039 \$69929 \$70293 \$69926 \$69020 NWELL PWELL BULK DFF_X1
X$156042 \$72902 \$69020 NWELL PWELL BULK BUF_X4
X$156044 \$I174723 \$73810 \$72919 \$69020 NWELL PWELL BULK DFF_X1
X$156046 \$I174679 \$74640 \$74914 \$69020 NWELL PWELL BULK DFF_X1
X$156049 \$I177224 \$74629 \$74481 \$69020 NWELL PWELL BULK DFF_X1
X$156052 \$I177333 \$72641 \$72398 \$69020 NWELL PWELL BULK DFF_X1
X$156054 \$I177223 \$72642 \$73235 \$69020 NWELL PWELL BULK DFF_X1
X$156056 \$71159 \$71699 \$71157 \$69020 NWELL PWELL BULK DFF_X1
X$156058 \$72645 \$72310 \$72309 \$69020 NWELL PWELL BULK DFF_X1
X$156061 \$71693 \$71335 \$71334 \$69020 NWELL PWELL BULK DFF_X1
X$156063 \$72882 \$72873 \$72871 \$69020 NWELL PWELL BULK DFF_X1
X$156066 \$I177331 \$71914 \$71155 \$69020 NWELL PWELL BULK DFF_X1
X$156069 \$71708 \$71545 \$72122 \$69020 NWELL PWELL BULK DFF_X1
X$156072 \$72646 \$73774 \$73152 \$69020 NWELL PWELL BULK DFF_X1
X$156075 \$72880 \$73156 \$73231 \$69020 NWELL PWELL BULK DFF_X1
X$156077 \$I175273 \$74068 \$73768 \$69020 NWELL PWELL BULK DFF_X1
X$156079 \$I177218 \$74487 \$74611 \$69020 NWELL PWELL BULK DFF_X1
X$156081 \$I177245 \$73499 \$74227 \$69020 NWELL PWELL BULK DFF_X1
X$156083 \$I177240 \$74620 \$74993 \$69020 NWELL PWELL BULK DFF_X1
X$156085 \$I174682 \$75238 \$75237 \$69020 NWELL PWELL BULK DFF_X1
X$156087 \$74233 \$74060 \$74236 \$69020 NWELL PWELL BULK DFF_X1
X$156089 \$75035 \$69020 \$I245546 \$74476 NWELL PWELL BULK DFF_X2
X$156092 \$70967 \$70846 \$71361 \$69020 NWELL PWELL BULK DFF_X1
X$156094 \$71729 \$72128 \$72399 \$69020 NWELL PWELL BULK DFF_X1
X$156097 \$I179043 \$72636 \$73833 \$69020 NWELL PWELL BULK DFF_X1
X$156133 S0_AXI_RID[3] \$69035 NWELL PWELL BULK BUF_X1
X$156207 \$69241 \$69237 \$69242 \$69111 NWELL PWELL BULK MUX2_X1
X$156229 S0_AXI_RDATA[5] \$69149 NWELL PWELL BULK BUF_X1
X$156276 \$69581 S2_AXI_AWVALID NWELL PWELL BULK BUF_X1
X$156281 S2_AXI_AWREADY \$70003 NWELL PWELL BULK BUF_X1
X$156346 \$I176083 \$69209 \$69772 \$69210 NWELL PWELL BULK DFF_X1
X$156352 \$I176084 \$70441 \$70968 \$69210 NWELL PWELL BULK DFF_X1
X$156354 \$I174957 \$69214 \$70115 \$69210 NWELL PWELL BULK DFF_X1
X$156357 \$I177744 \$70796 \$70795 \$69210 NWELL PWELL BULK DFF_X1
X$156362 \$I177732 \$70794 \$70792 \$69210 NWELL PWELL BULK DFF_X1
X$156365 \$I177904 \$69426 \$69431 \$69210 NWELL PWELL BULK DFF_X1
X$156369 \$I176119 \$70436 \$70623 \$69210 NWELL PWELL BULK DFF_X1
X$156371 \$I176092 \$70434 \$70626 \$69210 NWELL PWELL BULK DFF_X1
X$156373 \$I177908 \$70094 \$70097 \$69210 NWELL PWELL BULK DFF_X1
X$156375 \$73388 \$73091 \$73982 \$69210 NWELL PWELL BULK DFF_X1
X$156377 \$I177598 \$73390 \$73684 \$69210 NWELL PWELL BULK DFF_X1
X$156380 \$I177739 \$72224 \$72768 \$69210 NWELL PWELL BULK DFF_X1
X$156382 \$I177749 \$74182 \$74988 \$69210 NWELL PWELL BULK DFF_X1
X$156384 \$75000 \$74990 \$74997 \$69210 NWELL PWELL BULK DFF_X1
X$156386 \$74403 \$74404 \$74826 \$69210 NWELL PWELL BULK DFF_X1
X$156389 \$I178654 \$73396 \$74190 \$69210 NWELL PWELL BULK DFF_X1
X$156391 \$I177747 \$75014 \$75696 \$69210 NWELL PWELL BULK DFF_X1
X$156393 \$I176474 \$73093 \$73393 \$69210 NWELL PWELL BULK DFF_X1
X$156395 \$I177616 \$72549 \$72781 \$69210 NWELL PWELL BULK DFF_X1
X$156399 \$I177569 \$72047 \$71492 \$69210 NWELL PWELL BULK DFF_X1
X$156401 \$I176724 \$72548 \$72773 \$69210 NWELL PWELL BULK DFF_X1
X$156403 \$I176720 \$71680 \$72036 \$69210 NWELL PWELL BULK DFF_X1
X$156405 \$I176709 \$71842 \$72028 \$69210 NWELL PWELL BULK DFF_X1
X$156407 \$I176478 \$71670 \$71094 \$69210 NWELL PWELL BULK DFF_X1
X$156410 \$74827 \$75007 \$74999 \$69210 NWELL PWELL BULK DFF_X1
X$156413 \$74598 \$74399 \$74187 \$69210 NWELL PWELL BULK DFF_X1
X$156415 \$75708 \$76007 \$75549 \$69210 NWELL PWELL BULK DFF_X1
X$156418 \$I178577 \$72227 \$72046 \$69210 NWELL PWELL BULK DFF_X1
X$156460 \$83662 \$69217 \$84071 \$84251 NWELL PWELL BULK MUX2_X1
X$156462 \$83646 \$69217 \$83832 \$83671 NWELL PWELL BULK MUX2_X1
X$156464 \$77471 \$69217 \$77170 \$77722 NWELL PWELL BULK MUX2_X1
X$156467 \$82888 \$69217 \$82722 \$83051 NWELL PWELL BULK MUX2_X1
X$156470 \$83843 \$69217 \$83730 \$84558 NWELL PWELL BULK MUX2_X1
X$156473 \$77702 \$69217 \$77705 \$77831 NWELL PWELL BULK MUX2_X1
X$156475 \$83261 \$69217 \$83823 \$83975 NWELL PWELL BULK MUX2_X1
X$156477 \$82194 \$69217 \$81592 \$82330 NWELL PWELL BULK MUX2_X1
X$156479 \$79744 \$69217 \$79743 \$79889 NWELL PWELL BULK MUX2_X1
X$156482 \$79883 \$69217 \$79503 \$79890 NWELL PWELL BULK MUX2_X1
X$156484 \$78983 \$69217 \$78632 \$79130 NWELL PWELL BULK MUX2_X1
X$156487 \$74627 \$69217 \$74412 \$75180 NWELL PWELL BULK MUX2_X1
X$156490 \$82890 \$69217 \$82892 \$83345 NWELL PWELL BULK MUX2_X1
X$156492 \$82559 \$69217 \$83111 \$83454 NWELL PWELL BULK MUX2_X1
X$156495 \$84174 \$69217 \$82902 \$84617 NWELL PWELL BULK MUX2_X1
X$156497 \$83851 \$69217 \$84153 \$84165 NWELL PWELL BULK MUX2_X1
X$156500 \$74636 \$69217 \$74218 \$75181 NWELL PWELL BULK MUX2_X1
X$156503 \$79409 \$69217 \$80141 \$80142 NWELL PWELL BULK MUX2_X1
X$156505 \$79408 \$69217 \$80140 \$80491 NWELL PWELL BULK MUX2_X1
X$156507 \$83868 \$69217 \$83869 \$84702 NWELL PWELL BULK MUX2_X1
X$156510 \$83151 \$69217 \$83773 \$84700 NWELL PWELL BULK MUX2_X1
X$156513 \$83390 \$69217 \$84670 \$83476 NWELL PWELL BULK MUX2_X1
X$156516 \$83782 \$69217 \$83860 \$83790 NWELL PWELL BULK MUX2_X1
X$156518 \$82806 \$69217 \$82571 \$83198 NWELL PWELL BULK MUX2_X1
X$156520 \$81185 \$69217 \$81499 \$81877 NWELL PWELL BULK MUX2_X1
X$156522 \$83863 \$69217 \$82907 \$84227 NWELL PWELL BULK MUX2_X1
X$156525 \$83192 \$69217 \$83195 \$83858 NWELL PWELL BULK MUX2_X1
X$156527 \$83134 \$69217 \$83461 \$83462 NWELL PWELL BULK MUX2_X1
X$156529 \$83834 \$69217 \$83445 \$84524 NWELL PWELL BULK MUX2_X1
X$156532 \$84111 \$69217 \$83451 \$83452 NWELL PWELL BULK MUX2_X1
X$156534 \$82218 \$69217 \$82898 \$83377 NWELL PWELL BULK MUX2_X1
X$156537 \$83077 \$69217 \$83450 \$84526 NWELL PWELL BULK MUX2_X1
X$156540 \$81182 \$69217 \$81496 \$82095 NWELL PWELL BULK MUX2_X1
X$156543 \$82236 \$69217 \$82237 \$82846 NWELL PWELL BULK MUX2_X1
X$156545 \$83159 \$69217 \$82913 \$83166 NWELL PWELL BULK MUX2_X1
X$156549 \$78300 \$69217 \$78635 \$79132 NWELL PWELL BULK MUX2_X1
X$156551 \$77278 \$69217 \$77285 \$77830 NWELL PWELL BULK MUX2_X1
X$156553 \$81142 \$69217 \$81144 \$82334 NWELL PWELL BULK MUX2_X1
X$156555 \$82876 \$69217 \$82875 \$82991 NWELL PWELL BULK MUX2_X1
X$156558 \$77469 \$69217 \$77875 \$78201 NWELL PWELL BULK MUX2_X1
X$156561 \$76514 \$69217 \$76203 \$77164 NWELL PWELL BULK MUX2_X1
X$156563 \$77714 \$69217 \$77163 \$77165 NWELL PWELL BULK MUX2_X1
X$156627 \$69468 \$69227 \$69465 \$69618 NWELL PWELL BULK DFF_X1
X$156631 \$80053 \$69237 \$80423 \$80414 NWELL PWELL BULK MUX2_X1
X$156634 \$82464 \$69237 \$82221 \$82222 NWELL PWELL BULK MUX2_X1
X$156636 \$79383 \$69237 \$79287 \$78973 NWELL PWELL BULK MUX2_X1
X$156639 \$81466 \$69237 \$81171 \$82123 NWELL PWELL BULK MUX2_X1
X$156642 \$82500 \$69237 \$80862 \$82124 NWELL PWELL BULK MUX2_X1
X$156645 \$81468 \$69237 \$81775 \$81470 NWELL PWELL BULK MUX2_X1
X$156648 \$81390 \$69237 \$81737 \$81843 NWELL PWELL BULK MUX2_X1
X$156651 \$76096 \$69237 \$75447 \$75193 NWELL PWELL BULK MUX2_X1
X$156653 \$76544 \$69237 \$76547 \$77115 NWELL PWELL BULK MUX2_X1
X$156655 \$80699 \$69237 \$80116 \$79372 NWELL PWELL BULK MUX2_X1
X$156657 \$77894 \$69237 \$77624 \$77474 NWELL PWELL BULK MUX2_X1
X$156659 \$81456 \$69237 \$81457 \$80111 NWELL PWELL BULK MUX2_X1
X$156661 \$81026 \$69237 \$81028 \$80838 NWELL PWELL BULK MUX2_X1
X$156663 \$82018 \$69237 \$81683 \$82037 NWELL PWELL BULK MUX2_X1
X$156666 \$82421 \$69237 \$82742 \$82214 NWELL PWELL BULK MUX2_X1
X$156668 \$72920 \$69237 \$72586 \$72587 NWELL PWELL BULK MUX2_X1
X$156670 \$69492 \$69237 \$69494 \$69493 NWELL PWELL BULK MUX2_X1
X$156675 \$79311 \$69237 \$79697 \$79401 NWELL PWELL BULK MUX2_X1
X$156678 \$78339 \$69237 \$78959 \$79028 NWELL PWELL BULK MUX2_X1
X$156680 \$80750 \$69237 \$80128 \$80758 NWELL PWELL BULK MUX2_X1
X$156683 \$71771 \$69237 \$71778 \$71875 NWELL PWELL BULK MUX2_X1
X$156685 \$72142 \$69237 \$71871 \$72250 NWELL PWELL BULK MUX2_X1
X$156688 \$74288 \$69237 \$74295 \$74853 NWELL PWELL BULK MUX2_X1
X$156690 \$73797 \$69237 \$73114 \$72891 NWELL PWELL BULK MUX2_X1
X$156692 \$79257 \$69237 \$79652 \$79261 NWELL PWELL BULK MUX2_X1
X$156694 \$78961 \$69237 \$78680 \$78679 NWELL PWELL BULK MUX2_X1
X$156696 \$77381 \$69237 \$77184 \$76898 NWELL PWELL BULK MUX2_X1
X$156698 \$82010 \$69237 \$82405 \$82012 NWELL PWELL BULK MUX2_X1
X$156700 \$81850 \$69237 \$82228 \$81782 NWELL PWELL BULK MUX2_X1
X$156703 \$80687 \$69237 \$80693 \$80372 NWELL PWELL BULK MUX2_X1
X$156706 \$78879 \$69237 \$78534 \$78233 NWELL PWELL BULK MUX2_X1
X$156768 \$I176845 \$69265 \$69543 \$69541 NWELL PWELL BULK DFF_X1
X$156778 \$69269 \$69270 \$69517 NWELL PWELL BULK NOR2_X1
X$156780 \$69269 \$71141 \$70839 NWELL PWELL BULK NOR2_X1
X$156783 \$70839 \$69269 \$71002 \$71422 NWELL PWELL BULK AOI21_X1
X$156786 \$69269 \$69905 \$70712 NWELL PWELL BULK NOR2_X1
X$156789 \$71900 \$69269 NWELL PWELL BULK BUF_X8
X$156791 \$70712 \$69269 \$69647 \$69903 NWELL PWELL BULK AOI21_X1
X$156794 \$69269 \$71903 \$72289 NWELL PWELL BULK NOR2_X1
X$156797 \$72289 \$69269 \$72288 \$71901 NWELL PWELL BULK AOI21_X1
X$156800 \$79954 \$69269 \$79801 \$79806 NWELL PWELL BULK AOI21_X1
X$156803 \$69269 \$79949 \$79954 NWELL PWELL BULK NOR2_X1
X$156806 \$69269 \$79051 \$78718 NWELL PWELL BULK NOR2_X1
X$156809 \$78718 \$69269 \$78720 \$78861 NWELL PWELL BULK AOI21_X1
X$156812 \$69269 \$76805 \$76809 NWELL PWELL BULK NOR2_X1
X$156815 \$76809 \$69269 \$76150 \$76255 NWELL PWELL BULK AOI21_X1
X$156818 \$69269 \$79049 \$79048 NWELL PWELL BULK NOR2_X1
X$156821 \$79048 \$69269 \$79042 \$79047 NWELL PWELL BULK AOI21_X1
X$156824 \$74887 \$69269 \$73132 \$75469 NWELL PWELL BULK AOI21_X1
X$156828 \$69269 \$75087 \$74887 NWELL PWELL BULK NOR2_X1
X$156892 \$69310 S1_AXI_WID[7] NWELL PWELL BULK BUF_X1
X$156894 \$69310 \$70020 NWELL PWELL BULK BUF_X1
X$156913 \$78113 \$70862 \$77247 \$69322 NWELL PWELL BULK MUX2_X1
X$156922 \$69955 S2_AXI_WID[5] NWELL PWELL BULK BUF_X1
X$157059 S2_AXI_RDATA[25] \$69458 NWELL PWELL BULK CLKBUF_X2
X$157159 \$69536 M0_AXI_RRESP[1] NWELL PWELL BULK BUF_X1
X$157164 \$75121 \$75594 \$75773 \$69541 NWELL PWELL BULK DFF_X1
X$157167 \$I175086 \$75209 \$75499 \$69541 NWELL PWELL BULK DFF_X1
X$157170 \$75125 \$74874 \$75511 \$69541 NWELL PWELL BULK DFF_X1
X$157172 \$I176230 \$74342 \$74788 \$69541 NWELL PWELL BULK DFF_X1
X$157174 \$I178863 \$74036 \$74792 \$69541 NWELL PWELL BULK DFF_X1
X$157177 \$74771 \$74439 \$74868 \$69541 NWELL PWELL BULK DFF_X1
X$157179 \$I174263 \$75133 \$74872 \$69541 NWELL PWELL BULK DFF_X1
X$157181 \$I174593 \$70481 \$70831 \$69541 NWELL PWELL BULK DFF_X1
X$157184 \$I176779 \$70370 \$70364 \$69541 NWELL PWELL BULK DFF_X1
X$157186 \$I174613 \$70745 \$70480 \$69541 NWELL PWELL BULK DFF_X1
X$157189 \$I174505 \$69893 \$70352 \$69541 NWELL PWELL BULK DFF_X1
X$157192 \$I175004 \$69638 \$69755 \$69541 NWELL PWELL BULK DFF_X1
X$157195 \$I174918 \$69750 \$69640 \$69541 NWELL PWELL BULK DFF_X1
X$157198 \$71528 \$71027 \$71028 \$69541 NWELL PWELL BULK DFF_X1
X$157201 \$I179279 \$71456 \$71452 \$69541 NWELL PWELL BULK DFF_X1
X$157206 \$I178707 \$74871 \$75138 \$69541 NWELL PWELL BULK DFF_X1
X$157209 \$74870 \$75143 \$75503 \$69541 NWELL PWELL BULK DFF_X1
X$157212 \$I174251 \$74032 \$74357 \$69541 NWELL PWELL BULK DFF_X1
X$157214 \$I174326 \$71785 \$71891 \$69541 NWELL PWELL BULK DFF_X1
X$157217 \$I175759 \$71031 \$71127 \$69541 NWELL PWELL BULK DFF_X1
X$157220 \$72188 \$71790 \$71888 \$69541 NWELL PWELL BULK DFF_X1
X$157222 \$72902 \$69541 NWELL PWELL BULK BUF_X4
X$157224 \$71530 \$71780 \$71775 \$69541 NWELL PWELL BULK DFF_X1
X$157226 \$73958 \$73465 \$74337 \$69541 NWELL PWELL BULK DFF_X1
X$157229 \$I179260 \$72613 \$73955 \$69541 NWELL PWELL BULK DFF_X1
X$157231 \$73947 \$73045 \$73036 \$69541 NWELL PWELL BULK DFF_X1
X$157233 \$72601 \$72472 \$72478 \$69541 NWELL PWELL BULK DFF_X1
X$157235 \$73006 \$73003 \$73282 \$69541 NWELL PWELL BULK DFF_X1
X$157237 \$73899 \$73897 \$73450 \$69541 NWELL PWELL BULK DFF_X1
X$157275 \$69569 \$69568 \$69915 NWELL PWELL BULK OR2_X1
X$157281 \$69807 S2_AXI_AWID[6] NWELL PWELL BULK BUF_X1
X$157286 \$69816 S2_AXI_AWADDR[16] NWELL PWELL BULK BUF_X1
X$157291 \$72539 \$74168 \$72756 \$69581 NWELL PWELL BULK NAND3_X2
X$157294 \$69581 \$70003 \$73086 NWELL PWELL BULK NAND2_X2
X$157349 \$69795 \$69796 \$69617 \$69618 NWELL PWELL BULK DFF_X1
X$157351 \$71871 \$71757 \$71511 \$69618 NWELL PWELL BULK DFF_X1
X$157354 \$72142 \$72139 \$71869 \$69618 NWELL PWELL BULK DFF_X1
X$157357 \$I178284 \$70818 \$71048 \$69618 NWELL PWELL BULK DFF_X1
X$157359 \$73797 \$73113 \$73791 \$69618 NWELL PWELL BULK DFF_X1
X$157362 \$72864 \$73335 \$73336 \$69618 NWELL PWELL BULK DFF_X1
X$157365 \$73114 \$73803 \$73799 \$69618 NWELL PWELL BULK DFF_X1
X$157368 \$I178563 \$71388 \$71745 \$69618 NWELL PWELL BULK DFF_X1
X$157371 \$I178076 \$74424 \$75079 \$69618 NWELL PWELL BULK DFF_X1
X$157374 \$75569 \$75776 \$76058 \$69618 NWELL PWELL BULK DFF_X1
X$157377 \$I178376 \$74002 \$74268 \$69618 NWELL PWELL BULK DFF_X1
X$157379 \$73770 \$73421 \$73332 \$69618 NWELL PWELL BULK DFF_X1
X$157381 \$72853 \$72467 \$72469 \$69618 NWELL PWELL BULK DFF_X1
X$157383 \$73424 \$73425 \$73767 \$69618 NWELL PWELL BULK DFF_X1
X$157386 \$73428 \$73786 \$73775 \$69618 NWELL PWELL BULK DFF_X1
X$157388 \$I177757 \$71507 \$72121 \$69618 NWELL PWELL BULK DFF_X1
X$157390 \$71865 \$71864 \$72476 \$69618 NWELL PWELL BULK DFF_X1
X$157394 \$71863 \$71739 \$72115 \$69618 NWELL PWELL BULK DFF_X1
X$157399 \$69851 \$70694 \$70455 \$69618 NWELL PWELL BULK DFF_X1
X$157401 \$71018 \$71346 \$70687 \$69618 NWELL PWELL BULK DFF_X1
X$157403 \$70200 \$70195 \$70192 \$69618 NWELL PWELL BULK DFF_X1
X$157405 \$I177618 \$70815 \$71034 \$69618 NWELL PWELL BULK DFF_X1
X$157409 \$70701 \$70183 \$70181 \$69618 NWELL PWELL BULK DFF_X1
X$157411 \$70814 \$71365 \$71362 \$69618 NWELL PWELL BULK DFF_X1
X$157414 \$75404 \$75186 \$75407 \$69618 NWELL PWELL BULK DFF_X1
X$157416 \$74422 \$74421 \$74257 \$69618 NWELL PWELL BULK DFF_X1
X$157418 \$71354 \$71114 \$71858 \$69618 NWELL PWELL BULK DFF_X1
X$157420 \$71115 \$72100 \$72461 \$69618 NWELL PWELL BULK DFF_X1
X$157447 S1_AXI_RDATA[5] \$69621 NWELL PWELL BULK CLKBUF_X2
X$157494 \$72444 \$71900 \$69643 \$71898 NWELL PWELL BULK AOI21_X1
X$157505 \$71011 \$70387 \$69645 \$71756 NWELL PWELL BULK MUX2_X1
X$157533 M0_AXI_WDATA[12] \$69658 NWELL PWELL BULK CLKBUF_X2
X$157547 M0_AXI_WDATA[28] \$69665 NWELL PWELL BULK BUF_X1
X$157562 \$69671 \$71156 \$71923 \$72314 NWELL PWELL BULK OAI21_X1
X$157564 \$69671 \$70514 \$71318 \$71164 NWELL PWELL BULK OAI21_X1
X$157566 \$70521 \$69671 \$72077 \$71165 NWELL PWELL BULK OAI21_X1
X$157569 \$69671 \$71173 \$72082 \$72829 NWELL PWELL BULK OAI21_X1
X$157604 M0_AXI_WID[3] \$69690 NWELL PWELL BULK BUF_X1
X$157617 \$70020 S1_AXI_WID[3] NWELL PWELL BULK BUF_X1
X$157622 \$72671 \$70862 \$73645 \$69699 NWELL PWELL BULK MUX2_X1
X$157659 \$69732 S1_AXI_WSTRB[0] NWELL PWELL BULK BUF_X1
X$157692 \$69745 M1_AXI_RDATA[5] NWELL PWELL BULK BUF_X1
X$157740 \$69765 M0_AXI_RDATA[25] NWELL PWELL BULK BUF_X1
X$157769 \$69780 M0_AXI_RDATA[3] NWELL PWELL BULK BUF_X1
X$157804 \$71199 S2_AXI_AWADDR[2] NWELL PWELL BULK BUF_X1
X$157811 \$69815 S2_AXI_AWADDR[10] NWELL PWELL BULK BUF_X1
X$157816 \$70554 S2_AXI_AWADDR[17] NWELL PWELL BULK BUF_X1
X$157821 \$70568 S2_AXI_AWADDR[11] NWELL PWELL BULK BUF_X1
X$157827 \$69806 \$69807 NWELL PWELL BULK BUF_X1
X$157890 \$69841 \$70441 \$70970 \$70442 NWELL PWELL BULK HA_X1
X$157893 \$70803 \$69841 \$70645 NWELL PWELL BULK NAND2_X1
X$157992 \$69905 \$70387 \$69907 \$69908 NWELL PWELL BULK MUX2_X1
X$158015 \$70291 \$70296 \$69912 NWELL PWELL BULK OR2_X1
X$158069 \$70521 \$69944 \$74074 \$74183 NWELL PWELL BULK OAI21_X1
X$158072 \$69944 \$70514 \$75246 \$75333 NWELL PWELL BULK OAI21_X1
X$158074 \$69944 \$71156 \$76044 \$75916 NWELL PWELL BULK OAI21_X1
X$158076 \$69944 \$71173 \$75917 \$75247 NWELL PWELL BULK OAI21_X1
X$158089 M0_AXI_WDATA[0] \$69949 NWELL PWELL BULK BUF_X1
X$158102 \$75943 \$70862 \$76624 \$69955 NWELL PWELL BULK MUX2_X1
X$158117 \$70872 S2_AXI_WDATA[19] NWELL PWELL BULK BUF_X1
X$158146 \$78092 \$70862 \$78432 \$69986 NWELL PWELL BULK MUX2_X1
X$158155 \$74940 \$70862 \$74934 \$69987 NWELL PWELL BULK MUX2_X1
X$158262 \$70143 M0_AXI_RID[0] NWELL PWELL BULK BUF_X1
X$158339 S0_AXI_RDATA[8] \$70217 NWELL PWELL BULK BUF_X1
X$158358 \$70224 S1_AXI_WDATA[28] NWELL PWELL BULK BUF_X1
X$158367 S0_AXI_RDATA[25] \$70244 NWELL PWELL BULK BUF_X1
X$158474 \$70346 M0_AXI_RDATA[5] NWELL PWELL BULK BUF_X1
X$158487 \$70350 M2_AXI_RDATA[5] NWELL PWELL BULK BUF_X1
X$158516 \$70376 M1_AXI_RDATA[8] NWELL PWELL BULK BUF_X1
X$158527 \$83114 \$70387 \$83493 \$83709 NWELL PWELL BULK MUX2_X1
X$158529 \$82254 \$70387 \$81887 \$82788 NWELL PWELL BULK MUX2_X1
X$158531 \$83486 \$70387 \$83488 \$84139 NWELL PWELL BULK MUX2_X1
X$158533 \$81200 \$70387 \$81516 \$81674 NWELL PWELL BULK MUX2_X1
X$158535 \$82251 \$70387 \$82031 \$82418 NWELL PWELL BULK MUX2_X1
X$158537 \$80153 \$70387 \$80506 \$80731 NWELL PWELL BULK MUX2_X1
X$158540 \$78349 \$70387 \$78894 \$78702 NWELL PWELL BULK MUX2_X1
X$158543 \$77764 \$70387 \$77762 \$77966 NWELL PWELL BULK MUX2_X1
X$158545 \$78698 \$70387 \$78345 \$78701 NWELL PWELL BULK MUX2_X1
X$158548 \$73139 \$70387 \$73044 \$73923 NWELL PWELL BULK MUX2_X1
X$158550 \$74453 \$70387 \$75098 \$75482 NWELL PWELL BULK MUX2_X1
X$158553 \$71903 \$70387 \$72620 \$72442 NWELL PWELL BULK MUX2_X1
X$158556 \$73256 \$70387 \$73019 \$72624 NWELL PWELL BULK MUX2_X1
X$158559 \$77946 \$70387 \$77507 \$78230 NWELL PWELL BULK MUX2_X1
X$158561 \$74737 \$70387 \$74044 \$75081 NWELL PWELL BULK MUX2_X1
X$158564 \$75087 \$70387 \$74891 \$74892 NWELL PWELL BULK MUX2_X1
X$158566 \$76151 \$70387 \$75749 \$75886 NWELL PWELL BULK MUX2_X1
X$158568 \$80147 \$70387 \$80889 \$81019 NWELL PWELL BULK MUX2_X1
X$158570 \$80496 \$70387 \$80498 \$81045 NWELL PWELL BULK MUX2_X1
X$158573 \$82924 \$70387 \$82590 \$82827 NWELL PWELL BULK MUX2_X1
X$158580 \$71760 \$70387 \$70482 \$71536 NWELL PWELL BULK MUX2_X1
X$158582 \$71141 \$70387 \$71413 \$73021 NWELL PWELL BULK MUX2_X1
X$158584 \$81189 \$70387 \$81191 \$81192 NWELL PWELL BULK MUX2_X1
X$158587 \$82072 \$70387 \$82070 \$82447 NWELL PWELL BULK MUX2_X1
X$158589 \$80802 \$70387 \$80794 \$80880 NWELL PWELL BULK MUX2_X1
X$158591 \$83879 \$70387 \$83207 \$84170 NWELL PWELL BULK MUX2_X1
X$158594 \$82585 \$70387 \$82246 \$82586 NWELL PWELL BULK MUX2_X1
X$158596 \$82579 \$70387 \$82865 \$82917 NWELL PWELL BULK MUX2_X1
X$158598 \$83875 \$70387 \$83205 \$84741 NWELL PWELL BULK MUX2_X1
X$158601 \$83497 \$70387 \$83495 \$84112 NWELL PWELL BULK MUX2_X1
X$158603 \$79051 \$70387 \$79422 \$79424 NWELL PWELL BULK MUX2_X1
X$158605 \$79949 \$70387 \$80156 \$80158 NWELL PWELL BULK MUX2_X1
X$158607 \$78560 \$70387 \$79055 \$79574 NWELL PWELL BULK MUX2_X1
X$158609 \$79430 \$70387 \$80511 \$80309 NWELL PWELL BULK MUX2_X1
X$158611 \$76805 \$70387 \$75893 \$76927 NWELL PWELL BULK MUX2_X1
X$158614 \$77066 \$70387 \$76928 \$77215 NWELL PWELL BULK MUX2_X1
X$158616 \$81198 \$70387 \$80893 \$81693 NWELL PWELL BULK MUX2_X1
X$158618 \$77499 \$70387 \$77669 \$77503 NWELL PWELL BULK MUX2_X1
X$158620 \$78355 \$70387 \$78228 \$78357 NWELL PWELL BULK MUX2_X1
X$158622 \$78713 \$70387 \$78712 \$79265 NWELL PWELL BULK MUX2_X1
X$158624 \$79417 \$70387 \$79613 \$79418 NWELL PWELL BULK MUX2_X1
X$158626 \$79049 \$70387 \$79420 \$79969 NWELL PWELL BULK MUX2_X1
X$158629 \$79412 \$70387 \$79040 \$79413 NWELL PWELL BULK MUX2_X1
X$158632 \$76253 \$70387 \$76814 \$76573 NWELL PWELL BULK MUX2_X1
X$158635 \$76458 \$70387 \$76823 \$76250 NWELL PWELL BULK MUX2_X1
X$158637 \$74042 \$70387 \$74456 \$75480 NWELL PWELL BULK MUX2_X1
X$158640 \$76239 \$70387 \$76565 \$76472 NWELL PWELL BULK MUX2_X1
X$158642 \$76569 \$70387 \$75881 \$76465 NWELL PWELL BULK MUX2_X1
X$158644 \$77209 \$70387 \$77211 \$77397 NWELL PWELL BULK MUX2_X1
X$158715 \$70390 M2_AXI_RRESP[1] NWELL PWELL BULK BUF_X1
X$158724 \$70544 S2_AXI_AWADDR[0] NWELL PWELL BULK BUF_X1
X$158729 \$71194 S2_AXI_AWID[4] NWELL PWELL BULK BUF_X1
X$158734 \$70617 S2_AXI_AWADDR[13] NWELL PWELL BULK BUF_X1
X$158793 \$70803 \$70441 \$70973 NWELL PWELL BULK NAND2_X1
X$158801 \$70803 \$70804 \$70445 NWELL PWELL BULK NAND2_X1
X$158807 \$70450 \$70665 \$70674 \$70670 \$70447 NWELL PWELL BULK FA_X1
X$158810 \$71000 \$70449 \$70447 \$70661 NWELL PWELL BULK MUX2_X1
X$158816 \$70449 \$70674 \$70675 NWELL PWELL BULK NOR2_X1
X$158818 \$70675 \$70450 \$70449 \$70452 NWELL PWELL BULK AOI21_X1
X$158821 \$70803 \$72228 \$70449 \$I241608 NWELL PWELL BULK HA_X1
X$158880 M0_AXI_WDATA[31] \$70502 NWELL PWELL BULK BUF_X1
X$158912 \$70514 \$70860 \$71178 NWELL PWELL BULK NAND2_X1
X$158916 \$70514 \$73184 \$72716 NWELL PWELL BULK NAND2_X1
X$158921 \$70514 \$73180 \$73179 NWELL PWELL BULK NAND2_X1
X$158925 \$70514 \$72328 \$71949 NWELL PWELL BULK NAND2_X1
X$158927 \$70514 \$75930 \$76296 NWELL PWELL BULK NAND2_X1
X$158930 \$70514 \$75999 \$76305 NWELL PWELL BULK NAND2_X1
X$158932 \$70514 \$70856 \$71318 NWELL PWELL BULK NAND2_X1
X$158934 \$70514 \$70527 \$70865 NWELL PWELL BULK NAND2_X1
X$158937 \$70514 \$70869 \$70531 NWELL PWELL BULK NAND2_X1
X$158941 \$70514 \$71931 \$71559 NWELL PWELL BULK NAND2_X1
X$158944 \$70514 \$72815 \$73163 NWELL PWELL BULK NAND2_X1
X$158948 \$70514 \$72668 \$73656 NWELL PWELL BULK NAND2_X1
X$158951 \$70514 \$76291 \$76599 NWELL PWELL BULK NAND2_X1
X$158956 \$70514 \$73511 \$73510 NWELL PWELL BULK NAND2_X1
X$158959 \$70514 \$75327 \$75246 NWELL PWELL BULK NAND2_X1
X$158962 \$70514 \$70516 \$70515 NWELL PWELL BULK NAND2_X1
X$158964 \$70514 \$82960 \$82625 NWELL PWELL BULK NAND2_X1
X$158967 \$70514 \$82619 \$82984 NWELL PWELL BULK NAND2_X1
X$158969 \$70514 \$81546 \$81224 NWELL PWELL BULK NAND2_X1
X$158974 \$70514 \$83523 \$83229 NWELL PWELL BULK NAND2_X1
X$158977 \$70514 \$83521 \$83227 NWELL PWELL BULK NAND2_X1
X$158982 \$70959 \$70514 \$82940 \$83023 NWELL PWELL BULK OAI21_X1
X$158985 \$70514 \$83225 \$82940 NWELL PWELL BULK NAND2_X1
X$158989 \$70514 \$83222 \$83033 NWELL PWELL BULK NAND2_X1
X$158993 \$70514 \$78759 \$79085 NWELL PWELL BULK NAND2_X1
X$158995 \$70514 \$78094 \$78413 NWELL PWELL BULK NAND2_X1
X$159000 \$70514 \$77796 \$77795 NWELL PWELL BULK NAND2_X1
X$159004 \$70514 \$75241 \$75339 NWELL PWELL BULK NAND2_X1
X$159009 \$70514 \$77240 \$77238 NWELL PWELL BULK NAND2_X1
X$159016 \$70514 \$73810 \$73493 NWELL PWELL BULK NAND2_X1
X$159019 \$70514 \$73499 \$73776 NWELL PWELL BULK NAND2_X1
X$159028 \$70514 \$80599 \$80948 NWELL PWELL BULK NAND2_X1
X$159032 \$70514 \$80184 \$80239 NWELL PWELL BULK NAND2_X1
X$159037 \$70514 \$78379 \$78474 NWELL PWELL BULK NAND2_X1
X$159040 \$70514 \$79819 \$80252 NWELL PWELL BULK NAND2_X1
X$159045 \$70514 \$81968 \$81973 NWELL PWELL BULK NAND2_X1
X$159047 \$70514 \$81936 \$81221 NWELL PWELL BULK NAND2_X1
X$159050 \$70514 \$77006 \$77235 NWELL PWELL BULK NAND2_X1
X$159054 \$70514 \$79834 \$79833 NWELL PWELL BULK NAND2_X1
X$159057 \$70514 \$77529 \$77528 NWELL PWELL BULK NAND2_X1
X$159060 \$70514 \$78079 \$78188 NWELL PWELL BULK NAND2_X1
X$159064 \$70514 \$77538 \$77786 NWELL PWELL BULK NAND2_X1
X$159136 \$70516 \$70870 \$70522 \$70913 NWELL PWELL BULK MUX2_X1
X$159144 \$70521 \$70522 \$70520 NWELL PWELL BULK NAND2_X1
X$159150 \$70521 \$73529 \$73527 NWELL PWELL BULK NAND2_X1
X$159153 \$70521 \$73178 \$72750 NWELL PWELL BULK NAND2_X1
X$159156 \$70521 \$72680 \$73189 NWELL PWELL BULK NAND2_X1
X$159159 \$70521 \$70547 \$71207 NWELL PWELL BULK NAND2_X1
X$159161 \$70521 \$71183 \$70891 NWELL PWELL BULK NAND2_X1
X$159163 \$70521 \$75632 \$76343 NWELL PWELL BULK NAND2_X1
X$159166 \$70521 \$75258 \$75295 NWELL PWELL BULK NAND2_X1
X$159173 \$70521 \$70524 \$70578 NWELL PWELL BULK NAND2_X1
X$159180 \$70521 \$72669 \$73174 NWELL PWELL BULK NAND2_X1
X$159184 \$70521 \$71934 \$71561 NWELL PWELL BULK NAND2_X1
X$159192 \$70521 \$74492 \$74074 NWELL PWELL BULK NAND2_X1
X$159194 \$70521 \$72666 \$72322 NWELL PWELL BULK NAND2_X1
X$159201 \$70521 \$83234 \$82989 NWELL PWELL BULK NAND2_X1
X$159208 \$70521 \$83545 \$83546 NWELL PWELL BULK NAND2_X1
X$159213 \$70521 \$81222 \$81540 NWELL PWELL BULK NAND2_X1
X$159216 \$70521 \$81226 \$81572 NWELL PWELL BULK NAND2_X1
X$159219 \$70521 \$77801 \$78136 NWELL PWELL BULK NAND2_X1
X$159221 \$70521 \$82289 \$82653 NWELL PWELL BULK NAND2_X1
X$159224 \$70521 \$83903 \$83962 NWELL PWELL BULK NAND2_X1
X$159226 \$70521 \$70959 \$83962 \$83598 NWELL PWELL BULK OAI21_X1
X$159228 \$70521 \$83901 \$84284 NWELL PWELL BULK NAND2_X1
X$159235 \$70521 \$83904 \$83944 NWELL PWELL BULK NAND2_X1
X$159239 \$70521 \$79088 \$79087 NWELL PWELL BULK NAND2_X1
X$159244 \$70521 \$78091 \$78089 NWELL PWELL BULK NAND2_X1
X$159249 \$70521 \$76292 \$76600 NWELL PWELL BULK NAND2_X1
X$159252 \$70521 \$72659 \$72055 NWELL PWELL BULK NAND2_X1
X$159255 \$70521 \$71168 \$72077 NWELL PWELL BULK NAND2_X1
X$159262 \$70521 \$76594 \$75914 NWELL PWELL BULK NAND2_X1
X$159266 \$70521 \$75244 \$75623 NWELL PWELL BULK NAND2_X1
X$159269 \$70521 \$72641 \$71913 NWELL PWELL BULK NAND2_X1
X$159274 \$70521 \$74620 \$74484 NWELL PWELL BULK NAND2_X1
X$159277 \$70521 \$80185 \$80233 NWELL PWELL BULK NAND2_X1
X$159281 \$70521 \$78373 \$78372 NWELL PWELL BULK NAND2_X1
X$159286 \$70521 \$78458 \$78460 NWELL PWELL BULK NAND2_X1
X$159288 \$70521 \$79827 \$79824 NWELL PWELL BULK NAND2_X1
X$159293 \$70521 \$80243 \$80180 NWELL PWELL BULK NAND2_X1
X$159297 \$70521 \$81216 \$81284 NWELL PWELL BULK NAND2_X1
X$159301 \$70521 \$79839 \$79838 NWELL PWELL BULK NAND2_X1
X$159303 \$70521 \$78171 \$78082 NWELL PWELL BULK NAND2_X1
X$159308 \$70521 \$77231 \$77312 NWELL PWELL BULK NAND2_X1
X$159313 \$70521 \$77789 \$77589 NWELL PWELL BULK NAND2_X1
X$159409 \$70860 \$70870 \$70524 \$70861 NWELL PWELL BULK MUX2_X1
X$159415 \$70527 \$70870 \$71183 \$70868 NWELL PWELL BULK MUX2_X1
X$159421 \$I178464 \$70869 \$70530 \$71179 NWELL PWELL BULK DFF_X1
X$159431 \$70869 \$70870 \$70547 \$70879 NWELL PWELL BULK MUX2_X1
X$159519 \$70796 \$70641 \$70962 NWELL PWELL BULK XOR2_X1
X$159550 \$71005 \$70665 \$71008 NWELL PWELL BULK XOR2_X1
X$159556 \$71005 \$70670 NWELL PWELL BULK INV_X1
X$159603 \$70708 M1_AXI_RDATA[25] NWELL PWELL BULK BUF_X1
X$159645 M2_AXI_AWADDR[8] \$72204 NWELL PWELL BULK BUF_X1
X$159691 \$70803 \$72047 \$71683 NWELL PWELL BULK NAND2_X1
X$159695 \$70803 \$70987 \$71314 NWELL PWELL BULK NAND2_X1
X$159700 \$70804 \$70987 \$70803 \$71495 NWELL PWELL BULK NOR3_X4
X$159710 \$70804 \$72231 \$72437 NWELL PWELL BULK XNOR2_X1
X$159723 \$70809 \$71712 \$71500 \$71707 NWELL PWELL BULK MUX2_X1
X$159728 \$72825 \$73308 \$72826 \$70810 NWELL PWELL BULK DFF_X1
X$159730 \$I176448 \$74218 \$73734 \$70810 NWELL PWELL BULK DFF_X1
X$159732 \$73749 \$73411 \$73737 \$70810 NWELL PWELL BULK DFF_X1
X$159734 \$73729 \$73406 \$73293 \$70810 NWELL PWELL BULK DFF_X1
X$159736 \$71855 \$72817 \$72808 \$70810 NWELL PWELL BULK DFF_X1
X$159738 \$75357 \$75038 \$75353 \$70810 NWELL PWELL BULK DFF_X1
X$159740 \$75183 \$76037 \$75738 \$70810 NWELL PWELL BULK DFF_X1
X$159742 \$74193 \$72229 \$73399 \$70810 NWELL PWELL BULK DFF_X1
X$159745 \$74409 \$75023 \$75022 \$70810 NWELL PWELL BULK DFF_X1
X$159748 \$73987 \$74199 \$74407 \$70810 NWELL PWELL BULK DFF_X1
X$159751 \$75554 \$75555 \$75711 \$70810 NWELL PWELL BULK DFF_X1
X$159754 \$74406 \$74831 \$75332 \$70810 NWELL PWELL BULK DFF_X1
X$159756 \$I177780 \$74412 \$75030 \$70810 NWELL PWELL BULK DFF_X1
X$159759 \$I176445 \$74627 \$74209 \$70810 NWELL PWELL BULK DFF_X1
X$159763 \$I176571 \$74636 \$74222 \$70810 NWELL PWELL BULK DFF_X1
X$159766 \$76020 \$75723 \$75837 \$70810 NWELL PWELL BULK DFF_X1
X$159769 \$71347 \$70811 \$71719 \$70810 NWELL PWELL BULK DFF_X1
X$159771 \$I176701 \$75393 \$75395 \$70810 NWELL PWELL BULK DFF_X1
X$159773 \$I176498 \$74420 \$74418 \$70810 NWELL PWELL BULK DFF_X1
X$159776 \$72565 \$72841 \$72238 \$70810 NWELL PWELL BULK DFF_X1
X$159779 \$72460 \$72563 \$72834 \$70810 NWELL PWELL BULK DFF_X1
X$159782 \$74664 \$74660 \$74661 \$70810 NWELL PWELL BULK DFF_X1
X$159785 \$73417 \$73415 \$73756 \$70810 NWELL PWELL BULK DFF_X1
X$159787 \$72560 \$72833 \$72827 \$70810 NWELL PWELL BULK DFF_X1
X$159790 \$I177599 \$75564 \$75753 \$70810 NWELL PWELL BULK DFF_X1
X$159792 \$73412 \$74643 \$74644 \$70810 NWELL PWELL BULK DFF_X1
X$159795 \$75050 \$75046 \$75048 \$70810 NWELL PWELL BULK DFF_X1
X$159798 \$75063 \$75383 \$75059 \$70810 NWELL PWELL BULK DFF_X1
X$159800 \$74842 \$75365 \$75364 \$70810 NWELL PWELL BULK DFF_X1
X$159802 \$73416 \$73993 \$74645 \$70810 NWELL PWELL BULK DFF_X1
X$159859 \$71124 \$70824 \$71429 \$71123 NWELL PWELL BULK DFF_X1
X$159885 \$70856 \$70870 \$71168 \$71169 NWELL PWELL BULK MUX2_X1
X$159887 \$71940 \$70870 \$71566 \$70858 NWELL PWELL BULK MUX2_X1
X$159904 \$76947 \$70862 \$76595 \$77304 NWELL PWELL BULK MUX2_X1
X$159908 \$83526 \$70862 \$82617 \$83906 NWELL PWELL BULK MUX2_X1
X$159911 \$83519 \$70862 \$83520 \$84352 NWELL PWELL BULK MUX2_X1
X$159913 \$83235 \$70862 \$83528 \$84292 NWELL PWELL BULK MUX2_X1
X$159916 \$82953 \$70862 \$82628 \$84290 NWELL PWELL BULK MUX2_X1
X$159918 \$81931 \$70862 \$80911 \$82279 NWELL PWELL BULK MUX2_X1
X$159921 \$81254 \$70862 \$81245 \$81910 NWELL PWELL BULK MUX2_X1
X$159924 \$83223 \$70862 \$82271 \$83265 NWELL PWELL BULK MUX2_X1
X$159926 \$74917 \$70862 \$74985 \$77008 NWELL PWELL BULK MUX2_X1
X$159933 \$79821 \$70862 \$79444 \$79893 NWELL PWELL BULK MUX2_X1
X$159941 \$80535 \$70862 \$79077 \$80602 NWELL PWELL BULK MUX2_X1
X$159954 \$83565 \$70862 \$82941 \$83228 NWELL PWELL BULK MUX2_X1
X$159956 \$78756 \$70862 \$78099 \$70872 NWELL PWELL BULK MUX2_X1
X$159958 \$75245 \$70862 \$75625 \$75626 NWELL PWELL BULK MUX2_X1
X$159961 \$75401 \$71552 \$I245535 \$70862 NWELL PWELL BULK DFF_X2
X$159964 \$80596 \$70862 \$81901 \$81902 NWELL PWELL BULK MUX2_X1
X$159966 \$79082 \$70862 \$79829 \$79122 NWELL PWELL BULK MUX2_X1
X$159968 \$78735 \$70862 \$79154 \$78820 NWELL PWELL BULK MUX2_X1
X$159970 \$81529 \$70862 \$81965 \$83263 NWELL PWELL BULK MUX2_X1
X$159972 \$78447 \$70862 \$78385 \$78450 NWELL PWELL BULK MUX2_X1
X$159974 \$79837 \$70862 \$80194 \$80546 NWELL PWELL BULK MUX2_X1
X$159976 \$77530 \$70862 \$77785 \$77848 NWELL PWELL BULK MUX2_X1
X$159978 \$77232 \$70862 \$77539 \$78185 NWELL PWELL BULK MUX2_X1
X$160038 \$73808 \$70862 \$73497 \$75358 NWELL PWELL BULK MUX2_X1
X$160044 \$I174845 \$71183 \$70864 \$71179 NWELL PWELL BULK DFF_X1
X$160056 \$72328 \$70870 \$72680 \$72329 NWELL PWELL BULK MUX2_X1
X$160058 \$71608 \$70870 \$71573 \$71603 NWELL PWELL BULK MUX2_X1
X$160061 \$71205 \$70870 \$71577 \$71196 NWELL PWELL BULK MUX2_X1
X$160064 \$77240 \$70870 \$78171 \$78447 NWELL PWELL BULK MUX2_X1
X$160067 \$77792 \$70870 \$78087 \$78385 NWELL PWELL BULK MUX2_X1
X$160070 \$79834 \$70870 \$79839 \$79837 NWELL PWELL BULK MUX2_X1
X$160072 \$76287 \$70870 \$76288 \$76595 NWELL PWELL BULK MUX2_X1
X$160075 \$72668 \$70870 \$72669 \$72671 NWELL PWELL BULK MUX2_X1
X$160077 \$73511 \$70870 \$72666 \$73517 NWELL PWELL BULK MUX2_X1
X$160080 \$75327 \$70870 \$74492 \$74964 NWELL PWELL BULK MUX2_X1
X$160083 \$71931 \$70870 \$71934 \$72032 NWELL PWELL BULK MUX2_X1
X$160085 \$72815 \$70870 \$72659 \$72814 NWELL PWELL BULK MUX2_X1
X$160087 \$76291 \$70870 \$76292 \$76293 NWELL PWELL BULK MUX2_X1
X$160089 \$73697 \$70870 \$73516 \$73173 NWELL PWELL BULK MUX2_X1
X$160092 \$74592 \$70870 \$74588 \$75625 NWELL PWELL BULK MUX2_X1
X$160095 \$74500 \$70870 \$75261 \$73531 NWELL PWELL BULK MUX2_X1
X$160098 \$74109 \$70870 \$74927 \$73524 NWELL PWELL BULK MUX2_X1
X$160100 \$75269 \$70870 \$74506 \$74934 NWELL PWELL BULK MUX2_X1
X$160103 \$74931 \$70870 \$74503 \$74940 NWELL PWELL BULK MUX2_X1
X$160106 \$78749 \$70870 \$78751 \$78432 NWELL PWELL BULK MUX2_X1
X$160111 \$71925 \$70870 \$72073 \$72066 NWELL PWELL BULK MUX2_X1
X$160113 \$71568 \$70870 \$72002 \$71570 NWELL PWELL BULK MUX2_X1
X$160116 \$78094 \$70870 \$77801 \$78113 NWELL PWELL BULK MUX2_X1
X$160119 \$78398 \$70870 \$78098 \$78099 NWELL PWELL BULK MUX2_X1
X$160122 \$77796 \$70870 \$78091 \$78092 NWELL PWELL BULK MUX2_X1
X$160125 \$76959 \$70870 \$76968 \$76638 NWELL PWELL BULK MUX2_X1
X$160128 \$75634 \$70870 \$76308 \$75943 NWELL PWELL BULK MUX2_X1
X$160130 \$73180 \$70870 \$73178 \$73181 NWELL PWELL BULK MUX2_X1
X$160133 \$73533 \$70870 \$73543 \$73190 NWELL PWELL BULK MUX2_X1
X$160136 \$73184 \$70870 \$73529 \$73530 NWELL PWELL BULK MUX2_X1
X$160139 \$75930 \$70870 \$75258 \$76371 NWELL PWELL BULK MUX2_X1
X$160142 \$75999 \$70870 \$75632 \$75934 NWELL PWELL BULK MUX2_X1
X$160147 \$74073 \$70870 \$73506 \$73169 NWELL PWELL BULK MUX2_X1
X$160149 \$73520 \$70870 \$74129 \$73645 NWELL PWELL BULK MUX2_X1
X$160151 \$75628 \$70870 \$75248 \$75630 NWELL PWELL BULK MUX2_X1
X$160154 \$75252 \$70870 \$75631 \$75651 NWELL PWELL BULK MUX2_X1
X$160157 \$72027 \$70870 \$71637 \$71935 NWELL PWELL BULK MUX2_X1
X$160160 \$77245 \$70870 \$77244 \$77247 NWELL PWELL BULK MUX2_X1
X$160163 \$76317 \$70870 \$76610 \$76624 NWELL PWELL BULK MUX2_X1
X$160165 \$78759 \$70870 \$79088 \$78756 NWELL PWELL BULK MUX2_X1
X$160167 \$76604 \$70870 \$76956 \$76299 NWELL PWELL BULK MUX2_X1
X$160169 \$75241 \$70870 \$75244 \$75245 NWELL PWELL BULK MUX2_X1
X$160172 \$77006 \$70870 \$76594 \$76947 NWELL PWELL BULK MUX2_X1
X$160174 \$73496 \$70870 NWELL PWELL BULK BUF_X16
X$160177 \$78742 \$70870 \$78747 \$80194 NWELL PWELL BULK MUX2_X1
X$160301 \$70959 \$71173 \$83007 \$82724 NWELL PWELL BULK OAI21_X1
X$160304 \$70959 \$71156 \$81959 \$82331 NWELL PWELL BULK OAI21_X1
X$160309 \$70961 S1_AXI_WSTRB[1] NWELL PWELL BULK BUF_X1
X$160354 \$70987 \$71104 NWELL PWELL BULK INV_X2
X$160363 \$70987 \$73097 \$72798 NWELL PWELL BULK XNOR2_X1
X$160369 \$70991 M2_AXI_RDATA[25] NWELL PWELL BULK BUF_X1
X$160452 M2_AXI_AWADDR[4] \$72521 NWELL PWELL BULK BUF_X1
X$160459 M2_AXI_AWADDR[27] \$71595 NWELL PWELL BULK BUF_X1
X$160473 \$I175461 \$71070 \$72525 \$71474 NWELL PWELL BULK DFF_X1
X$160477 \$I178386 \$71071 \$71610 \$71474 NWELL PWELL BULK DFF_X1
X$160481 \$I178446 \$71074 \$71614 \$71474 NWELL PWELL BULK DFF_X1
X$160507 \$71670 \$71841 \$71489 \$71094 NWELL PWELL BULK MUX2_X1
X$160521 \$71111 \$72080 \$71499 \$72451 NWELL PWELL BULK MUX2_X1
X$160529 S1_AXI_RDATA[4] \$71121 NWELL PWELL BULK BUF_X1
X$160542 \$73856 \$73853 \$74305 \$71123 NWELL PWELL BULK DFF_X1
X$160544 \$I178441 \$72930 \$73121 \$71123 NWELL PWELL BULK DFF_X1
X$160546 \$I175399 \$72257 \$72510 \$71123 NWELL PWELL BULK DFF_X1
X$160549 \$74749 \$74747 \$75118 \$71123 NWELL PWELL BULK DFF_X1
X$160551 \$74434 \$74321 \$74314 \$71123 NWELL PWELL BULK DFF_X1
X$160556 \$I175389 \$71807 \$71808 \$71123 NWELL PWELL BULK DFF_X1
X$160559 \$71878 \$71520 \$71794 \$71123 NWELL PWELL BULK DFF_X1
X$160563 \$72961 \$72970 \$73286 \$71123 NWELL PWELL BULK DFF_X1
X$160565 \$73868 \$73874 \$73863 \$71123 NWELL PWELL BULK DFF_X1
X$160567 \$72962 \$73127 \$72959 \$71123 NWELL PWELL BULK DFF_X1
X$160569 \$74865 \$75791 \$75795 \$71123 NWELL PWELL BULK DFF_X1
X$160571 \$74349 \$73895 \$74341 \$71123 NWELL PWELL BULK DFF_X1
X$160574 \$75863 \$75802 \$75466 \$71123 NWELL PWELL BULK DFF_X1
X$160577 \$75592 \$75782 \$76144 \$71123 NWELL PWELL BULK DFF_X1
X$160579 \$75200 \$75470 \$75475 \$71123 NWELL PWELL BULK DFF_X1
X$160582 \$74019 \$74333 \$74334 \$71123 NWELL PWELL BULK DFF_X1
X$160585 \$75146 \$75493 \$75202 \$71123 NWELL PWELL BULK DFF_X1
X$160587 \$71778 \$72158 \$72513 \$71123 NWELL PWELL BULK DFF_X1
X$160589 \$72920 \$72254 \$72912 \$71123 NWELL PWELL BULK DFF_X1
X$160592 \$72586 \$73303 \$73304 \$71123 NWELL PWELL BULK DFF_X1
X$160595 \$73854 \$73441 \$73847 \$71123 NWELL PWELL BULK DFF_X1
X$160597 \$76436 \$76438 \$76072 \$71123 NWELL PWELL BULK DFF_X1
X$160599 \$75811 \$76101 \$76099 \$71123 NWELL PWELL BULK DFF_X1
X$160602 \$74295 \$73830 \$73826 \$71123 NWELL PWELL BULK DFF_X1
X$160604 \$75447 \$74851 \$75437 \$71123 NWELL PWELL BULK DFF_X1
X$160606 \$74288 \$74007 \$74284 \$71123 NWELL PWELL BULK DFF_X1
X$160608 \$I175504 \$74004 \$74694 \$71123 NWELL PWELL BULK DFF_X1
X$160611 \$I178369 \$74847 \$74425 \$71123 NWELL PWELL BULK DFF_X1
X$160614 \$77353 \$77174 \$77337 \$71123 NWELL PWELL BULK DFF_X1
X$160649 S0_AXI_RDATA[19] \$71133 NWELL PWELL BULK BUF_X1
X$160666 \$I176656 \$71136 \$71450 \$71532 NWELL PWELL BULK DFF_X1
X$160690 \$72958 \$72265 \$71149 NWELL PWELL BULK OR2_X1
X$160712 M0_AXI_WSTRB[1] \$71152 NWELL PWELL BULK CLKBUF_X2
X$160721 \$75375 \$74476 \$74062 \$71156 NWELL PWELL BULK NAND3_X4
X$160726 \$71156 \$71568 \$71567 NWELL PWELL BULK NAND2_X1
X$160729 \$71156 \$71608 \$71990 NWELL PWELL BULK NAND2_X1
X$160734 \$71156 \$71205 \$71186 NWELL PWELL BULK NAND2_X1
X$160740 \$71156 \$73533 \$73586 NWELL PWELL BULK NAND2_X1
X$160742 \$71156 \$74500 \$74498 NWELL PWELL BULK NAND2_X1
X$160749 \$71156 \$74109 \$74083 NWELL PWELL BULK NAND2_X1
X$160754 \$71156 \$73520 \$73519 NWELL PWELL BULK NAND2_X1
X$160757 \$71156 \$72027 \$72360 NWELL PWELL BULK NAND2_X1
X$160760 \$71156 \$75252 \$75315 NWELL PWELL BULK NAND2_X1
X$160767 \$71156 \$73697 \$73508 NWELL PWELL BULK NAND2_X1
X$160771 \$71156 \$74073 \$74188 NWELL PWELL BULK NAND2_X1
X$160773 \$71156 \$75628 \$76044 NWELL PWELL BULK NAND2_X1
X$160775 \$71156 \$71940 \$71939 NWELL PWELL BULK NAND2_X1
X$160780 \$71156 \$82285 \$81918 NWELL PWELL BULK NAND2_X1
X$160783 \$71156 \$82615 \$82697 NWELL PWELL BULK NAND2_X1
X$160788 \$71156 \$77245 \$77269 NWELL PWELL BULK NAND2_X1
X$160793 \$71156 \$76959 \$77242 NWELL PWELL BULK NAND2_X1
X$160800 \$71156 \$82272 \$81959 NWELL PWELL BULK NAND2_X1
X$160803 \$71156 \$80545 \$80191 NWELL PWELL BULK NAND2_X1
X$160808 \$71156 \$80909 \$81265 NWELL PWELL BULK NAND2_X1
X$160811 \$71156 \$81550 \$81230 NWELL PWELL BULK NAND2_X1
X$160814 \$71156 \$78398 \$78401 NWELL PWELL BULK NAND2_X1
X$160817 \$71156 \$76604 \$76602 NWELL PWELL BULK NAND2_X1
X$160819 \$71156 \$78749 \$78787 NWELL PWELL BULK NAND2_X1
X$160822 \$71156 \$74592 \$74921 NWELL PWELL BULK NAND2_X1
X$160825 \$71156 \$76287 \$76393 NWELL PWELL BULK NAND2_X1
X$160831 \$71156 \$71925 \$71923 NWELL PWELL BULK NAND2_X1
X$160837 \$71156 \$71914 \$71345 NWELL PWELL BULK NAND2_X1
X$160840 \$71156 \$74487 \$74607 NWELL PWELL BULK NAND2_X1
X$160847 \$71156 \$76406 \$76407 NWELL PWELL BULK NAND2_X1
X$160853 \$71156 \$79450 \$79081 NWELL PWELL BULK NAND2_X1
X$160856 \$71156 \$78737 \$78804 NWELL PWELL BULK NAND2_X1
X$160860 \$71156 \$79071 \$79070 NWELL PWELL BULK NAND2_X1
X$160869 \$71156 \$80610 \$80530 NWELL PWELL BULK NAND2_X1
X$160872 \$71156 \$82336 \$82269 NWELL PWELL BULK NAND2_X1
X$160877 \$71156 \$81535 \$81948 NWELL PWELL BULK NAND2_X1
X$160879 \$71156 \$82275 \$82274 NWELL PWELL BULK NAND2_X1
X$160882 \$71156 \$77792 \$77541 NWELL PWELL BULK NAND2_X1
X$160885 \$71156 \$78742 \$78382 NWELL PWELL BULK NAND2_X1
X$160890 \$71156 \$78488 \$78375 NWELL PWELL BULK NAND2_X1
X$160892 \$71156 \$77011 \$76941 NWELL PWELL BULK NAND2_X1
X$160980 \$74910 \$74476 \$74062 \$71173 NWELL PWELL BULK NAND3_X4
X$160986 \$71173 \$71573 \$71986 NWELL PWELL BULK NAND2_X1
X$160989 \$71173 \$72002 \$72327 NWELL PWELL BULK NAND2_X1
X$160992 \$71173 \$73543 \$73546 NWELL PWELL BULK NAND2_X1
X$160995 \$71173 \$75261 \$74525 NWELL PWELL BULK NAND2_X1
X$161001 \$71173 \$74927 \$74085 NWELL PWELL BULK NAND2_X1
X$161004 \$71173 \$73506 \$73731 NWELL PWELL BULK NAND2_X1
X$161009 \$71173 \$71637 \$71639 NWELL PWELL BULK NAND2_X1
X$161012 \$71173 \$73516 \$73513 NWELL PWELL BULK NAND2_X1
X$161015 \$71173 \$75248 \$75917 NWELL PWELL BULK NAND2_X1
X$161018 \$71173 \$71577 \$71582 NWELL PWELL BULK NAND2_X1
X$161020 \$71173 \$75631 \$75924 NWELL PWELL BULK NAND2_X1
X$161026 \$71173 \$74129 \$74080 NWELL PWELL BULK NAND2_X1
X$161033 \$71173 \$71566 \$71258 NWELL PWELL BULK NAND2_X1
X$161036 \$71173 \$82951 \$82287 NWELL PWELL BULK NAND2_X1
X$161038 \$71173 \$82282 \$82684 NWELL PWELL BULK NAND2_X1
X$161043 \$71173 \$77244 \$77561 NWELL PWELL BULK NAND2_X1
X$161046 \$71173 \$78098 \$78105 NWELL PWELL BULK NAND2_X1
X$161053 \$71173 \$76968 \$76971 NWELL PWELL BULK NAND2_X1
X$161055 \$71173 \$82725 \$83028 NWELL PWELL BULK NAND2_X1
X$161058 \$71173 \$82612 \$83007 NWELL PWELL BULK NAND2_X1
X$161060 \$71173 \$81531 \$81532 NWELL PWELL BULK NAND2_X1
X$161065 \$71173 \$80540 \$80924 NWELL PWELL BULK NAND2_X1
X$161067 \$71173 \$82942 \$82278 NWELL PWELL BULK NAND2_X1
X$161070 \$71173 \$81228 \$81555 NWELL PWELL BULK NAND2_X1
X$161074 \$71173 \$76956 \$76662 NWELL PWELL BULK NAND2_X1
X$161078 \$71173 \$78751 \$78390 NWELL PWELL BULK NAND2_X1
X$161080 \$71173 \$82631 \$82630 NWELL PWELL BULK NAND2_X1
X$161085 \$71173 \$76288 \$76597 NWELL PWELL BULK NAND2_X1
X$161087 \$71173 \$74588 \$74070 NWELL PWELL BULK NAND2_X1
X$161091 \$71173 \$72073 \$72082 NWELL PWELL BULK NAND2_X1
X$161095 \$71173 \$78087 \$78158 NWELL PWELL BULK NAND2_X1
X$161099 \$71173 \$72642 \$72906 NWELL PWELL BULK NAND2_X1
X$161102 \$71173 \$74068 \$74067 NWELL PWELL BULK NAND2_X1
X$161108 \$71173 \$76280 \$76279 NWELL PWELL BULK NAND2_X1
X$161118 \$71173 \$79446 \$79822 NWELL PWELL BULK NAND2_X1
X$161120 \$71173 \$79448 \$79144 NWELL PWELL BULK NAND2_X1
X$161122 \$71173 \$78812 \$78809 NWELL PWELL BULK NAND2_X1
X$161124 \$71173 \$79831 \$79451 NWELL PWELL BULK NAND2_X1
X$161127 \$71173 \$81606 \$81218 NWELL PWELL BULK NAND2_X1
X$161130 \$71173 \$78747 \$78386 NWELL PWELL BULK NAND2_X1
X$161137 \$71173 \$76592 \$76591 NWELL PWELL BULK NAND2_X1
X$161209 \$I178505 \$75634 \$75970 \$71179 NWELL PWELL BULK DFF_X1
X$161212 \$I174864 \$75269 \$75276 \$71179 NWELL PWELL BULK DFF_X1
X$161214 \$I174854 \$74109 \$74127 \$71179 NWELL PWELL BULK DFF_X1
X$161217 \$I174818 \$71608 \$71944 \$71179 NWELL PWELL BULK DFF_X1
X$161220 \$I174754 \$72002 \$71943 \$71179 NWELL PWELL BULK DFF_X1
X$161223 \$I174913 \$73180 \$73522 \$71179 NWELL PWELL BULK DFF_X1
X$161226 \$I179192 \$71205 \$71598 \$71179 NWELL PWELL BULK DFF_X1
X$161229 \$I179191 \$72680 \$73590 \$71179 NWELL PWELL BULK DFF_X1
X$161231 \$I174923 \$73533 \$73532 \$71179 NWELL PWELL BULK DFF_X1
X$161234 \$I174783 \$73543 \$72681 \$71179 NWELL PWELL BULK DFF_X1
X$161236 \$I179186 \$72328 \$72348 \$71179 NWELL PWELL BULK DFF_X1
X$161238 \$I178488 \$74931 \$74929 \$71179 NWELL PWELL BULK DFF_X1
X$161241 \$I174990 \$74503 \$74096 \$71179 NWELL PWELL BULK DFF_X1
X$161244 \$I174866 \$74506 \$74089 \$71179 NWELL PWELL BULK DFF_X1
X$161246 \$I178641 \$74500 \$74955 \$71179 NWELL PWELL BULK DFF_X1
X$161249 \$I178506 \$75261 \$74501 \$71179 NWELL PWELL BULK DFF_X1
X$161252 \$I174919 \$73529 \$73622 \$71179 NWELL PWELL BULK DFF_X1
X$161255 \$I178587 \$73184 \$73183 \$71179 NWELL PWELL BULK DFF_X1
X$161259 \$I178586 \$71573 \$72350 \$71179 NWELL PWELL BULK DFF_X1
X$161261 \$I178643 \$75632 \$76368 \$71179 NWELL PWELL BULK DFF_X1
X$161263 \$I178474 \$75258 \$75254 \$71179 NWELL PWELL BULK DFF_X1
X$161265 \$I178650 \$74927 \$74084 \$71179 NWELL PWELL BULK DFF_X1
X$161269 \$I179281 \$72669 \$72784 \$71179 NWELL PWELL BULK DFF_X1
X$161271 \$I178475 \$73178 \$73208 \$71179 NWELL PWELL BULK DFF_X1
X$161273 \$I175244 \$71577 \$71950 \$71179 NWELL PWELL BULK DFF_X1
X$161275 \$I179280 \$71940 \$71938 \$71179 NWELL PWELL BULK DFF_X1
X$161278 \$I175048 \$71566 \$71275 \$71179 NWELL PWELL BULK DFF_X1
X$161280 \$I174905 \$71568 \$71941 \$71179 NWELL PWELL BULK DFF_X1
X$161405 \$71333 \$72110 \$71689 \$71552 NWELL PWELL BULK DFF_X1
X$161418 M0_AXI_WDATA[11] \$71336 NWELL PWELL BULK BUF_X1
X$161560 M2_AXI_AWSIZE[0] \$72689 NWELL PWELL BULK BUF_X1
X$161565 M2_AXI_AWADDR[7] \$72353 NWELL PWELL BULK BUF_X1
X$161579 \$73591 \$73594 \$73352 \$71474 NWELL PWELL BULK DFF_X1
X$161582 \$I178321 \$71978 \$72356 \$71474 NWELL PWELL BULK DFF_X1
X$161585 \$73592 \$73350 \$73207 \$71474 NWELL PWELL BULK DFF_X1
X$161588 \$75678 \$75969 \$75534 \$71474 NWELL PWELL BULK DFF_X1
X$161590 \$74807 \$74950 \$74804 \$71474 NWELL PWELL BULK DFF_X1
X$161593 \$74947 \$74802 \$74948 \$71474 NWELL PWELL BULK DFF_X1
X$161596 \$75524 \$75952 \$75652 \$71474 NWELL PWELL BULK DFF_X1
X$161598 \$74800 \$74799 \$75151 \$71474 NWELL PWELL BULK DFF_X1
X$161601 \$I178353 \$75532 \$75671 \$71474 NWELL PWELL BULK DFF_X1
X$161604 \$75284 \$75153 \$75659 \$71474 NWELL PWELL BULK DFF_X1
X$161607 \$75155 \$75665 \$75154 \$71474 NWELL PWELL BULK DFF_X1
X$161610 \$73971 \$74535 \$74532 \$71474 NWELL PWELL BULK DFF_X1
X$161612 \$74108 \$74103 \$74106 \$71474 NWELL PWELL BULK DFF_X1
X$161615 \$I175502 \$74128 \$74549 \$71474 NWELL PWELL BULK DFF_X1
X$161617 \$75162 \$75304 \$75300 \$71474 NWELL PWELL BULK DFF_X1
X$161619 \$I175535 \$75963 \$75967 \$71474 NWELL PWELL BULK DFF_X1
X$161621 \$75826 \$76338 \$76184 \$71474 NWELL PWELL BULK DFF_X1
X$161623 \$74970 \$74965 \$74967 \$71474 NWELL PWELL BULK DFF_X1
X$161626 \$I178363 \$74811 \$74380 \$71474 NWELL PWELL BULK DFF_X1
X$161629 \$I175500 \$73080 \$73625 \$71474 NWELL PWELL BULK DFF_X1
X$161631 \$I178352 \$72730 \$73614 \$71474 NWELL PWELL BULK DFF_X1
X$161633 \$I178347 \$72720 \$72724 \$71474 NWELL PWELL BULK DFF_X1
X$161636 \$I178348 \$74810 \$74960 \$71474 NWELL PWELL BULK DFF_X1
X$161639 \$73357 \$74118 \$74377 \$71474 NWELL PWELL BULK DFF_X1
X$161643 \$I178355 \$73361 \$73359 \$71474 NWELL PWELL BULK DFF_X1
X$161646 \$73610 \$72721 \$73220 \$71474 NWELL PWELL BULK DFF_X1
X$161649 \$I178445 \$71985 \$72366 \$71474 NWELL PWELL BULK DFF_X1
X$161679 S2_AXI_RLAST \$71489 NWELL PWELL BULK BUF_X1
X$161682 \$71842 \$71712 \$71489 \$72028 NWELL PWELL BULK MUX2_X1
X$161697 \$77702 \$71495 \$76995 \$77818 NWELL PWELL BULK MUX2_X1
X$161700 \$82194 \$71495 \$81146 \$82320 NWELL PWELL BULK MUX2_X1
X$161706 \$74423 \$71495 NWELL PWELL BULK BUF_X8
X$161709 \$79744 \$71495 \$79336 \$80232 NWELL PWELL BULK MUX2_X1
X$161711 \$78983 \$71495 \$78298 \$79118 NWELL PWELL BULK MUX2_X1
X$161713 \$82876 \$71495 \$77367 \$82877 NWELL PWELL BULK MUX2_X1
X$161725 S2_AXI_RDATA[11] \$71500 NWELL PWELL BULK CLKBUF_X2
X$161730 \$71704 \$71841 \$71500 \$71703 NWELL PWELL BULK MUX2_X1
X$161765 S0_AXI_RDATA[2] \$71521 NWELL PWELL BULK BUF_X1
X$161791 \$I174985 \$72287 \$71897 \$71532 NWELL PWELL BULK DFF_X1
X$161794 \$I174725 \$73139 \$73136 \$71532 NWELL PWELL BULK DFF_X1
X$161796 \$I178663 \$73267 \$73134 \$71532 NWELL PWELL BULK DFF_X1
X$161800 \$71772 \$72172 \$72173 \$71532 NWELL PWELL BULK DFF_X1
X$161802 \$I178754 \$71896 \$73059 \$71532 NWELL PWELL BULK DFF_X1
X$161804 \$I174581 \$78894 \$78600 \$71532 NWELL PWELL BULK DFF_X1
X$161807 \$I177855 \$77946 \$77954 \$71532 NWELL PWELL BULK DFF_X1
X$161810 \$I178947 \$77762 \$77504 \$71532 NWELL PWELL BULK DFF_X1
X$161813 \$I174381 \$78349 \$78238 \$71532 NWELL PWELL BULK DFF_X1
X$161815 \$I177631 \$76253 \$76571 \$71532 NWELL PWELL BULK DFF_X1
X$161817 \$I179246 \$74891 \$75600 \$71532 NWELL PWELL BULK DFF_X1
X$161820 \$I175081 \$75087 \$75469 \$71532 NWELL PWELL BULK DFF_X1
X$161822 \$I179284 \$75749 \$75213 \$71532 NWELL PWELL BULK DFF_X1
X$161825 \$I179147 \$74453 \$74449 \$71532 NWELL PWELL BULK DFF_X1
X$161828 \$I179302 \$74037 \$74781 \$71532 NWELL PWELL BULK DFF_X1
X$161831 \$I178571 \$74042 \$73470 \$71532 NWELL PWELL BULK DFF_X1
X$161833 \$I175258 \$75881 \$76471 \$71532 NWELL PWELL BULK DFF_X1
X$161835 \$I175099 \$74456 \$74751 \$71532 NWELL PWELL BULK DFF_X1
X$161838 \$I175254 \$75596 \$75491 \$71532 NWELL PWELL BULK DFF_X1
X$161841 \$I175255 \$75098 \$75485 \$71532 NWELL PWELL BULK DFF_X1
X$161844 \$72902 \$71532 NWELL PWELL BULK BUF_X4
X$161846 \$I179270 \$76151 \$75751 \$71532 NWELL PWELL BULK DFF_X1
X$161849 \$I174244 \$77764 \$77432 \$71532 NWELL PWELL BULK DFF_X1
X$161851 \$I174268 \$76458 \$76829 \$71532 NWELL PWELL BULK DFF_X1
X$161854 \$I174250 \$76569 \$76567 \$71532 NWELL PWELL BULK DFF_X1
X$161856 \$I175782 \$77669 \$77500 \$71532 NWELL PWELL BULK DFF_X1
X$161858 \$I174493 \$77507 \$77424 \$71532 NWELL PWELL BULK DFF_X1
X$161860 \$I174385 \$76823 \$77106 \$71532 NWELL PWELL BULK DFF_X1
X$161863 \$I178989 \$77209 \$77418 \$71532 NWELL PWELL BULK DFF_X1
X$161865 \$I176010 \$79408 \$79674 \$71532 NWELL PWELL BULK DFF_X1
X$161903 \$72252 \$72577 \$71537 NWELL PWELL BULK OR2_X2
X$161916 \$72902 \$71552 NWELL PWELL BULK BUF_X4
X$161919 \$I177540 \$74588 \$74196 \$71552 NWELL PWELL BULK DFF_X1
X$161922 \$I174542 \$74592 \$74982 \$71552 NWELL PWELL BULK DFF_X1
X$161924 \$I177541 \$75241 \$75620 \$71552 NWELL PWELL BULK DFF_X1
X$161927 \$72856 \$72857 \$72651 \$71552 NWELL PWELL BULK DFF_X1
X$161930 \$72653 \$73158 \$73229 \$71552 NWELL PWELL BULK DFF_X1
X$161932 \$I174538 \$75244 \$76056 \$71552 NWELL PWELL BULK DFF_X1
X$161934 \$I177474 \$77240 \$77587 \$71552 NWELL PWELL BULK DFF_X1
X$161936 \$I174392 \$76287 \$76695 \$71552 NWELL PWELL BULK DFF_X1
X$161939 \$I177436 \$76288 \$76948 \$71552 NWELL PWELL BULK DFF_X1
X$161941 \$75912 \$71552 \$I245600 \$74910 NWELL PWELL BULK DFF_X2
X$161943 \$I179259 \$76594 \$76284 \$71552 NWELL PWELL BULK DFF_X1
X$161946 \$I179286 \$76592 \$76719 \$71552 NWELL PWELL BULK DFF_X1
X$161949 \$76418 \$71552 \$I245729 \$73496 NWELL PWELL BULK DFF_X2
X$161952 \$I176924 \$78458 \$78801 \$71552 NWELL PWELL BULK DFF_X1
X$161955 \$I176921 \$78737 \$78808 \$71552 NWELL PWELL BULK DFF_X1
X$161958 \$I175672 \$78373 \$78509 \$71552 NWELL PWELL BULK DFF_X1
X$161960 \$I175664 \$78379 \$78473 \$71552 NWELL PWELL BULK DFF_X1
X$161962 \$I174747 \$79831 \$79121 \$71552 NWELL PWELL BULK DFF_X1
X$161965 \$I176148 \$77006 \$76705 \$71552 NWELL PWELL BULK DFF_X1
X$161968 \$I176140 \$78171 \$78181 \$71552 NWELL PWELL BULK DFF_X1
X$161970 \$I174446 \$77792 \$77583 \$71552 NWELL PWELL BULK DFF_X1
X$161973 \$I176715 \$76406 \$76272 \$71552 NWELL PWELL BULK DFF_X1
X$161976 \$I176898 \$77529 \$77318 \$71552 NWELL PWELL BULK DFF_X1
X$161978 \$I176900 \$77231 \$77531 \$71552 NWELL PWELL BULK DFF_X1
X$161980 \$I175410 \$77538 \$77597 \$71552 NWELL PWELL BULK DFF_X1
X$161983 \$I175634 \$77011 \$77014 \$71552 NWELL PWELL BULK DFF_X1
X$161986 \$I176668 \$76280 \$76281 \$71552 NWELL PWELL BULK DFF_X1
X$161989 \$I176195 \$77789 \$77594 \$71552 NWELL PWELL BULK DFF_X1
X$162122 \$71838 \$71666 NWELL PWELL BULK INV_X1
X$162138 \$71680 \$72080 \$73093 \$71845 NWELL PWELL BULK MUX2_X1
X$162181 \$80437 \$71712 \$80438 \$80585 NWELL PWELL BULK MUX2_X1
X$162184 \$73406 \$71712 \$72556 \$73293 NWELL PWELL BULK MUX2_X1
X$162188 \$76190 \$71712 \$76191 \$76367 NWELL PWELL BULK MUX2_X1
X$162191 \$74831 \$71712 \$74832 \$75332 NWELL PWELL BULK MUX2_X1
X$162194 \$81234 \$71712 \$81137 \$81553 NWELL PWELL BULK MUX2_X1
X$162197 \$78976 \$71712 \$79325 \$79090 NWELL PWELL BULK MUX2_X1
X$162199 \$78619 \$71712 \$78290 \$78618 NWELL PWELL BULK MUX2_X1
X$162201 \$76351 \$71712 \$76185 \$76348 NWELL PWELL BULK MUX2_X1
X$162205 \$76188 \$71712 \$75701 \$76352 NWELL PWELL BULK MUX2_X1
X$162208 \$82523 \$71712 \$82647 \$82646 NWELL PWELL BULK MUX2_X1
X$162210 \$82866 \$71712 \$83418 \$82955 NWELL PWELL BULK MUX2_X1
X$162212 \$80919 \$71712 \$80558 \$80913 NWELL PWELL BULK MUX2_X1
X$162214 \$78128 \$71712 \$78418 \$78410 NWELL PWELL BULK MUX2_X1
X$162217 \$81261 \$71712 \$80828 \$80941 NWELL PWELL BULK MUX2_X1
X$162219 \$81421 \$71712 \$81423 \$80926 NWELL PWELL BULK MUX2_X1
X$162221 \$82979 \$71712 \$82531 \$82972 NWELL PWELL BULK MUX2_X1
X$162223 \$72548 \$71712 \$71843 \$72773 NWELL PWELL BULK MUX2_X1
X$162225 \$74399 \$71712 \$73552 \$74187 NWELL PWELL BULK MUX2_X1
X$162227 \$79495 \$71712 \$79740 \$79332 NWELL PWELL BULK MUX2_X1
X$162229 \$79105 \$71712 \$78978 \$79104 NWELL PWELL BULK MUX2_X1
X$162232 \$77457 \$71712 \$76861 \$77257 NWELL PWELL BULK MUX2_X1
X$162234 \$76643 \$71712 \$75838 \$76642 NWELL PWELL BULK MUX2_X1
X$162274 M0_AXI_WSTRB[0] \$71721 NWELL PWELL BULK BUF_X1
X$162327 \$71900 \$71760 \$72444 NWELL PWELL BULK NOR2_X1
X$162353 \$71783 M0_AXI_RDATA[19] NWELL PWELL BULK BUF_X1
X$162377 S1_AXI_RRESP[0] \$71791 NWELL PWELL BULK BUF_X1
X$162403 \$71796 M0_AXI_RDATA[11] NWELL PWELL BULK BUF_X1
X$162445 M2_AXI_AWADDR[21] \$72207 NWELL PWELL BULK BUF_X1
X$162450 M2_AXI_AWADDR[24] \$72706 NWELL PWELL BULK BUF_X1
X$162485 \$I177588 \$72540 \$71835 \$72541 NWELL PWELL BULK DFF_X1
X$162488 \$71837 \$71836 NWELL PWELL BULK INV_X2
X$162496 \$71837 \$72540 \$72756 NWELL PWELL BULK XNOR2_X1
X$162499 \$73088 \$72541 \$I245641 \$71837 NWELL PWELL BULK DFF_X2
X$162508 \$71838 \$73085 \$72539 NWELL PWELL BULK XNOR2_X1
X$162511 \$72761 \$72541 \$I245681 \$71838 NWELL PWELL BULK DFF_X2
X$162519 \$72555 \$71841 \$72556 \$72799 NWELL PWELL BULK MUX2_X1
X$162521 \$76192 \$71841 \$75838 \$76010 NWELL PWELL BULK MUX2_X1
X$162523 \$75555 \$71841 \$74832 \$75711 NWELL PWELL BULK MUX2_X1
X$162525 \$83920 \$71841 \$82647 \$83917 NWELL PWELL BULK MUX2_X1
X$162527 \$82185 \$71841 \$81137 \$82295 NWELL PWELL BULK MUX2_X1
X$162529 \$80572 \$71841 \$80438 \$80074 NWELL PWELL BULK MUX2_X1
X$162531 \$79492 \$71841 \$79740 \$79331 NWELL PWELL BULK MUX2_X1
X$162534 \$80428 \$71841 \$80558 \$80548 NWELL PWELL BULK MUX2_X1
X$162536 \$79462 \$71841 \$79325 \$79842 NWELL PWELL BULK MUX2_X1
X$162539 \$83910 \$71841 \$83418 \$83908 NWELL PWELL BULK MUX2_X1
X$162542 \$77698 \$71841 \$78418 \$77811 NWELL PWELL BULK MUX2_X1
X$162544 \$76863 \$71841 \$76191 \$76987 NWELL PWELL BULK MUX2_X1
X$162547 \$76345 \$71841 \$76185 \$76626 NWELL PWELL BULK MUX2_X1
X$162549 \$81567 \$71841 \$81423 \$81565 NWELL PWELL BULK MUX2_X1
X$162552 \$80933 \$71841 \$80828 \$80567 NWELL PWELL BULK MUX2_X1
X$162554 \$82530 \$71841 \$82531 \$82658 NWELL PWELL BULK MUX2_X1
X$162556 \$72224 \$71841 \$71843 \$72768 NWELL PWELL BULK MUX2_X1
X$162559 \$74990 \$71841 \$73552 \$74997 NWELL PWELL BULK MUX2_X1
X$162561 \$75998 \$71841 \$75701 \$75997 NWELL PWELL BULK MUX2_X1
X$162565 \$78289 \$71841 \$78290 \$78396 NWELL PWELL BULK MUX2_X1
X$162567 \$76973 \$71841 \$76861 \$76969 NWELL PWELL BULK MUX2_X1
X$162569 \$78773 \$71841 \$78978 \$78768 NWELL PWELL BULK MUX2_X1
X$162616 S2_AXI_RID[0] \$71843 NWELL PWELL BULK CLKBUF_X2
X$162627 \$72228 \$72549 \$71847 NWELL PWELL BULK NAND2_X1
X$162631 \$71848 \$73396 \$73702 NWELL PWELL BULK NAND2_X1
X$162634 \$72441 \$73725 \$71848 NWELL PWELL BULK NAND2_X4
X$162636 \$71848 \$72229 \$73401 NWELL PWELL BULK NAND2_X1
X$162639 \$71848 \$73097 \$73711 NWELL PWELL BULK NAND2_X1
X$162642 \$71848 \$72228 NWELL PWELL BULK INV_X2
X$162644 \$71848 \$72227 \$72044 NWELL PWELL BULK NAND2_X1
X$162646 \$71848 \$72231 \$72429 NWELL PWELL BULK NAND2_X1
X$162658 \$71854 \$72080 \$71855 \$72818 NWELL PWELL BULK MUX2_X1
X$162665 S2_AXI_RDATA[19] \$71859 NWELL PWELL BULK BUF_X1
X$162679 S1_AXI_RDATA[19] \$71861 NWELL PWELL BULK BUF_X1
X$162732 \$80810 \$71900 \$80355 \$80492 NWELL PWELL BULK AOI21_X1
X$162734 \$82242 \$71900 \$82241 \$82240 NWELL PWELL BULK AOI21_X1
X$162737 \$71900 \$82579 \$82242 NWELL PWELL BULK NOR2_X1
X$162740 \$81716 \$71900 \$81082 \$81196 NWELL PWELL BULK AOI21_X1
X$162742 \$71900 \$80802 \$80810 NWELL PWELL BULK NOR2_X1
X$162745 \$81367 \$71900 \$81188 \$81743 NWELL PWELL BULK AOI21_X1
X$162747 \$71900 \$81189 \$81367 NWELL PWELL BULK NOR2_X1
X$162749 \$71900 \$82924 \$82923 NWELL PWELL BULK NOR2_X1
X$162752 \$82923 \$71900 \$82067 \$83141 NWELL PWELL BULK AOI21_X1
X$162755 \$71900 \$82585 \$82583 NWELL PWELL BULK NOR2_X1
X$162758 \$82583 \$71900 \$82581 \$82861 NWELL PWELL BULK AOI21_X1
X$162761 \$71900 \$83114 \$82927 NWELL PWELL BULK NOR2_X1
X$162764 \$82927 \$71900 \$82817 \$83130 NWELL PWELL BULK AOI21_X1
X$162767 \$81882 \$71900 \$81881 \$82062 NWELL PWELL BULK AOI21_X1
X$162770 \$71900 \$82251 \$81882 NWELL PWELL BULK NOR2_X1
X$162773 \$71900 \$81198 \$81716 NWELL PWELL BULK NOR2_X1
X$162775 \$79278 \$71900 \$78707 \$79651 NWELL PWELL BULK AOI21_X1
X$162778 \$77766 \$71900 \$77767 \$77954 NWELL PWELL BULK AOI21_X1
X$162780 \$71900 \$79412 \$79278 NWELL PWELL BULK NOR2_X1
X$162783 \$71900 \$80147 \$80340 NWELL PWELL BULK NOR2_X1
X$162785 \$80340 \$71900 \$80146 \$80348 NWELL PWELL BULK AOI21_X1
X$162788 \$74452 \$71900 \$74040 \$74449 NWELL PWELL BULK AOI21_X1
X$162791 \$71900 \$74453 \$74452 NWELL PWELL BULK NOR2_X1
X$162794 \$71900 \$76458 \$76462 NWELL PWELL BULK NOR2_X1
X$162796 \$76462 \$71900 \$76159 \$76829 NWELL PWELL BULK AOI21_X1
X$162798 \$77205 \$71900 \$77092 \$77418 NWELL PWELL BULK AOI21_X1
X$162801 \$71900 \$77209 \$77205 NWELL PWELL BULK NOR2_X1
X$162804 \$71900 \$77946 \$77766 NWELL PWELL BULK NOR2_X1
X$162845 \$71914 \$73496 \$72642 \$73497 NWELL PWELL BULK MUX2_X1
X$162849 M0_AXI_WDATA[18] \$71918 NWELL PWELL BULK BUF_X1
X$162864 M0_AXI_WID[0] \$71920 NWELL PWELL BULK BUF_X1
X$163000 \$72047 \$72227 \$72425 NWELL PWELL BULK XNOR2_X1
X$163030 \$72805 \$72080 \$73729 \$72806 NWELL PWELL BULK MUX2_X1
X$163033 \$75554 \$72080 \$74406 \$74202 NWELL PWELL BULK MUX2_X1
X$163036 \$81249 \$72080 \$80826 \$81251 NWELL PWELL BULK MUX2_X1
X$163039 \$83813 \$72080 \$82868 \$82969 NWELL PWELL BULK MUX2_X1
X$163042 \$83171 \$72080 \$83913 \$82963 NWELL PWELL BULK MUX2_X1
X$163045 \$79848 \$72080 \$79847 \$79327 NWELL PWELL BULK MUX2_X1
X$163048 \$79466 \$72080 \$79463 \$79469 NWELL PWELL BULK MUX2_X1
X$163051 \$76978 \$72080 \$77155 \$76980 NWELL PWELL BULK MUX2_X1
X$163053 \$78770 \$72080 \$78623 \$78625 NWELL PWELL BULK MUX2_X1
X$163056 \$76629 \$72080 \$76186 \$76630 NWELL PWELL BULK MUX2_X1
X$163058 \$77695 \$72080 \$78114 \$77696 NWELL PWELL BULK MUX2_X1
X$163060 \$80923 \$72080 \$80563 \$80565 NWELL PWELL BULK MUX2_X1
X$163063 \$80434 \$72080 \$81259 \$81582 NWELL PWELL BULK MUX2_X1
X$163066 \$75708 \$72080 \$75835 \$75552 NWELL PWELL BULK MUX2_X1
X$163068 \$81916 \$72080 \$82299 \$81920 NWELL PWELL BULK MUX2_X1
X$163070 \$81912 \$72080 \$81811 \$81913 NWELL PWELL BULK MUX2_X1
X$163073 \$80550 \$72080 \$80551 \$80564 NWELL PWELL BULK MUX2_X1
X$163075 \$83812 \$72080 \$82959 \$82962 NWELL PWELL BULK MUX2_X1
X$163077 \$81925 \$72080 \$82193 \$81422 NWELL PWELL BULK MUX2_X1
X$163079 \$81941 \$72080 \$81429 \$81943 NWELL PWELL BULK MUX2_X1
X$163081 \$82652 \$72080 \$82981 \$82659 NWELL PWELL BULK MUX2_X1
X$163083 \$82870 \$72080 \$83556 \$82871 NWELL PWELL BULK MUX2_X1
X$163086 \$74827 \$72080 \$74403 \$74402 NWELL PWELL BULK MUX2_X1
X$163088 \$72224 \$72080 \$72548 \$72226 NWELL PWELL BULK MUX2_X1
X$163091 \$75834 \$72080 \$76355 \$75709 NWELL PWELL BULK MUX2_X1
X$163094 \$75000 \$72080 \$74598 \$74608 NWELL PWELL BULK MUX2_X1
X$163096 \$76639 \$72080 \$76508 \$76865 NWELL PWELL BULK MUX2_X1
X$163098 \$77157 \$72080 \$77564 \$77262 NWELL PWELL BULK MUX2_X1
X$163101 \$78628 \$72080 \$78785 \$78425 NWELL PWELL BULK MUX2_X1
X$163104 \$78758 \$72080 \$78764 \$78117 NWELL PWELL BULK MUX2_X1
X$163107 \$79333 \$72080 \$79742 \$78982 NWELL PWELL BULK MUX2_X1
X$163109 \$79329 \$72080 \$79483 \$79486 NWELL PWELL BULK MUX2_X1
X$163111 \$80213 \$72080 \$80220 \$80075 NWELL PWELL BULK MUX2_X1
X$163113 \$77253 \$72080 \$77151 \$77152 NWELL PWELL BULK MUX2_X1
X$163115 \$77697 \$72080 \$78131 \$78130 NWELL PWELL BULK MUX2_X1
X$163121 \$75839 \$72080 \$76020 \$75729 NWELL PWELL BULK MUX2_X1
X$163124 \$73987 \$72080 \$74409 \$74410 NWELL PWELL BULK MUX2_X1
X$163126 \$76013 \$72080 \$76374 \$76018 NWELL PWELL BULK MUX2_X1
X$163128 \$77813 \$72080 \$77267 \$76866 NWELL PWELL BULK MUX2_X1
X$163130 \$83945 \$72080 \$83816 \$82872 NWELL PWELL BULK MUX2_X1
X$163132 \$80580 \$72080 \$80436 \$80591 NWELL PWELL BULK MUX2_X1
X$163134 \$80440 \$72080 \$80830 \$80078 NWELL PWELL BULK MUX2_X1
X$163229 \$72132 M0_AXI_RDATA[9] NWELL PWELL BULK BUF_X1
X$163257 \$72167 M1_AXI_RDATA[9] NWELL PWELL BULK BUF_X1
X$163286 M2_AXI_AWID[3] \$75274 NWELL PWELL BULK BUF_X1
X$163291 M2_AXI_AWLEN[5] \$72530 NWELL PWELL BULK BUF_X1
X$163356 \$72228 \$73704 \$73394 NWELL PWELL BULK NAND2_X1
X$163361 \$72228 \$73095 \$73275 NWELL PWELL BULK NAND2_X1
X$163363 \$72228 \$72229 \$72551 NWELL PWELL BULK NAND2_X1
X$163365 \$72228 \$74193 \$73400 NWELL PWELL BULK NAND2_X1
X$163367 \$72228 \$73396 \$73712 NWELL PWELL BULK NAND2_X1
X$163374 \$72229 \$73396 \$73704 \$73095 NWELL PWELL BULK HA_X1
X$163388 S1_AXI_RDATA[9] \$72248 NWELL PWELL BULK BUF_X1
X$163425 \$72274 \$72982 \$72301 NWELL PWELL BULK OR2_X1
X$163501 \$73840 \$73148 \$72306 NWELL PWELL BULK XOR2_X1
X$163504 \$72633 \$72307 \$73242 \$72945 NWELL PWELL BULK MUX2_X1
X$163508 \$73240 \$72636 \$72307 \$72638 NWELL PWELL BULK AOI21_X1
X$163511 \$72307 \$73149 \$73240 NWELL PWELL BULK NOR2_X1
X$163627 \$72798 \$72425 \$72437 \$72441 NWELL PWELL BULK NAND3_X2
X$163653 \$72441 M0_AXI_RVALID NWELL PWELL BULK BUF_X1
X$163730 M2_AXI_AWADDR[1] \$73199 NWELL PWELL BULK BUF_X1
X$163775 \$73086 \$72540 \$73671 NWELL PWELL BULK NAND2_X1
X$163780 \$I177572 \$74159 \$74156 \$72541 NWELL PWELL BULK DFF_X1
X$163782 \$75980 \$75829 \$76341 \$72541 NWELL PWELL BULK DFF_X1
X$163784 \$75166 \$75306 \$75307 \$72541 NWELL PWELL BULK DFF_X1
X$163786 \$75986 \$75985 \$75984 \$72541 NWELL PWELL BULK DFF_X1
X$163788 \$I177575 \$74819 \$75540 \$72541 NWELL PWELL BULK DFF_X1
X$163791 \$74388 \$74389 \$74571 \$72541 NWELL PWELL BULK DFF_X1
X$163794 \$I176630 \$74393 \$74820 \$72541 NWELL PWELL BULK DFF_X1
X$163796 \$75543 \$75171 \$75170 \$72541 NWELL PWELL BULK DFF_X1
X$163801 \$I176626 \$74166 \$73674 \$72541 NWELL PWELL BULK DFF_X1
X$163803 \$I177581 \$74386 \$74385 \$72541 NWELL PWELL BULK DFF_X1
X$163805 \$I176463 \$75544 \$75989 \$72541 NWELL PWELL BULK DFF_X1
X$163808 \$75834 \$75998 \$75997 \$72541 NWELL PWELL BULK DFF_X1
X$163810 \$76186 \$76351 \$76348 \$72541 NWELL PWELL BULK DFF_X1
X$163812 \$76355 \$76188 \$76352 \$72541 NWELL PWELL BULK DFF_X1
X$163815 \$77157 \$77259 \$77158 \$72541 NWELL PWELL BULK DFF_X1
X$163818 \$78764 \$78619 \$78618 \$72541 NWELL PWELL BULK DFF_X1
X$163820 \$79848 \$79734 \$80202 \$72541 NWELL PWELL BULK DFF_X1
X$163822 \$78758 \$78289 \$78396 \$72541 NWELL PWELL BULK DFF_X1
X$163824 \$76978 \$76973 \$76969 \$72541 NWELL PWELL BULK DFF_X1
X$163827 \$77155 \$77457 \$77257 \$72541 NWELL PWELL BULK DFF_X1
X$163830 \$76629 \$76345 \$76626 \$72541 NWELL PWELL BULK DFF_X1
X$163832 \$77253 \$77150 \$77148 \$72541 NWELL PWELL BULK DFF_X1
X$163834 \$77697 \$77698 \$77811 \$72541 NWELL PWELL BULK DFF_X1
X$163836 \$78770 \$78773 \$78768 \$72541 NWELL PWELL BULK DFF_X1
X$163839 \$78114 \$78405 \$78009 \$72541 NWELL PWELL BULK DFF_X1
X$163842 \$77151 \$77558 \$77555 \$72541 NWELL PWELL BULK DFF_X1
X$163844 \$77695 \$78104 \$78106 \$72541 NWELL PWELL BULK DFF_X1
X$163874 \$73390 \$73386 \$73688 \$72543 NWELL PWELL BULK MUX2_X1
X$163884 \$72549 \$73275 \$72785 NWELL PWELL BULK XNOR2_X1
X$163898 S2_AXI_RDATA[2] \$72556 NWELL PWELL BULK CLKBUF_X2
X$163925 S1_AXI_RDATA[11] \$72570 NWELL PWELL BULK BUF_X1
X$164056 \$72636 \$73148 \$73149 \$72942 \$73242 NWELL PWELL BULK FA_X1
X$164063 \$73810 \$73496 \$72641 \$73808 NWELL PWELL BULK MUX2_X1
X$164095 \$I175154 \$72668 \$73214 \$74077 NWELL PWELL BULK DFF_X1
X$164358 \$72902 \$78376 NWELL PWELL BULK BUF_X4
X$164369 \$72902 \$73485 NWELL PWELL BULK BUF_X4
X$164371 \$72902 \$76270 NWELL PWELL BULK BUF_X4
X$164374 \$72902 \$78069 NWELL PWELL BULK BUF_X4
X$164377 \$72902 \$80515 NWELL PWELL BULK BUF_X4
X$164380 \$72902 \$76921 NWELL PWELL BULK BUF_X4
X$164385 \$72902 \$80126 NWELL PWELL BULK BUF_X4
X$164388 \$72902 \$76229 NWELL PWELL BULK BUF_X4
X$164447 \$73840 \$72942 NWELL PWELL BULK INV_X1
X$164495 \$72994 M2_AXI_RDATA[4] NWELL PWELL BULK BUF_X1
X$164505 \$73002 M2_AXI_RDATA[2] NWELL PWELL BULK BUF_X1
X$164580 S2_AXI_RRESP[0] \$73552 NWELL PWELL BULK CLKBUF_X2
X$164585 M2_AXI_AWADDR[16] \$74121 NWELL PWELL BULK BUF_X1
X$164590 M2_AXI_AWADDR[5] \$75636 NWELL PWELL BULK BUF_X1
X$164616 \$73086 \$73085 \$73666 NWELL PWELL BULK NAND2_X1
X$164621 \$73386 \$73086 \$I241055 \$74822 NWELL PWELL BULK HA_X1
X$164623 \$73086 \$74159 \$73665 NWELL PWELL BULK NAND2_X1
X$164625 \$73086 \$74389 \$74575 NWELL PWELL BULK NAND2_X1
X$164627 \$73086 \$73977 NWELL PWELL BULK INV_X2
X$164630 \$73086 \$74393 \$74979 NWELL PWELL BULK NAND2_X1
X$164646 \$73091 \$73390 \$73688 \$73690 NWELL PWELL BULK HA_X1
X$164649 \$73386 \$73091 \$73678 NWELL PWELL BULK NAND2_X1
X$164651 \$73091 \$73386 \$73388 \$73680 NWELL PWELL BULK MUX2_X1
X$164666 S2_AXI_RDATA[4] \$73105 NWELL PWELL BULK BUF_X1
X$164683 \$74627 \$74423 \$73106 \$74209 NWELL PWELL BULK MUX2_X1
X$164686 \$74412 \$74626 \$73106 \$75030 NWELL PWELL BULK MUX2_X1
X$164715 \$73277 \$73131 \$73145 NWELL PWELL BULK OR2_X1
X$164868 \$73254 M1_AXI_RRESP[0] NWELL PWELL BULK BUF_X1
X$164890 \$73261 M1_AXI_RDATA[2] NWELL PWELL BULK BUF_X1
X$164894 \$73386 \$73390 \$73265 NWELL PWELL BULK NAND2_X1
X$164938 \$73297 M0_AXI_RDATA[4] NWELL PWELL BULK BUF_X1
X$164958 \$73310 \$73309 \$73478 NWELL PWELL BULK OR2_X1
X$164989 M2_AXI_AWADDR[11] \$74798 NWELL PWELL BULK BUF_X1
X$165023 \$73977 \$74158 \$73379 NWELL PWELL BULK NAND2_X1
X$165030 \$73386 \$74182 \$74175 NWELL PWELL BULK NAND2_X1
X$165054 \$73690 \$73391 NWELL PWELL BULK INV_X1
X$165102 S1_AXI_RDATA[21] \$73436 NWELL PWELL BULK BUF_X1
X$165116 \$73441 \$73444 \$74300 \$73847 NWELL PWELL BULK MUX2_X1
X$165119 \$80860 \$73444 \$79780 \$81093 NWELL PWELL BULK MUX2_X1
X$165121 \$78581 \$73444 \$77481 \$78332 NWELL PWELL BULK MUX2_X1
X$165123 \$76408 \$73444 \$76686 \$76520 NWELL PWELL BULK MUX2_X1
X$165128 \$79948 \$73444 \$79771 \$79951 NWELL PWELL BULK MUX2_X1
X$165131 \$79369 \$73444 \$78920 \$79635 NWELL PWELL BULK MUX2_X1
X$165133 \$78302 \$73444 \$77712 \$78455 NWELL PWELL BULK MUX2_X1
X$165135 \$80270 \$73444 \$79157 \$80265 NWELL PWELL BULK MUX2_X1
X$165138 \$74333 \$73444 \$74436 \$74334 NWELL PWELL BULK MUX2_X1
X$165140 \$76870 \$73444 \$76198 \$77002 NWELL PWELL BULK MUX2_X1
X$165142 \$75186 \$73444 \$75187 \$75407 NWELL PWELL BULK MUX2_X1
X$165145 \$73895 \$73444 \$73889 \$74341 NWELL PWELL BULK MUX2_X1
X$165147 \$75800 \$73444 \$75199 \$75584 NWELL PWELL BULK MUX2_X1
X$165149 \$76457 \$73444 \$75858 \$76758 NWELL PWELL BULK MUX2_X1
X$165151 \$79517 \$73444 \$79146 \$79514 NWELL PWELL BULK MUX2_X1
X$165154 \$81286 \$73444 \$80079 \$80954 NWELL PWELL BULK MUX2_X1
X$165156 \$80299 \$73444 \$80093 \$80301 NWELL PWELL BULK MUX2_X1
X$165168 \$77174 \$73444 \$77175 \$77337 NWELL PWELL BULK MUX2_X1
X$165209 \$73458 \$74028 \$74043 NWELL PWELL BULK OR2_X1
X$165241 \$I177126 \$73482 \$73869 \$73485 NWELL PWELL BULK DFF_X1
X$165249 \$I175857 \$73861 \$73484 \$73485 NWELL PWELL BULK DFF_X1
X$165251 \$I175887 \$75898 \$76115 \$73485 NWELL PWELL BULK DFF_X1
X$165253 \$I175890 \$75423 \$75434 \$73485 NWELL PWELL BULK DFF_X1
X$165256 \$I177092 \$74900 \$75062 \$73485 NWELL PWELL BULK DFF_X1
X$165258 \$I175733 \$74047 \$73487 \$73485 NWELL PWELL BULK DFF_X1
X$165261 \$I177105 \$74465 \$74463 \$73485 NWELL PWELL BULK DFF_X1
X$165263 \$I177122 \$75605 \$76128 \$73485 NWELL PWELL BULK DFF_X1
X$165265 \$I177641 \$75893 \$76449 \$73485 NWELL PWELL BULK DFF_X1
X$165268 \$I175888 \$75731 \$75606 \$73485 NWELL PWELL BULK DFF_X1
X$165271 \$I177210 \$74897 \$75069 \$73485 NWELL PWELL BULK DFF_X1
X$165273 \$I177941 \$75602 \$75744 \$73485 NWELL PWELL BULK DFF_X1
X$165275 \$I175719 \$75445 \$75442 \$73485 NWELL PWELL BULK DFF_X1
X$165280 \$I177642 \$76805 \$76255 \$73485 NWELL PWELL BULK DFF_X1
X$165283 \$I176218 \$76142 \$75887 \$73485 NWELL PWELL BULK DFF_X1
X$165285 \$I178154 \$78535 \$78367 \$73485 NWELL PWELL BULK DFF_X1
X$165288 \$I176204 \$79200 \$79555 \$73485 NWELL PWELL BULK DFF_X1
X$165290 \$I177667 \$78537 \$78543 \$73485 NWELL PWELL BULK DFF_X1
X$165293 \$I178188 \$78200 \$78203 \$73485 NWELL PWELL BULK DFF_X1
X$165295 \$I175806 \$77890 \$77513 \$73485 NWELL PWELL BULK DFF_X1
X$165298 \$I175488 \$76444 \$76578 \$73485 NWELL PWELL BULK DFF_X1
X$165301 \$I175483 \$77216 \$77370 \$73485 NWELL PWELL BULK DFF_X1
X$165306 \$I178181 \$77041 \$76579 \$73485 NWELL PWELL BULK DFF_X1
X$165308 \$I175798 \$77778 \$77893 \$73485 NWELL PWELL BULK DFF_X1
X$165311 \$I175749 \$76933 \$77039 \$73485 NWELL PWELL BULK DFF_X1
X$165314 \$I175972 \$78840 \$78725 \$73485 NWELL PWELL BULK DFF_X1
X$165316 \$I178111 \$78364 \$78844 \$73485 NWELL PWELL BULK DFF_X1
X$165319 \$I178068 \$78724 \$78853 \$73485 NWELL PWELL BULK DFF_X1
X$165321 \$I176058 \$76928 \$77382 \$73485 NWELL PWELL BULK DFF_X1
X$165324 \$I175481 \$77775 \$77904 \$73485 NWELL PWELL BULK DFF_X1
X$165347 \$73489 M2_AXI_RDATA[11] NWELL PWELL BULK BUF_X1
X$165357 \$79819 \$73496 \$80243 \$79821 NWELL PWELL BULK MUX2_X1
X$165359 \$77538 \$73496 \$77789 \$77232 NWELL PWELL BULK MUX2_X1
X$165361 \$80610 \$73496 \$81531 \$81965 NWELL PWELL BULK MUX2_X1
X$165364 \$82336 \$73496 \$82725 \$82271 NWELL PWELL BULK MUX2_X1
X$165366 \$83523 \$73496 \$83545 \$83526 NWELL PWELL BULK MUX2_X1
X$165368 \$82272 \$73496 \$82612 \$83520 NWELL PWELL BULK MUX2_X1
X$165371 \$82619 \$73496 \$83234 \$83235 NWELL PWELL BULK MUX2_X1
X$165374 \$81550 \$73496 \$82631 \$82628 NWELL PWELL BULK MUX2_X1
X$165376 \$81968 \$73496 \$81216 \$81529 NWELL PWELL BULK MUX2_X1
X$165378 \$83521 \$73496 \$83904 \$83565 NWELL PWELL BULK MUX2_X1
X$165380 \$80909 \$73496 \$80540 \$80911 NWELL PWELL BULK MUX2_X1
X$165383 \$83225 \$73496 \$83903 \$83519 NWELL PWELL BULK MUX2_X1
X$165386 \$83222 \$73496 \$83901 \$83223 NWELL PWELL BULK MUX2_X1
X$165389 \$78379 \$73496 \$78458 \$79082 NWELL PWELL BULK MUX2_X1
X$165391 \$80184 \$73496 \$80185 \$80535 NWELL PWELL BULK MUX2_X1
X$165394 \$80599 \$73496 \$79827 \$80596 NWELL PWELL BULK MUX2_X1
X$165397 \$82285 \$73496 \$82951 \$83528 NWELL PWELL BULK MUX2_X1
X$165399 \$82615 \$73496 \$82282 \$82617 NWELL PWELL BULK MUX2_X1
X$165402 \$82960 \$73496 \$82289 \$82953 NWELL PWELL BULK MUX2_X1
X$165404 \$82275 \$73496 \$82942 \$82941 NWELL PWELL BULK MUX2_X1
X$165407 \$80545 \$73496 \$81228 \$81245 NWELL PWELL BULK MUX2_X1
X$165409 \$81546 \$73496 \$81226 \$81254 NWELL PWELL BULK MUX2_X1
X$165413 \$74487 \$73496 \$74068 \$74985 NWELL PWELL BULK MUX2_X1
X$165416 \$73499 \$73496 \$74620 \$74917 NWELL PWELL BULK MUX2_X1
X$165418 \$81535 \$73496 \$81606 \$81901 NWELL PWELL BULK MUX2_X1
X$165420 \$78737 \$73496 \$79448 \$79077 NWELL PWELL BULK MUX2_X1
X$165422 \$79071 \$73496 \$79446 \$79444 NWELL PWELL BULK MUX2_X1
X$165424 \$79450 \$73496 \$79831 \$79829 NWELL PWELL BULK MUX2_X1
X$165427 \$81936 \$73496 \$81222 \$81931 NWELL PWELL BULK MUX2_X1
X$165430 \$78488 \$73496 \$78812 \$79154 NWELL PWELL BULK MUX2_X1
X$165432 \$78079 \$73496 \$78373 \$78735 NWELL PWELL BULK MUX2_X1
X$165434 \$77011 \$73496 \$76592 \$77539 NWELL PWELL BULK MUX2_X1
X$165440 \$77529 \$73496 \$77231 \$77530 NWELL PWELL BULK MUX2_X1
X$165442 \$76406 \$73496 \$76280 \$77785 NWELL PWELL BULK MUX2_X1
X$165513 \$I179144 \$73516 \$73515 \$74077 NWELL PWELL BULK DFF_X1
X$165526 \$I179142 \$73520 \$74147 \$74077 NWELL PWELL BULK DFF_X1
X$165688 \$73977 \$74159 \$73667 NWELL PWELL BULK NAND2_X1
X$165717 \$I179311 \$73697 \$74164 \$74077 NWELL PWELL BULK DFF_X1
X$165735 M0_AXI_RREADY \$73725 NWELL PWELL BULK CLKBUF_X2
X$165846 \$74062 \$74058 \$I241116 \$73840 NWELL PWELL BULK HA_X1
X$165853 \$74058 \$73843 NWELL PWELL BULK INV_X2
X$165858 \$73843 \$75225 \$75405 NWELL PWELL BULK NAND2_X1
X$165860 \$73843 \$74055 \$74057 NWELL PWELL BULK NAND2_X1
X$165863 \$73843 \$75716 \$75717 NWELL PWELL BULK NAND2_X1
X$165865 \$73843 \$74471 \$74056 NWELL PWELL BULK NAND2_X1
X$165867 \$73843 \$75411 \$75053 NWELL PWELL BULK NAND2_X1
X$165869 \$73843 \$75611 \$75906 NWELL PWELL BULK NAND2_X1
X$165899 \$73854 \$73857 \$73856 \$73862 NWELL PWELL BULK MUX2_X1
X$165906 \$76208 \$73857 \$76209 \$76425 NWELL PWELL BULK MUX2_X1
X$165909 \$77983 \$73857 \$78608 \$77985 NWELL PWELL BULK MUX2_X1
X$165911 \$75592 \$73857 \$75146 \$74437 NWELL PWELL BULK MUX2_X1
X$165914 \$75860 \$73857 \$75863 \$76108 NWELL PWELL BULK MUX2_X1
X$165917 \$76126 \$73857 \$76226 \$74863 NWELL PWELL BULK MUX2_X1
X$165920 \$76701 \$73857 \$77038 \$76706 NWELL PWELL BULK MUX2_X1
X$165922 \$77410 \$73857 \$77191 \$77192 NWELL PWELL BULK MUX2_X1
X$165926 \$75582 \$73857 \$75811 \$75196 NWELL PWELL BULK MUX2_X1
X$165928 \$78989 \$73857 \$79754 \$79150 NWELL PWELL BULK MUX2_X1
X$165930 \$80083 \$73857 \$80442 \$80965 NWELL PWELL BULK MUX2_X1
X$165933 \$80964 \$73857 \$81291 \$80970 NWELL PWELL BULK MUX2_X1
X$165935 \$76481 \$73857 \$76817 \$76557 NWELL PWELL BULK MUX2_X1
X$165937 \$80272 \$73857 \$79759 \$79541 NWELL PWELL BULK MUX2_X1
X$165939 \$74019 \$73857 \$73868 \$74340 NWELL PWELL BULK MUX2_X1
X$165941 \$74865 \$73857 \$75200 \$75130 NWELL PWELL BULK MUX2_X1
X$165944 \$77004 \$73857 \$77296 \$76872 NWELL PWELL BULK MUX2_X1
X$165947 \$76434 \$73857 \$76436 \$75851 NWELL PWELL BULK MUX2_X1
X$165949 \$78344 \$73857 \$79297 \$79298 NWELL PWELL BULK MUX2_X1
X$165951 \$77692 \$73857 \$77426 \$77490 NWELL PWELL BULK MUX2_X1
X$165954 \$78055 \$73857 \$78265 \$78057 NWELL PWELL BULK MUX2_X1
X$165957 \$80875 \$73857 \$80816 \$81089 NWELL PWELL BULK MUX2_X1
X$165959 \$78616 \$73857 \$77200 \$77750 NWELL PWELL BULK MUX2_X1
X$165961 \$74749 \$73857 \$74434 \$73864 NWELL PWELL BULK MUX2_X1
X$165963 \$75404 \$73857 \$75569 \$75571 NWELL PWELL BULK MUX2_X1
X$165965 \$77961 \$73857 \$78280 \$78588 NWELL PWELL BULK MUX2_X1
X$165967 \$78273 \$73857 \$78670 \$78051 NWELL PWELL BULK MUX2_X1
X$165970 \$77478 \$73857 \$77651 \$77930 NWELL PWELL BULK MUX2_X1
X$165972 \$77353 \$73857 \$77476 \$77363 NWELL PWELL BULK MUX2_X1
X$165974 \$80639 \$73857 \$80645 \$81021 NWELL PWELL BULK MUX2_X1
X$165977 \$80646 \$73857 \$80450 \$80839 NWELL PWELL BULK MUX2_X1
X$165980 \$77685 \$73857 \$77682 \$77495 NWELL PWELL BULK MUX2_X1
X$165983 \$80119 \$73857 \$80733 \$80725 NWELL PWELL BULK MUX2_X1
X$165985 \$81097 \$73857 \$80722 \$80715 NWELL PWELL BULK MUX2_X1
X$165988 \$80104 \$73857 \$80106 \$80345 NWELL PWELL BULK MUX2_X1
X$165990 \$79247 \$73857 \$79010 \$79251 NWELL PWELL BULK MUX2_X1
X$165992 \$79250 \$73857 \$78667 \$79011 NWELL PWELL BULK MUX2_X1
X$165994 \$80099 \$73857 \$80451 \$80454 NWELL PWELL BULK MUX2_X1
X$165996 \$80775 \$73857 \$81406 \$80478 NWELL PWELL BULK MUX2_X1
X$165998 \$76028 \$73857 \$76031 \$75842 NWELL PWELL BULK MUX2_X1
X$166000 \$79344 \$73857 \$78636 \$79520 NWELL PWELL BULK MUX2_X1
X$166002 \$77713 \$73857 \$78022 \$78024 NWELL PWELL BULK MUX2_X1
X$166004 \$78452 \$73857 \$78163 \$78162 NWELL PWELL BULK MUX2_X1
X$166006 \$79029 \$73857 \$79030 \$79032 NWELL PWELL BULK MUX2_X1
X$166008 \$77436 \$73857 \$77444 \$78261 NWELL PWELL BULK MUX2_X1
X$166010 \$79793 \$73857 \$80136 \$80778 NWELL PWELL BULK MUX2_X1
X$166013 \$79534 \$73857 \$79347 \$79538 NWELL PWELL BULK MUX2_X1
X$166015 \$79406 \$73857 \$80023 \$80358 NWELL PWELL BULK MUX2_X1
X$166121 S0_AXI_RRESP[0] \$73889 NWELL PWELL BULK BUF_X1
X$166189 \$73950 M1_AXI_RDATA[19] NWELL PWELL BULK BUF_X1
X$166214 \$73977 \$74819 \$74980 NWELL PWELL BULK NAND2_X1
X$166217 \$73977 \$74389 \$73979 NWELL PWELL BULK NAND2_X1
X$166222 \$73977 \$74388 \$74817 NWELL PWELL BULK NAND2_X1
X$166225 \$73977 \$73978 \$75167 NWELL PWELL BULK NAND2_X1
X$166230 \$74389 \$74159 \$74158 \$73978 NWELL PWELL BULK HA_X1
X$166245 S1_AXI_RDATA[2] \$73994 NWELL PWELL BULK BUF_X1
X$166260 \$74424 \$74423 \$73999 \$75079 NWELL PWELL BULK MUX2_X1
X$166263 \$74002 \$74626 \$73999 \$74268 NWELL PWELL BULK MUX2_X1
X$166359 \$74055 \$74056 \$74247 NWELL PWELL BULK XNOR2_X1
X$166367 \$76416 \$76936 \$74058 NWELL PWELL BULK NAND2_X2
X$166369 \$74058 \$75907 \$75905 NWELL PWELL BULK NAND2_X1
X$166371 \$74058 \$75615 \$75397 NWELL PWELL BULK NAND2_X1
X$166373 \$74058 \$75225 \$75052 NWELL PWELL BULK NAND2_X1
X$166376 \$74058 \$74906 \$74673 NWELL PWELL BULK NAND2_X1
X$166380 \$74058 \$75611 \$75718 NWELL PWELL BULK NAND2_X1
X$166389 \$74060 \$74640 \$74230 \$74064 NWELL PWELL BULK HA_X1
X$166391 \$74062 \$74060 \$75028 NWELL PWELL BULK NAND2_X1
X$166395 \$74062 \$74064 \$74631 NWELL PWELL BULK NAND2_X1
X$166397 \$74062 \$74640 \$75236 NWELL PWELL BULK NAND2_X1
X$166400 \$74062 \$74230 \$74913 NWELL PWELL BULK NAND2_X1
X$166404 \$74062 \$74233 \$74231 NWELL PWELL BULK NAND2_X1
X$166407 \$74062 \$74629 \$75239 NWELL PWELL BULK NAND2_X1
X$166442 \$I179258 \$76317 \$76309 \$74077 NWELL PWELL BULK DFF_X1
X$166445 \$I179255 \$76308 \$76606 \$74077 NWELL PWELL BULK DFF_X1
X$166448 \$I174885 \$75930 \$75928 \$74077 NWELL PWELL BULK DFF_X1
X$166451 \$I175011 \$75999 \$76004 \$74077 NWELL PWELL BULK DFF_X1
X$166455 \$I179143 \$75252 \$75249 \$74077 NWELL PWELL BULK DFF_X1
X$166462 \$I175256 \$75631 \$75923 \$74077 NWELL PWELL BULK DFF_X1
X$166464 \$I175257 \$74129 \$74142 \$74077 NWELL PWELL BULK DFF_X1
X$166467 \$I175320 \$74492 \$74183 \$74077 NWELL PWELL BULK DFF_X1
X$166469 \$I179145 \$75628 \$75916 \$74077 NWELL PWELL BULK DFF_X1
X$166474 \$I175339 \$75327 \$75333 \$74077 NWELL PWELL BULK DFF_X1
X$166477 \$I175263 \$75248 \$75247 \$74077 NWELL PWELL BULK DFF_X1
X$166480 \$I174696 \$77244 \$77243 \$74077 NWELL PWELL BULK DFF_X1
X$166483 \$I176754 \$76610 \$76965 \$74077 NWELL PWELL BULK DFF_X1
X$166485 \$I178556 \$78094 \$78423 \$74077 NWELL PWELL BULK DFF_X1
X$166487 \$I174934 \$77801 \$77799 \$74077 NWELL PWELL BULK DFF_X1
X$166490 \$I178509 \$77245 \$76960 \$74077 NWELL PWELL BULK DFF_X1
X$166492 \$I176569 \$76968 \$77291 \$74077 NWELL PWELL BULK DFF_X1
X$166494 \$I175880 \$78098 \$78124 \$74077 NWELL PWELL BULK DFF_X1
X$166497 \$I174677 \$78091 \$78088 \$74077 NWELL PWELL BULK DFF_X1
X$166500 \$I179131 \$76604 \$76951 \$74077 NWELL PWELL BULK DFF_X1
X$166503 \$I174897 \$76291 \$76598 \$74077 NWELL PWELL BULK DFF_X1
X$166505 \$I175678 \$77796 \$77810 \$74077 NWELL PWELL BULK DFF_X1
X$166507 \$I178726 \$76959 \$77574 \$74077 NWELL PWELL BULK DFF_X1
X$166509 \$I175224 \$76956 \$76952 \$74077 NWELL PWELL BULK DFF_X1
X$166513 \$I178821 \$78398 \$78766 \$74077 NWELL PWELL BULK DFF_X1
X$166515 \$I178672 \$76292 \$76997 \$74077 NWELL PWELL BULK DFF_X1
X$166639 \$74166 \$74393 \$74168 NWELL PWELL BULK XNOR2_X1
X$166756 \$75116 \$75114 \$74272 NWELL PWELL BULK OR2_X2
X$166775 S0_AXI_RDATA[4] \$74300 NWELL PWELL BULK BUF_X1
X$166909 \$83646 \$74423 \$82552 \$84038 NWELL PWELL BULK MUX2_X1
X$166912 \$84111 \$74423 \$81840 \$83840 NWELL PWELL BULK MUX2_X1
X$166914 \$83834 \$74423 \$79979 \$83833 NWELL PWELL BULK MUX2_X1
X$166917 \$83851 \$74423 \$82562 \$84141 NWELL PWELL BULK MUX2_X1
X$166921 \$81182 \$74423 \$81493 \$81766 NWELL PWELL BULK MUX2_X1
X$166923 \$83868 \$74423 \$82831 \$84232 NWELL PWELL BULK MUX2_X1
X$166925 \$83863 \$74423 \$81806 \$84214 NWELL PWELL BULK MUX2_X1
X$166928 \$82806 \$74423 \$80771 \$83143 NWELL PWELL BULK MUX2_X1
X$166930 \$82888 \$74423 \$80098 \$82545 NWELL PWELL BULK MUX2_X1
X$166932 \$84174 \$74423 \$83140 \$84172 NWELL PWELL BULK MUX2_X1
X$166934 \$83843 \$74423 \$77655 \$84116 NWELL PWELL BULK MUX2_X1
X$166937 \$83159 \$74423 \$81483 \$82909 NWELL PWELL BULK MUX2_X1
X$166940 \$75564 \$74423 \$74843 \$75753 NWELL PWELL BULK MUX2_X1
X$166942 \$77471 \$74423 \$77169 \$77612 NWELL PWELL BULK MUX2_X1
X$166945 \$76514 \$74423 \$76515 \$76670 NWELL PWELL BULK MUX2_X1
X$166947 \$79408 \$74423 \$79404 \$79674 NWELL PWELL BULK MUX2_X1
X$166998 S0_AXI_RDATA[11] \$74436 NWELL PWELL BULK BUF_X1
X$167068 \$75225 \$75611 \$75716 \$74471 NWELL PWELL BULK HA_X1
X$167081 \$74476 \$75615 \$75910 NWELL PWELL BULK XNOR2_X1
X$167090 \$74629 \$74631 \$74480 NWELL PWELL BULK XNOR2_X1
X$167188 \$83832 \$74626 \$82552 \$84050 NWELL PWELL BULK MUX2_X1
X$167191 \$76203 \$74626 \$76515 \$76391 NWELL PWELL BULK MUX2_X1
X$167193 \$77705 \$74626 \$76995 \$77704 NWELL PWELL BULK MUX2_X1
X$167195 \$82875 \$74626 \$77367 \$82666 NWELL PWELL BULK MUX2_X1
X$167197 \$79743 \$74626 \$79336 \$79499 NWELL PWELL BULK MUX2_X1
X$167199 \$78632 \$74626 \$78298 \$78793 NWELL PWELL BULK MUX2_X1
X$167204 \$83445 \$74626 \$79979 \$83689 NWELL PWELL BULK MUX2_X1
X$167207 \$82902 \$74626 \$83140 \$83415 NWELL PWELL BULK MUX2_X1
X$167209 \$81496 \$74626 \$81493 \$82116 NWELL PWELL BULK MUX2_X1
X$167212 \$83869 \$74626 \$82831 \$83479 NWELL PWELL BULK MUX2_X1
X$167214 \$82571 \$74626 \$80771 \$83145 NWELL PWELL BULK MUX2_X1
X$167218 \$82722 \$74626 \$80098 \$83037 NWELL PWELL BULK MUX2_X1
X$167220 \$83730 \$74626 \$77655 \$83847 NWELL PWELL BULK MUX2_X1
X$167223 \$84153 \$74626 \$82562 \$83459 NWELL PWELL BULK MUX2_X1
X$167226 \$83451 \$74626 \$81840 \$83838 NWELL PWELL BULK MUX2_X1
X$167230 \$82913 \$74626 \$81483 \$82844 NWELL PWELL BULK MUX2_X1
X$167233 \$82907 \$74626 \$81806 \$83147 NWELL PWELL BULK MUX2_X1
X$167238 \$81592 \$74626 \$81146 \$81937 NWELL PWELL BULK MUX2_X1
X$167240 \$75845 \$74626 \$74843 \$76051 NWELL PWELL BULK MUX2_X1
X$167242 \$80140 \$74626 \$79404 \$80822 NWELL PWELL BULK MUX2_X1
X$167244 \$77170 \$74626 \$77169 \$77321 NWELL PWELL BULK MUX2_X1
X$167450 \$74819 \$75167 \$75312 NWELL PWELL BULK XNOR2_X1
X$167454 \$74822 \$74821 NWELL PWELL BULK INV_X1
X$167456 \$75544 \$75319 \$75172 \$74821 \$75171 NWELL PWELL BULK FA_X1
X$167459 \$74822 \$75319 \$74823 NWELL PWELL BULK XOR2_X1
X$167463 \$74823 \$75173 \$75324 NWELL PWELL BULK NOR2_X1
X$167473 S2_AXI_RDATA[9] \$74832 NWELL PWELL BULK BUF_X1
X$167481 S1_AXI_RDATA[26] \$74838 NWELL PWELL BULK BUF_X1
X$167575 \$75427 \$75581 \$74896 NWELL PWELL BULK OR2_X2
X$167599 \$75238 \$74906 \$75909 NWELL PWELL BULK XNOR2_X1
X$167606 \$74910 \$75375 NWELL PWELL BULK INV_X1
X$167611 \$74910 \$75907 \$75908 NWELL PWELL BULK XNOR2_X1
X$167744 \$75014 \$75324 \$75175 NWELL PWELL BULK XNOR2_X1
X$167801 \$75067 M2_AXI_RDATA[19] NWELL PWELL BULK BUF_X1
X$167905 \$75543 \$75173 \$75171 \$75318 NWELL PWELL BULK MUX2_X1
X$167912 \$75173 \$75172 \$75546 NWELL PWELL BULK NOR2_X1
X$167918 \$75546 \$75544 \$75173 \$75831 NWELL PWELL BULK AOI21_X1
X$167936 S0_AXI_RDATA[26] \$75187 NWELL PWELL BULK BUF_X1
X$167964 S0_AXI_RDATA[9] \$75199 NWELL PWELL BULK BUF_X1
X$167993 \$75222 M2_AXI_RDATA[21] NWELL PWELL BULK BUF_X1
X$168075 \$75278 \$76320 \$76179 \$75816 NWELL PWELL BULK DFF_X1
X$168147 \$75351 M0_AXI_RDATA[2] NWELL PWELL BULK BUF_X1
X$168161 \$75358 S2_AXI_WDATA[8] NWELL PWELL BULK BUF_X1
X$168251 \$75431 M0_AXI_RDATA[21] NWELL PWELL BULK BUF_X1
X$168280 \$75453 M2_AXI_RDATA[9] NWELL PWELL BULK BUF_X1
X$168287 \$75461 M1_AXI_RDATA[4] NWELL PWELL BULK BUF_X1
X$168345 \$75512 M0_AXI_RRESP[0] NWELL PWELL BULK BUF_X1
X$168354 \$75519 \$76315 \$76312 \$75816 NWELL PWELL BULK DFF_X1
X$168425 \$75582 \$76457 \$76758 \$76468 NWELL PWELL BULK DFF_X1
X$168428 \$76126 \$75800 \$75584 \$76468 NWELL PWELL BULK DFF_X1
X$168466 \$I175382 \$75611 \$75903 \$76270 NWELL PWELL BULK DFF_X1
X$168482 \$75626 S2_AXI_WDATA[18] NWELL PWELL BULK BUF_X1
X$168541 \$75958 \$75664 \$75822 \$75816 NWELL PWELL BULK DFF_X1
X$168581 S2_AXI_RDATA[26] \$75701 NWELL PWELL BULK BUF_X1
X$168650 \$75750 M1_AXI_RDATA[21] NWELL PWELL BULK BUF_X1
X$168663 \$75764 M1_AXI_RDATA[26] NWELL PWELL BULK BUF_X1
X$168678 S0_AXI_RDATA[24] \$75774 NWELL PWELL BULK BUF_X1
X$168693 S1_AXI_RDATA[24] \$75780 NWELL PWELL BULK BUF_X1
X$168709 \$75872 \$75871 \$75781 \$76468 NWELL PWELL BULK DFF_X1
X$168738 \$76096 \$75812 \$76091 \$76468 NWELL PWELL BULK DFF_X1
X$168743 \$81916 \$81244 \$81419 \$75816 NWELL PWELL BULK DFF_X1
X$168745 \$80563 \$80557 \$80559 \$75816 NWELL PWELL BULK DFF_X1
X$168748 \$80923 \$81237 \$80922 \$75816 NWELL PWELL BULK DFF_X1
X$168750 \$82299 \$82304 \$82298 \$75816 NWELL PWELL BULK DFF_X1
X$168753 \$82868 \$82523 \$82646 \$75816 NWELL PWELL BULK DFF_X1
X$168755 \$83913 \$83915 \$83912 \$75816 NWELL PWELL BULK DFF_X1
X$168757 \$83171 \$83540 \$83538 \$75816 NWELL PWELL BULK DFF_X1
X$168760 \$81925 \$82310 \$82312 \$75816 NWELL PWELL BULK DFF_X1
X$168763 \$80551 \$80919 \$80913 \$75816 NWELL PWELL BULK DFF_X1
X$168766 \$81811 \$81234 \$81553 \$75816 NWELL PWELL BULK DFF_X1
X$168768 \$80550 \$80428 \$80548 \$75816 NWELL PWELL BULK DFF_X1
X$168770 \$83812 \$83910 \$83908 \$75816 NWELL PWELL BULK DFF_X1
X$168772 \$82959 \$82866 \$82955 \$75816 NWELL PWELL BULK DFF_X1
X$168774 \$79463 \$78976 \$79090 \$75816 NWELL PWELL BULK DFF_X1
X$168777 \$79466 \$79462 \$79842 \$75816 NWELL PWELL BULK DFF_X1
X$168780 \$82193 \$82528 \$82648 \$75816 NWELL PWELL BULK DFF_X1
X$168782 \$81912 \$82185 \$82295 \$75816 NWELL PWELL BULK DFF_X1
X$168784 \$83813 \$83920 \$83917 \$75816 NWELL PWELL BULK DFF_X1
X$168786 \$82870 \$82642 \$82869 \$75816 NWELL PWELL BULK DFF_X1
X$168788 \$83556 \$83554 \$83549 \$75816 NWELL PWELL BULK DFF_X1
X$168790 \$76501 \$76337 \$76500 \$75816 NWELL PWELL BULK DFF_X1
X$168793 \$76182 \$76620 \$76617 \$75816 NWELL PWELL BULK DFF_X1
X$168799 \$75946 \$75944 \$76177 \$75816 NWELL PWELL BULK DFF_X1
X$168802 \$76178 \$76612 \$76499 \$75816 NWELL PWELL BULK DFF_X1
X$168806 \$76331 \$76326 \$76329 \$75816 NWELL PWELL BULK DFF_X1
X$168844 \$75835 \$76365 \$76189 \$76370 NWELL PWELL BULK DFF_X1
X$168848 S2_AXI_RDATA[21] \$75838 NWELL PWELL BULK BUF_X1
X$168862 \$75839 \$76195 \$76652 \$76202 NWELL PWELL BULK DFF_X1
X$168866 S1_AXI_RDATA[16] \$75844 NWELL PWELL BULK BUF_X1
X$168882 \$I176496 \$75845 \$76051 \$76202 NWELL PWELL BULK DFF_X1
X$168886 S0_AXI_RDATA[21] \$75858 NWELL PWELL BULK BUF_X1
X$168901 \$75860 \$76224 \$76223 \$76468 NWELL PWELL BULK DFF_X1
X$168910 \$75873 \$76825 \$76821 \$76229 NWELL PWELL BULK DFF_X1
X$168924 \$I177636 \$76239 \$75878 \$76229 NWELL PWELL BULK DFF_X1
X$168951 \$76803 \$76903 \$75897 NWELL PWELL BULK OR2_X1
X$168978 \$I177639 \$75907 \$76418 \$76270 NWELL PWELL BULK DFF_X1
X$168984 \$75908 \$75909 \$75910 \$76416 NWELL PWELL BULK NAND3_X2
X$169097 \$76013 \$76192 \$76010 \$76202 NWELL PWELL BULK DFF_X1
X$169113 \$76028 \$76026 \$76197 \$76202 NWELL PWELL BULK DFF_X1
X$169122 \$76031 \$76383 \$76201 \$76202 NWELL PWELL BULK DFF_X1
X$169133 \$76404 \$76400 \$76043 \$76202 NWELL PWELL BULK DFF_X1
X$169205 \$76136 M2_AXI_RDATA[26] NWELL PWELL BULK BUF_X1
X$169240 \$76231 \$76156 \$76155 \$76229 NWELL PWELL BULK DFF_X1
X$169273 \$76174 \$76236 \$76478 \$76229 NWELL PWELL BULK DFF_X1
X$169290 S2_AXI_RDATA[16] \$76185 NWELL PWELL BULK BUF_X1
X$169305 \$76508 \$76190 \$76367 \$76370 NWELL PWELL BULK DFF_X1
X$169312 S2_AXI_RDATA[24] \$76191 NWELL PWELL BULK CLKBUF_X2
X$169327 S0_AXI_RDATA[18] \$76198 NWELL PWELL BULK BUF_X1
X$169343 \$79534 \$79910 \$79908 \$76202 NWELL PWELL BULK DFF_X1
X$169348 \$I178606 \$76203 \$76391 \$76202 NWELL PWELL BULK DFF_X1
X$169353 \$77296 \$77584 \$77290 \$76202 NWELL PWELL BULK DFF_X1
X$169356 \$77004 \$76870 \$77002 \$76202 NWELL PWELL BULK DFF_X1
X$169358 \$77713 \$77841 \$77840 \$76202 NWELL PWELL BULK DFF_X1
X$169361 \$78163 \$78160 \$77835 \$76202 NWELL PWELL BULK DFF_X1
X$169364 \$78306 \$78477 \$78472 \$76202 NWELL PWELL BULK DFF_X1
X$169366 \$78483 \$78489 \$78193 \$76202 NWELL PWELL BULK DFF_X1
X$169368 \$I174544 \$76514 \$76670 \$76202 NWELL PWELL BULK DFF_X1
X$169370 \$I174537 \$77163 \$77297 \$76202 NWELL PWELL BULK DFF_X1
X$169373 \$76374 \$76643 \$76642 \$76202 NWELL PWELL BULK DFF_X1
X$169376 \$I176120 \$77285 \$77279 \$76202 NWELL PWELL BULK DFF_X1
X$169378 \$78022 \$78463 \$78464 \$76202 NWELL PWELL BULK DFF_X1
X$169380 \$76208 \$76408 \$76520 \$76202 NWELL PWELL BULK DFF_X1
X$169384 \$76701 \$76210 \$76694 \$76202 NWELL PWELL BULK DFF_X1
X$169388 \$79347 \$78638 \$79155 \$76202 NWELL PWELL BULK DFF_X1
X$169390 \$78827 \$79162 \$78825 \$76202 NWELL PWELL BULK DFF_X1
X$169392 \$77167 \$77166 \$77018 \$76202 NWELL PWELL BULK DFF_X1
X$169394 \$76518 \$76678 \$76676 \$76202 NWELL PWELL BULK DFF_X1
X$169397 \$76209 \$76522 \$77032 \$76202 NWELL PWELL BULK DFF_X1
X$169400 \$I177574 \$77469 \$77605 \$76202 NWELL PWELL BULK DFF_X1
X$169403 \$77468 \$77600 \$77860 \$76202 NWELL PWELL BULK DFF_X1
X$169406 \$I176665 \$77714 \$77846 \$76202 NWELL PWELL BULK DFF_X1
X$169411 \$78186 \$78026 \$78180 \$76202 NWELL PWELL BULK DFF_X1
X$169468 \$76219 \$76754 \$76930 NWELL PWELL BULK OR2_X2
X$169482 \$76226 \$76785 \$76782 \$76468 NWELL PWELL BULK DFF_X1
X$169485 \$76230 \$76494 \$76228 \$76229 NWELL PWELL BULK DFF_X1
X$169494 \$I175805 \$76565 \$77117 \$76229 NWELL PWELL BULK DFF_X1
X$169497 \$76853 \$77121 \$77125 \$76229 NWELL PWELL BULK DFF_X1
X$169500 \$77200 \$77448 \$77449 \$76229 NWELL PWELL BULK DFF_X1
X$169504 \$79297 \$78066 \$78248 \$76229 NWELL PWELL BULK DFF_X1
X$169506 \$I177825 \$77499 \$77201 \$76229 NWELL PWELL BULK DFF_X1
X$169509 \$77682 \$77496 \$77997 \$76229 NWELL PWELL BULK DFF_X1
X$169512 \$79793 \$80032 \$80380 \$76229 NWELL PWELL BULK DFF_X1
X$169514 \$77692 \$77431 \$77196 \$76229 NWELL PWELL BULK DFF_X1
X$169516 \$77444 \$77439 \$77199 \$76229 NWELL PWELL BULK DFF_X1
X$169519 \$77685 \$77129 \$77135 \$76229 NWELL PWELL BULK DFF_X1
X$169521 \$77436 \$77198 \$77430 \$76229 NWELL PWELL BULK DFF_X1
X$169523 \$78959 \$78964 \$78966 \$76229 NWELL PWELL BULK DFF_X1
X$169525 \$79697 \$79310 \$79305 \$76229 NWELL PWELL BULK DFF_X1
X$169527 \$79029 \$78690 \$78955 \$76229 NWELL PWELL BULK DFF_X1
X$169530 \$79030 \$78947 \$78952 \$76229 NWELL PWELL BULK DFF_X1
X$169532 \$78055 \$77990 \$77744 \$76229 NWELL PWELL BULK DFF_X1
X$169534 \$78265 \$78003 \$78001 \$76229 NWELL PWELL BULK DFF_X1
X$169536 \$80875 \$80801 \$80798 \$76229 NWELL PWELL BULK DFF_X1
X$169538 \$79406 \$79405 \$80025 \$76229 NWELL PWELL BULK DFF_X1
X$169540 \$I178179 \$78698 \$78930 \$76229 NWELL PWELL BULK DFF_X1
X$169542 \$80023 \$79680 \$79679 \$76229 NWELL PWELL BULK DFF_X1
X$169544 \$78616 \$78060 \$78615 \$76229 NWELL PWELL BULK DFF_X1
X$169547 \$78339 \$78054 \$78053 \$76229 NWELL PWELL BULK DFF_X1
X$169550 \$78344 \$78610 \$78612 \$76229 NWELL PWELL BULK DFF_X1
X$169553 \$I176022 \$78345 \$78928 \$76229 NWELL PWELL BULK DFF_X1
X$169640 \$I177772 \$76263 \$76262 \$76270 NWELL PWELL BULK DFF_X1
X$169649 \$76843 \$76844 \$76265 NWELL PWELL BULK OR2_X1
X$169666 \$I175860 \$76268 \$76269 \$76270 NWELL PWELL BULK DFF_X1
X$169676 \$I177620 \$77345 \$77348 \$76270 NWELL PWELL BULK DFF_X1
X$169678 \$I175855 \$77519 \$77879 \$76270 NWELL PWELL BULK DFF_X1
X$169683 \$I175875 \$76762 \$76763 \$76270 NWELL PWELL BULK DFF_X1
X$169686 \$I178203 \$77025 \$77028 \$76270 NWELL PWELL BULK DFF_X1
X$169689 \$I178133 \$78528 \$78529 \$76270 NWELL PWELL BULK DFF_X1
X$169692 \$I178159 \$79527 \$79190 \$76270 NWELL PWELL BULK DFF_X1
X$169694 \$I178134 \$77224 \$77225 \$76270 NWELL PWELL BULK DFF_X1
X$169696 \$I178221 \$77523 \$77228 \$76270 NWELL PWELL BULK DFF_X1
X$169698 \$I178137 \$78371 \$78514 \$76270 NWELL PWELL BULK DFF_X1
X$169701 \$I178136 \$79506 \$79178 \$76270 NWELL PWELL BULK DFF_X1
X$169703 \$I175859 \$79066 \$79438 \$76270 NWELL PWELL BULK DFF_X1
X$169706 \$I175893 \$79441 \$79439 \$76270 NWELL PWELL BULK DFF_X1
X$169710 \$I178138 \$78516 \$78518 \$76270 NWELL PWELL BULK DFF_X1
X$169713 \$I175840 \$80167 \$80170 \$76270 NWELL PWELL BULK DFF_X1
X$169716 \$I175844 \$79437 \$79525 \$76270 NWELL PWELL BULK DFF_X1
X$169719 \$I177621 \$79925 \$79930 \$76270 NWELL PWELL BULK DFF_X1
X$169721 \$I175861 \$78370 \$78526 \$76270 NWELL PWELL BULK DFF_X1
X$169723 \$I178143 \$77324 \$77619 \$76270 NWELL PWELL BULK DFF_X1
X$169725 \$I176532 \$81212 \$81294 \$76270 NWELL PWELL BULK DFF_X1
X$169727 \$I177671 \$80621 \$80627 \$76270 NWELL PWELL BULK DFF_X1
X$169729 \$I177658 \$80525 \$80987 \$76270 NWELL PWELL BULK DFF_X1
X$169732 \$I176535 \$80524 \$80522 \$76270 NWELL PWELL BULK DFF_X1
X$169735 \$I177672 \$80521 \$80665 \$76270 NWELL PWELL BULK DFF_X1
X$169737 \$I176529 \$80527 \$80628 \$76270 NWELL PWELL BULK DFF_X1
X$169740 \$I177763 \$81525 \$81636 \$76270 NWELL PWELL BULK DFF_X1
X$169742 \$I177734 \$81523 \$81522 \$76270 NWELL PWELL BULK DFF_X1
X$169893 \$81249 \$81567 \$81565 \$76370 NWELL PWELL BULK DFF_X1
X$169895 \$81429 \$81428 \$81930 \$76370 NWELL PWELL BULK DFF_X1
X$169897 \$81941 \$81928 \$81425 \$76370 NWELL PWELL BULK DFF_X1
X$169900 \$80580 \$80572 \$80074 \$76370 NWELL PWELL BULK DFF_X1
X$169903 \$81259 \$81261 \$80941 \$76370 NWELL PWELL BULK DFF_X1
X$169905 \$80434 \$80933 \$80567 \$76370 NWELL PWELL BULK DFF_X1
X$169907 \$80826 \$81421 \$80926 \$76370 NWELL PWELL BULK DFF_X1
X$169910 \$82981 \$82979 \$82972 \$76370 NWELL PWELL BULK DFF_X1
X$169913 \$82652 \$82530 \$82658 \$76370 NWELL PWELL BULK DFF_X1
X$169915 \$83945 \$83425 \$83941 \$76370 NWELL PWELL BULK DFF_X1
X$169920 \$77267 \$77460 \$77268 \$76370 NWELL PWELL BULK DFF_X1
X$169922 \$76639 \$76863 \$76987 \$76370 NWELL PWELL BULK DFF_X1
X$169925 \$79483 \$79478 \$79328 \$76370 NWELL PWELL BULK DFF_X1
X$169927 \$79329 \$80073 \$79856 \$76370 NWELL PWELL BULK DFF_X1
X$169930 \$79333 \$79492 \$79331 \$76370 NWELL PWELL BULK DFF_X1
X$169932 \$78628 \$78782 \$78781 \$76370 NWELL PWELL BULK DFF_X1
X$169934 \$79847 \$79735 \$80204 \$76370 NWELL PWELL BULK DFF_X1
X$169937 \$78785 \$78016 \$78424 \$76370 NWELL PWELL BULK DFF_X1
X$169939 \$80213 \$79866 \$79863 \$76370 NWELL PWELL BULK DFF_X1
X$169942 \$79742 \$79495 \$79332 \$76370 NWELL PWELL BULK DFF_X1
X$169944 \$80220 \$80218 \$79870 \$76370 NWELL PWELL BULK DFF_X1
X$169949 \$77813 \$78017 \$78137 \$76370 NWELL PWELL BULK DFF_X1
X$169952 \$77564 \$77566 \$77266 \$76370 NWELL PWELL BULK DFF_X1
X$169955 \$78131 \$78128 \$78410 \$76370 NWELL PWELL BULK DFF_X1
X$169957 \$78623 \$79105 \$79104 \$76370 NWELL PWELL BULK DFF_X1
X$169959 \$80436 \$80437 \$80585 \$76370 NWELL PWELL BULK DFF_X1
X$169961 \$I178666 \$82194 \$82320 \$76370 NWELL PWELL BULK DFF_X1
X$169963 \$83816 \$83426 \$83251 \$76370 NWELL PWELL BULK DFF_X1
X$170027 \$76416 S2_AXI_WVALID NWELL PWELL BULK BUF_X1
X$170047 \$76434 \$76713 \$76712 \$76525 NWELL PWELL BULK DFF_X1
X$170088 \$76481 \$76482 \$76553 \$76468 NWELL PWELL BULK DFF_X1
X$170092 \$79652 \$80006 \$80000 \$76468 NWELL PWELL BULK DFF_X1
X$170094 \$78670 \$78672 \$78945 \$76468 NWELL PWELL BULK DFF_X1
X$170096 \$80053 \$79782 \$80044 \$76468 NWELL PWELL BULK DFF_X1
X$170098 \$79311 \$80066 \$80060 \$76468 NWELL PWELL BULK DFF_X1
X$170100 \$77983 \$77686 \$77681 \$76468 NWELL PWELL BULK DFF_X1
X$170102 \$76817 \$77143 \$76555 \$76468 NWELL PWELL BULK DFF_X1
X$170107 \$77961 \$77483 \$77661 \$76468 NWELL PWELL BULK DFF_X1
X$170109 \$78280 \$77673 \$77962 \$76468 NWELL PWELL BULK DFF_X1
X$170112 \$76547 \$76780 \$76775 \$76468 NWELL PWELL BULK DFF_X1
X$170115 \$77184 \$77953 \$77735 \$76468 NWELL PWELL BULK DFF_X1
X$170117 \$77381 \$77378 \$77375 \$76468 NWELL PWELL BULK DFF_X1
X$170119 \$78608 \$78604 \$78602 \$76468 NWELL PWELL BULK DFF_X1
X$170121 \$78273 \$78581 \$78332 \$76468 NWELL PWELL BULK DFF_X1
X$170126 \$78680 \$78279 \$78334 \$76468 NWELL PWELL BULK DFF_X1
X$170128 \$77651 \$77182 \$77940 \$76468 NWELL PWELL BULK DFF_X1
X$170131 \$77478 \$77181 \$77637 \$76468 NWELL PWELL BULK DFF_X1
X$170134 \$77476 \$77920 \$77630 \$76468 NWELL PWELL BULK DFF_X1
X$170137 \$77426 \$77421 \$77195 \$76468 NWELL PWELL BULK DFF_X1
X$170139 \$77191 \$77676 \$77485 \$76468 NWELL PWELL BULK DFF_X1
X$170141 \$77410 \$77186 \$77189 \$76468 NWELL PWELL BULK DFF_X1
X$170143 \$76544 \$77103 \$77099 \$76468 NWELL PWELL BULK DFF_X1
X$170146 \$79250 \$78570 \$78563 \$76468 NWELL PWELL BULK DFF_X1
X$170149 \$78667 \$78668 \$78923 \$76468 NWELL PWELL BULK DFF_X1
X$170235 \$77624 \$77173 \$77331 \$76525 NWELL PWELL BULK DFF_X1
X$170239 \$77894 \$77724 \$77889 \$76525 NWELL PWELL BULK DFF_X1
X$170242 \$78534 \$78039 \$78038 \$76525 NWELL PWELL BULK DFF_X1
X$170244 \$82010 \$82001 \$82005 \$76525 NWELL PWELL BULK DFF_X1
X$170247 \$82405 \$82208 \$82398 \$76525 NWELL PWELL BULK DFF_X1
X$170250 \$80645 \$80092 \$80630 \$76525 NWELL PWELL BULK DFF_X1
X$170253 \$80639 \$80299 \$80301 \$76525 NWELL PWELL BULK DFF_X1
X$170255 \$81322 \$81638 \$81315 \$76525 NWELL PWELL BULK DFF_X1
X$170257 \$81028 \$81657 \$81340 \$76525 NWELL PWELL BULK DFF_X1
X$170259 \$81026 \$81332 \$81331 \$76525 NWELL PWELL BULK DFF_X1
X$170262 \$80646 \$80311 \$80308 \$76525 NWELL PWELL BULK DFF_X1
X$170265 \$80450 \$80095 \$80315 \$76525 NWELL PWELL BULK DFF_X1
X$170268 \$I179032 \$82722 \$83037 \$76525 NWELL PWELL BULK DFF_X1
X$170270 \$78648 \$79201 \$78646 \$76525 NWELL PWELL BULK DFF_X1
X$170272 \$78998 \$79581 \$79939 \$76525 NWELL PWELL BULK DFF_X1
X$170274 \$78519 \$78513 \$78511 \$76525 NWELL PWELL BULK DFF_X1
X$170276 \$78501 \$78843 \$78487 \$76525 NWELL PWELL BULK DFF_X1
X$170278 \$I176727 \$77170 \$77321 \$76525 NWELL PWELL BULK DFF_X1
X$170280 \$77038 \$76879 \$77042 \$76525 NWELL PWELL BULK DFF_X1
X$170282 \$80286 \$79762 \$79918 \$76525 NWELL PWELL BULK DFF_X1
X$170285 \$80291 \$79922 \$79764 \$76525 NWELL PWELL BULK DFF_X1
X$170288 \$78642 \$79547 \$79175 \$76525 NWELL PWELL BULK DFF_X1
X$170292 \$79579 \$79199 \$79355 \$76525 NWELL PWELL BULK DFF_X1
X$170295 \$79353 \$79933 \$79352 \$76525 NWELL PWELL BULK DFF_X1
X$170298 \$79566 \$79562 \$79561 \$76525 NWELL PWELL BULK DFF_X1
X$170301 \$78848 \$79189 \$78845 \$76525 NWELL PWELL BULK DFF_X1
X$170303 \$79177 \$79164 \$78640 \$76525 NWELL PWELL BULK DFF_X1
X$170305 \$I177568 \$77875 \$77719 \$76525 NWELL PWELL BULK DFF_X1
X$170307 \$I177571 \$77471 \$77612 \$76525 NWELL PWELL BULK DFF_X1
X$170372 \$76734 \$76532 \$76533 NWELL PWELL BULK OR2_X2
X$170536 S0_AXI_RDATA[16] \$76686 NWELL PWELL BULK BUF_X1
X$170623 \$76786 M2_AXI_RDATA[23] NWELL PWELL BULK BUF_X1
X$170641 \$I176224 \$76814 \$77091 \$76921 NWELL PWELL BULK DFF_X1
X$170663 \$76824 M1_AXI_RDATA[16] NWELL PWELL BULK BUF_X1
X$170686 \$76851 M1_AXI_RDATA[18] NWELL PWELL BULK BUF_X1
X$170695 S2_AXI_RDATA[18] \$76861 NWELL PWELL BULK BUF_X1
X$170732 S1_AXI_RDATA[23] \$76896 NWELL PWELL BULK BUF_X1
X$170771 S0_AXI_RDATA[10] \$76910 NWELL PWELL BULK BUF_X1
X$170790 \$I176109 \$81198 \$81196 \$76921 NWELL PWELL BULK DFF_X1
X$170793 \$I175931 \$79422 \$79249 \$76921 NWELL PWELL BULK DFF_X1
X$170795 \$I175916 \$79949 \$79806 \$76921 NWELL PWELL BULK DFF_X1
X$170797 \$I178024 \$79430 \$79940 \$76921 NWELL PWELL BULK DFF_X1
X$170799 \$I178012 \$79051 \$78861 \$76921 NWELL PWELL BULK DFF_X1
X$170802 \$I176070 \$79055 \$78719 \$76921 NWELL PWELL BULK DFF_X1
X$170804 \$I178382 \$81004 \$81007 \$76921 NWELL PWELL BULK DFF_X1
X$170806 \$I177668 \$80162 \$80163 \$76921 NWELL PWELL BULK DFF_X1
X$170808 \$I178086 \$79212 \$79216 \$76921 NWELL PWELL BULK DFF_X1
X$170810 \$I175485 \$78560 \$78858 \$76921 NWELL PWELL BULK DFF_X1
X$170813 \$I178374 \$79812 \$80302 \$76921 NWELL PWELL BULK DFF_X1
X$170816 \$I176061 \$77066 \$77392 \$76921 NWELL PWELL BULK DFF_X1
X$170819 \$I176059 \$77918 \$77919 \$76921 NWELL PWELL BULK DFF_X1
X$170821 \$I178042 \$78073 \$78212 \$76921 NWELL PWELL BULK DFF_X1
X$170824 \$I178272 \$82254 \$82415 \$76921 NWELL PWELL BULK DFF_X1
X$170826 \$I178273 \$81516 \$81680 \$76921 NWELL PWELL BULK DFF_X1
X$170828 \$I176223 \$83488 \$83733 \$76921 NWELL PWELL BULK DFF_X1
X$170831 \$I175563 \$83493 \$84133 \$76921 NWELL PWELL BULK DFF_X1
X$170834 \$I175639 \$83495 \$83112 \$76921 NWELL PWELL BULK DFF_X1
X$170836 \$I176735 \$82031 \$82591 \$76921 NWELL PWELL BULK DFF_X1
X$170839 \$I175656 \$81200 \$80895 \$76921 NWELL PWELL BULK DFF_X1
X$170842 \$I177670 \$80511 \$80706 \$76921 NWELL PWELL BULK DFF_X1
X$170844 \$I178399 \$82251 \$82062 \$76921 NWELL PWELL BULK DFF_X1
X$170846 \$I177669 \$80156 \$80724 \$76921 NWELL PWELL BULK DFF_X1
X$170848 \$I178444 \$80893 \$81707 \$76921 NWELL PWELL BULK DFF_X1
X$170851 \$I177942 \$78360 \$78359 \$76921 NWELL PWELL BULK DFF_X1
X$170854 \$I176219 \$80153 \$80336 \$76921 NWELL PWELL BULK DFF_X1
X$170857 \$I178985 \$77211 \$77656 \$76921 NWELL PWELL BULK DFF_X1
X$170860 \$I176176 \$77773 \$77931 \$76921 NWELL PWELL BULK DFF_X1
X$170917 S2_AXI_WREADY \$76936 NWELL PWELL BULK BUF_X1
X$171008 \$77008 S2_AXI_WDATA[2] NWELL PWELL BULK BUF_X1
X$171028 \$77024 M2_AXI_RRESP[0] NWELL PWELL BULK BUF_X1
X$171149 S0_AXI_RDATA[23] \$77139 NWELL PWELL BULK BUF_X1
X$171162 S0_AXI_RDATA[1] \$77142 NWELL PWELL BULK BUF_X1
X$171230 S1_AXI_RDATA[15] \$77172 NWELL PWELL BULK BUF_X1
X$171244 S0_AXI_RDATA[15] \$77175 NWELL PWELL BULK BUF_X1
X$171395 \$I176080 \$77278 \$77276 \$77572 NWELL PWELL BULK DFF_X1
X$171431 \$77304 S2_AXI_WDATA[14] NWELL PWELL BULK BUF_X1
X$171523 \$77396 M1_AXI_RDATA[23] NWELL PWELL BULK BUF_X1
X$171617 S0_AXI_RDATA[31] \$77481 NWELL PWELL BULK BUF_X1
X$171676 \$77927 \$77925 \$77512 NWELL PWELL BULK OR2_X2
X$171732 \$I176087 \$79743 \$79499 \$77572 NWELL PWELL BULK DFF_X1
X$171734 \$I176082 \$79883 \$79747 \$77572 NWELL PWELL BULK DFF_X1
X$171737 \$I177907 \$78635 \$78439 \$77572 NWELL PWELL BULK DFF_X1
X$171739 \$I177909 \$79503 \$79129 \$77572 NWELL PWELL BULK DFF_X1
X$171741 \$I177902 \$79744 \$80232 \$77572 NWELL PWELL BULK DFF_X1
X$171743 \$I178630 \$78632 \$78793 \$77572 NWELL PWELL BULK DFF_X1
X$171745 \$I177896 \$78983 \$79118 \$77572 NWELL PWELL BULK DFF_X1
X$171748 \$79754 \$79899 \$79900 \$77572 NWELL PWELL BULK DFF_X1
X$171750 \$80272 \$80270 \$80265 \$77572 NWELL PWELL BULK DFF_X1
X$171753 \$78636 \$79141 \$79138 \$77572 NWELL PWELL BULK DFF_X1
X$171755 \$78989 \$79151 \$79145 \$77572 NWELL PWELL BULK DFF_X1
X$171757 \$80083 \$80258 \$80081 \$77572 NWELL PWELL BULK DFF_X1
X$171760 \$79344 \$79517 \$79514 \$77572 NWELL PWELL BULK DFF_X1
X$171762 \$I177900 \$77702 \$77818 \$77572 NWELL PWELL BULK DFF_X1
X$171765 \$I177899 \$77705 \$77704 \$77572 NWELL PWELL BULK DFF_X1
X$171769 \$I177992 \$81144 \$81433 \$77572 NWELL PWELL BULK DFF_X1
X$171772 \$I176390 \$81592 \$81937 \$77572 NWELL PWELL BULK DFF_X1
X$171775 \$I176413 \$83823 \$84240 \$77572 NWELL PWELL BULK DFF_X1
X$171777 \$I176336 \$82875 \$82666 \$77572 NWELL PWELL BULK DFF_X1
X$171780 \$I177976 \$83261 \$83255 \$77572 NWELL PWELL BULK DFF_X1
X$171783 \$80440 \$80077 \$80587 \$77572 NWELL PWELL BULK DFF_X1
X$171786 \$80964 \$81286 \$80954 \$77572 NWELL PWELL BULK DFF_X1
X$171789 \$81291 \$81610 \$81601 \$77572 NWELL PWELL BULK DFF_X1
X$171791 \$80442 \$80444 \$80607 \$77572 NWELL PWELL BULK DFF_X1
X$171793 \$I176153 \$78300 \$78146 \$77572 NWELL PWELL BULK DFF_X1
X$171795 \$78452 \$78302 \$78455 \$77572 NWELL PWELL BULK DFF_X1
X$171797 \$80830 \$80832 \$80833 \$77572 NWELL PWELL BULK DFF_X1
X$171800 \$I176389 \$81142 \$81271 \$77572 NWELL PWELL BULK DFF_X1
X$171802 \$81964 \$81962 \$81958 \$77572 NWELL PWELL BULK DFF_X1
X$171867 \$77604 M0_AXI_RDATA[18] NWELL PWELL BULK BUF_X1
X$171904 \$77640 M2_AXI_RDATA[18] NWELL PWELL BULK BUF_X1
X$171911 \$77649 M1_AXI_RDATA[24] NWELL PWELL BULK BUF_X1
X$171952 S0_AXI_RDATA[30] \$77679 NWELL PWELL BULK BUF_X1
X$172010 \$77708 M0_AXI_RDATA[15] NWELL PWELL BULK BUF_X1
X$172016 S0_AXI_RDATA[7] \$77712 NWELL PWELL BULK BUF_X1
X$172040 \$77721 M0_AXI_RDATA[26] NWELL PWELL BULK BUF_X1
X$172145 \$I176131 \$78087 \$77793 \$78086 NWELL PWELL BULK DFF_X1
X$172203 \$77848 S2_AXI_WSTRB[3] NWELL PWELL BULK BUF_X1
X$172216 \$77867 M2_AXI_RDATA[24] NWELL PWELL BULK BUF_X1
X$172369 S2_AXI_RDATA[12] \$78027 NWELL PWELL BULK BUF_X1
X$172394 \$78043 \$78327 \$78336 NWELL PWELL BULK OR2_X2
X$172398 S1_AXI_RDATA[28] \$78052 NWELL PWELL BULK BUF_X1
X$172441 \$I176044 \$83879 \$83876 \$78069 NWELL PWELL BULK DFF_X1
X$172443 \$I176054 \$83486 \$83741 \$78069 NWELL PWELL BULK DFF_X1
X$172445 \$I175495 \$80802 \$80492 \$78069 NWELL PWELL BULK DFF_X1
X$172447 \$I178364 \$81189 \$81743 \$78069 NWELL PWELL BULK DFF_X1
X$172449 \$I178224 \$80498 \$81058 \$78069 NWELL PWELL BULK DFF_X1
X$172451 \$I178418 \$82246 \$82450 \$78069 NWELL PWELL BULK DFF_X1
X$172453 \$I178193 \$81191 \$81741 \$78069 NWELL PWELL BULK DFF_X1
X$172455 \$I178415 \$82072 \$81193 \$78069 NWELL PWELL BULK DFF_X1
X$172457 \$I177934 \$80506 \$80149 \$78069 NWELL PWELL BULK DFF_X1
X$172460 \$I178416 \$80889 \$80501 \$78069 NWELL PWELL BULK DFF_X1
X$172462 \$I178225 \$80147 \$80348 \$78069 NWELL PWELL BULK DFF_X1
X$172465 \$I176026 \$80496 \$80495 \$78069 NWELL PWELL BULK DFF_X1
X$172467 \$I178359 \$80794 \$80878 \$78069 NWELL PWELL BULK DFF_X1
X$172470 \$I175406 \$82070 \$81504 \$78069 NWELL PWELL BULK DFF_X1
X$172475 \$I178041 \$83207 \$83482 \$78069 NWELL PWELL BULK DFF_X1
X$172477 \$I175933 \$82924 \$83141 \$78069 NWELL PWELL BULK DFF_X1
X$172479 \$I178036 \$82585 \$82861 \$78069 NWELL PWELL BULK DFF_X1
X$172482 \$I176178 \$82590 \$82838 \$78069 NWELL PWELL BULK DFF_X1
X$172484 \$I174553 \$79409 \$79654 \$78069 NWELL PWELL BULK DFF_X1
X$172486 \$I179065 \$80141 \$79999 \$78069 NWELL PWELL BULK DFF_X1
X$172488 \$I177844 \$79040 \$79799 \$78069 NWELL PWELL BULK DFF_X1
X$172491 \$I174495 \$79412 \$79651 \$78069 NWELL PWELL BULK DFF_X1
X$172493 \$I177849 \$78712 \$78706 \$78069 NWELL PWELL BULK DFF_X1
X$172495 \$I174379 \$78355 \$78352 \$78069 NWELL PWELL BULK DFF_X1
X$172498 \$I174494 \$78713 \$78594 \$78069 NWELL PWELL BULK DFF_X1
X$172501 \$I177857 \$79613 \$79043 \$78069 NWELL PWELL BULK DFF_X1
X$172504 \$I177945 \$79049 \$79047 \$78069 NWELL PWELL BULK DFF_X1
X$172507 \$I177850 \$79420 \$79976 \$78069 NWELL PWELL BULK DFF_X1
X$172509 \$I177851 \$79417 \$79414 \$78069 NWELL PWELL BULK DFF_X1
X$172512 \$I178987 \$78228 \$78231 \$78069 NWELL PWELL BULK DFF_X1
X$172555 \$78074 M2_AXI_RDATA[15] NWELL PWELL BULK BUF_X1
X$172561 \$I179102 \$78079 \$78194 \$78376 NWELL PWELL BULK DFF_X1
X$172568 \$I177386 \$82615 \$82997 \$78086 NWELL PWELL BULK DFF_X1
X$172570 \$I177494 \$83234 \$83233 \$78086 NWELL PWELL BULK DFF_X1
X$172573 \$I174511 \$83545 \$83524 \$78086 NWELL PWELL BULK DFF_X1
X$172576 \$I175243 \$82951 \$82286 \$78086 NWELL PWELL BULK DFF_X1
X$172578 \$I177291 \$82960 \$82624 \$78086 NWELL PWELL BULK DFF_X1
X$172581 \$I177313 \$82282 \$82280 \$78086 NWELL PWELL BULK DFF_X1
X$172583 \$I177019 \$81546 \$81542 \$78086 NWELL PWELL BULK DFF_X1
X$172586 \$I175271 \$82619 \$82675 \$78086 NWELL PWELL BULK DFF_X1
X$172588 \$I177219 \$81228 \$81915 \$78086 NWELL PWELL BULK DFF_X1
X$172591 \$I177020 \$82285 \$82283 \$78086 NWELL PWELL BULK DFF_X1
X$172593 \$I176723 \$81226 \$81543 \$78086 NWELL PWELL BULK DFF_X1
X$172595 \$I177350 \$83523 \$83250 \$78086 NWELL PWELL BULK DFF_X1
X$172597 \$I175238 \$80545 \$80542 \$78086 NWELL PWELL BULK DFF_X1
X$172599 \$I174817 \$81222 \$81264 \$78086 NWELL PWELL BULK DFF_X1
X$172603 \$I178908 \$81550 \$81549 \$78086 NWELL PWELL BULK DFF_X1
X$172606 \$I177199 \$82289 \$82663 \$78086 NWELL PWELL BULK DFF_X1
X$172608 \$I176307 \$78749 \$78748 \$78086 NWELL PWELL BULK DFF_X1
X$172611 \$I178810 \$79088 \$79086 \$78086 NWELL PWELL BULK DFF_X1
X$172614 \$I178838 \$78759 \$79455 \$78086 NWELL PWELL BULK DFF_X1
X$172617 \$I176396 \$78751 \$78772 \$78086 NWELL PWELL BULK DFF_X1
X$172620 \$I178974 \$82631 \$82954 \$78086 NWELL PWELL BULK DFF_X1
X$172624 \$I177364 \$80540 \$80583 \$78086 NWELL PWELL BULK DFF_X1
X$172626 \$I174678 \$80909 \$80945 \$78086 NWELL PWELL BULK DFF_X1
X$172629 \$I175484 \$80599 \$80536 \$78086 NWELL PWELL BULK DFF_X1
X$172632 \$I177348 \$81936 \$81598 \$78086 NWELL PWELL BULK DFF_X1
X$172635 \$I176963 \$78747 \$78744 \$78086 NWELL PWELL BULK DFF_X1
X$172637 \$I176985 \$79834 \$79468 \$78086 NWELL PWELL BULK DFF_X1
X$172639 \$I176135 \$79839 \$79454 \$78086 NWELL PWELL BULK DFF_X1
X$172641 \$I176315 \$78742 \$78799 \$78086 NWELL PWELL BULK DFF_X1
X$172771 \$78185 S2_AXI_WDATA[26] NWELL PWELL BULK BUF_X1
X$172814 \$78216 M0_AXI_RDATA[16] NWELL PWELL BULK BUF_X1
X$172824 \$78901 \$78549 \$78223 NWELL PWELL BULK OR2_X2
X$172895 \$78961 \$78593 \$78283 \$78674 NWELL PWELL BULK DFF_X1
X$172900 S2_AXI_RDATA[15] \$78290 NWELL PWELL BULK BUF_X1
X$172982 S0_AXI_RDATA[0] \$78342 NWELL PWELL BULK BUF_X1
X$173025 \$78361 M2_AXI_RDATA[7] NWELL PWELL BULK BUF_X1
X$173046 \$79392 \$79729 \$78366 NWELL PWELL BULK OR2_X1
X$173059 \$78368 M2_AXI_RDATA[16] NWELL PWELL BULK BUF_X1
X$173085 \$I175847 \$83903 \$83598 \$78376 NWELL PWELL BULK DFF_X1
X$173087 \$I175462 \$82942 \$82709 \$78376 NWELL PWELL BULK DFF_X1
X$173090 \$I177072 \$83521 \$83253 \$78376 NWELL PWELL BULK DFF_X1
X$173093 \$I175454 \$82275 \$82328 \$78376 NWELL PWELL BULK DFF_X1
X$173096 \$I175846 \$83225 \$83023 \$78376 NWELL PWELL BULK DFF_X1
X$173098 \$I177046 \$81216 \$81214 \$78376 NWELL PWELL BULK DFF_X1
X$173101 \$I177179 \$82272 \$82331 \$78376 NWELL PWELL BULK DFF_X1
X$173103 \$I175476 \$82612 \$82724 \$78376 NWELL PWELL BULK DFF_X1
X$173106 \$I176128 \$83222 \$82732 \$78376 NWELL PWELL BULK DFF_X1
X$173108 \$I175874 \$83901 \$83899 \$78376 NWELL PWELL BULK DFF_X1
X$173110 \$I175490 \$82725 \$82610 \$78376 NWELL PWELL BULK DFF_X1
X$173113 \$I176111 \$82336 \$82343 \$78376 NWELL PWELL BULK DFF_X1
X$173115 \$I177069 \$83904 \$84286 \$78376 NWELL PWELL BULK DFF_X1
X$173117 \$I176885 \$79819 \$79904 \$78376 NWELL PWELL BULK DFF_X1
X$173119 \$I176947 \$79071 \$78730 \$78376 NWELL PWELL BULK DFF_X1
X$173121 \$I176624 \$79446 \$79445 \$78376 NWELL PWELL BULK DFF_X1
X$173123 \$I176512 \$80243 \$80178 \$78376 NWELL PWELL BULK DFF_X1
X$173125 \$I175698 \$79827 \$79884 \$78376 NWELL PWELL BULK DFF_X1
X$173127 \$I175449 \$79448 \$79447 \$78376 NWELL PWELL BULK DFF_X1
X$173129 \$I175670 \$78488 \$78497 \$78376 NWELL PWELL BULK DFF_X1
X$173132 \$I175696 \$79450 \$79482 \$78376 NWELL PWELL BULK DFF_X1
X$173134 \$I175487 \$80185 \$80532 \$78376 NWELL PWELL BULK DFF_X1
X$173136 \$I177048 \$80610 \$80529 \$78376 NWELL PWELL BULK DFF_X1
X$173139 \$I177624 \$81968 \$81627 \$78376 NWELL PWELL BULK DFF_X1
X$173142 \$I177185 \$81535 \$81219 \$78376 NWELL PWELL BULK DFF_X1
X$173145 \$I177177 \$81606 \$81613 \$78376 NWELL PWELL BULK DFF_X1
X$173148 \$I175474 \$81531 \$80967 \$78376 NWELL PWELL BULK DFF_X1
X$173150 \$I177371 \$80184 \$80236 \$78376 NWELL PWELL BULK DFF_X1
X$173153 \$I177133 \$78812 \$78496 \$78376 NWELL PWELL BULK DFF_X1
X$173215 S2_AXI_RDATA[23] \$78418 NWELL PWELL BULK BUF_X1
X$173255 \$78450 S2_AXI_WDATA[27] NWELL PWELL BULK BUF_X1
X$173501 S1_AXI_RDATA[31] \$78643 NWELL PWELL BULK BUF_X1
X$173520 \$78879 \$78651 \$78649 \$79245 NWELL PWELL BULK DFF_X1
X$173560 \$80116 \$80019 \$80012 \$78674 NWELL PWELL BULK DFF_X1
X$173563 \$80119 \$80405 \$80029 \$78674 NWELL PWELL BULK DFF_X1
X$173566 \$79287 \$78675 \$78963 \$78674 NWELL PWELL BULK DFF_X1
X$173568 \$80423 \$80123 \$80422 \$78674 NWELL PWELL BULK DFF_X1
X$173571 \$80733 \$80040 \$80036 \$78674 NWELL PWELL BULK DFF_X1
X$173574 \$79383 \$79020 \$79282 \$78674 NWELL PWELL BULK DFF_X1
X$173577 \$81466 \$81170 \$81753 \$78674 NWELL PWELL BULK DFF_X1
X$173580 \$81737 \$82083 \$82073 \$78674 NWELL PWELL BULK DFF_X1
X$173583 \$I175220 \$83851 \$84141 \$78674 NWELL PWELL BULK DFF_X1
X$173586 \$I174784 \$84153 \$83459 \$78674 NWELL PWELL BULK DFF_X1
X$173589 \$82221 \$82561 \$82770 \$78674 NWELL PWELL BULK DFF_X1
X$173591 \$I179130 \$83730 \$83847 \$78674 NWELL PWELL BULK DFF_X1
X$173593 \$80862 \$81120 \$81122 \$78674 NWELL PWELL BULK DFF_X1
X$173596 \$81171 \$80467 \$81114 \$78674 NWELL PWELL BULK DFF_X1
X$173599 \$82500 \$82791 \$82785 \$78674 NWELL PWELL BULK DFF_X1
X$173603 \$81775 \$81411 \$81409 \$78674 NWELL PWELL BULK DFF_X1
X$173606 \$80750 \$80471 \$80746 \$78674 NWELL PWELL BULK DFF_X1
X$173608 \$82464 \$82461 \$82453 \$78674 NWELL PWELL BULK DFF_X1
X$173610 \$81390 \$81460 \$81394 \$78674 NWELL PWELL BULK DFF_X1
X$173613 \$81468 \$81412 \$81764 \$78674 NWELL PWELL BULK DFF_X1
X$173615 \$81850 \$82132 \$82507 \$78674 NWELL PWELL BULK DFF_X1
X$173617 \$82228 \$82798 \$82568 \$78674 NWELL PWELL BULK DFF_X1
X$173619 \$80722 \$80714 \$80709 \$78674 NWELL PWELL BULK DFF_X1
X$173622 \$I175236 \$84174 \$84172 \$78674 NWELL PWELL BULK DFF_X1
X$173624 \$I174791 \$83461 \$83187 \$78674 NWELL PWELL BULK DFF_X1
X$173626 \$I179220 \$83134 \$83132 \$78674 NWELL PWELL BULK DFF_X1
X$173628 \$I175241 \$82902 \$83415 \$78674 NWELL PWELL BULK DFF_X1
X$173630 \$I179206 \$83192 \$83762 \$78674 NWELL PWELL BULK DFF_X1
X$173632 \$I175754 \$83195 \$83411 \$78674 NWELL PWELL BULK DFF_X1
X$173662 S1_AXI_RDATA[30] \$78686 NWELL PWELL BULK BUF_X1
X$173841 \$78820 S2_AXI_WDATA[12] NWELL PWELL BULK BUF_X1
X$173907 \$78867 M1_AXI_RDATA[31] NWELL PWELL BULK BUF_X1
X$173945 S0_AXI_RDATA[12] \$78920 NWELL PWELL BULK BUF_X1
X$174014 S2_AXI_RDATA[31] \$78978 NWELL PWELL BULK BUF_X1
X$174058 S1_AXI_RDATA[29] \$78994 NWELL PWELL BULK BUF_X1
X$174085 \$79010 \$79992 \$79996 \$79245 NWELL PWELL BULK DFF_X1
X$174101 \$79668 \$79378 \$79017 NWELL PWELL BULK OR2_X2
X$174138 \$79037 M1_AXI_RDATA[15] NWELL PWELL BULK BUF_X1
X$174182 \$79230 \$79362 \$79059 NWELL PWELL BULK OR2_X2
X$174242 \$79122 S2_AXI_WDATA[15] NWELL PWELL BULK BUF_X1
X$174277 S0_AXI_RDATA[29] \$79146 NWELL PWELL BULK BUF_X1
X$174305 S0_AXI_RDATA[28] \$79157 NWELL PWELL BULK BUF_X1
X$174337 \$79180 M2_AXI_RDATA[31] NWELL PWELL BULK BUF_X1
X$174358 S1_AXI_RDATA[7] \$79194 NWELL PWELL BULK BUF_X1
X$174394 \$79207 M2_AXI_RDATA[29] NWELL PWELL BULK BUF_X1
X$174445 \$I174772 \$83111 \$83109 \$79245 NWELL PWELL BULK DFF_X1
X$174447 \$81097 \$80860 \$81093 \$79245 NWELL PWELL BULK DFF_X1
X$174450 \$80699 \$80377 \$80113 \$79245 NWELL PWELL BULK DFF_X1
X$174452 \$81456 \$81453 \$81454 \$79245 NWELL PWELL BULK DFF_X1
X$174455 \$80693 \$80690 \$80692 \$79245 NWELL PWELL BULK DFF_X1
X$174457 \$81457 \$81458 \$81722 \$79245 NWELL PWELL BULK DFF_X1
X$174461 \$I178993 \$82218 \$82556 \$79245 NWELL PWELL BULK DFF_X1
X$174463 \$80687 \$80362 \$80369 \$79245 NWELL PWELL BULK DFF_X1
X$174466 \$80104 \$79977 \$80332 \$79245 NWELL PWELL BULK DFF_X1
X$174470 \$80099 \$79948 \$79951 \$79245 NWELL PWELL BULK DFF_X1
X$174473 \$79257 \$79370 \$79638 \$79245 NWELL PWELL BULK DFF_X1
X$174476 \$79247 \$79369 \$79635 \$79245 NWELL PWELL BULK DFF_X1
X$174479 \$I175049 \$82898 \$82750 \$79245 NWELL PWELL BULK DFF_X1
X$174481 \$I174773 \$82559 \$82757 \$79245 NWELL PWELL BULK DFF_X1
X$174484 \$I175024 \$83450 \$83448 \$79245 NWELL PWELL BULK DFF_X1
X$174487 \$I175095 \$83834 \$83833 \$79245 NWELL PWELL BULK DFF_X1
X$174489 \$I175044 \$84111 \$83840 \$79245 NWELL PWELL BULK DFF_X1
X$174492 \$I174771 \$83843 \$84116 \$79245 NWELL PWELL BULK DFF_X1
X$174495 \$I179274 \$83451 \$83838 \$79245 NWELL PWELL BULK DFF_X1
X$174497 \$80451 \$80452 \$80658 \$79245 NWELL PWELL BULK DFF_X1
X$174499 \$81683 \$81675 \$81663 \$79245 NWELL PWELL BULK DFF_X1
X$174501 \$82018 \$81834 \$82016 \$79245 NWELL PWELL BULK DFF_X1
X$174503 \$80106 \$80677 \$80356 \$79245 NWELL PWELL BULK DFF_X1
X$174506 \$I175051 \$83077 \$83074 \$79245 NWELL PWELL BULK DFF_X1
X$174508 \$82742 \$82432 \$82430 \$79245 NWELL PWELL BULK DFF_X1
X$174510 \$I178979 \$83445 \$83689 \$79245 NWELL PWELL BULK DFF_X1
X$174512 \$I178956 \$82892 \$83052 \$79245 NWELL PWELL BULK DFF_X1
X$174514 \$82421 \$82213 \$82740 \$79245 NWELL PWELL BULK DFF_X1
X$174602 \$79288 M1_AXI_RDATA[7] NWELL PWELL BULK BUF_X1
X$174637 S2_AXI_RDATA[7] \$79325 NWELL PWELL BULK BUF_X1
X$174795 \$79425 M1_AXI_RDATA[29] NWELL PWELL BULK BUF_X1
X$174920 \$79509 M0_AXI_RDATA[31] NWELL PWELL BULK BUF_X1
X$175032 \$79639 M1_AXI_RDATA[28] NWELL PWELL BULK BUF_X1
X$175089 S2_AXI_RDATA[29] \$79740 NWELL PWELL BULK BUF_X1
X$175112 \$79759 \$80613 \$80274 \$80086 NWELL PWELL BULK DFF_X1
X$175119 S0_AXI_RDATA[17] \$79771 NWELL PWELL BULK BUF_X1
X$175133 S1_AXI_RDATA[12] \$79777 NWELL PWELL BULK BUF_X1
X$175144 S0_AXI_RDATA[22] \$79780 NWELL PWELL BULK BUF_X1
X$175158 S1_AXI_RDATA[10] \$79783 NWELL PWELL BULK BUF_X1
X$175279 \$79893 S2_AXI_WID[1] NWELL PWELL BULK BUF_X1
X$175367 \$79972 M1_AXI_RDATA[12] NWELL PWELL BULK BUF_X1
X$175469 S0_AXI_RDATA[20] \$80079 NWELL PWELL BULK BUF_X1
X$175480 \$80080 M0_AXI_RDATA[12] NWELL PWELL BULK BUF_X1
X$175486 \$82206 \$82387 \$82380 \$80086 NWELL PWELL BULK DFF_X1
X$175489 \$80446 \$80988 \$80989 \$80086 NWELL PWELL BULK DFF_X1
X$175492 \$82205 \$82367 \$81828 \$80086 NWELL PWELL BULK DFF_X1
X$175495 \$81618 \$81620 \$81619 \$80086 NWELL PWELL BULK DFF_X1
X$175497 \$81321 \$81312 \$81002 \$80086 NWELL PWELL BULK DFF_X1
X$175499 \$83177 \$83601 \$83981 \$80086 NWELL PWELL BULK DFF_X1
X$175501 \$83178 \$83625 \$83431 \$80086 NWELL PWELL BULK DFF_X1
X$175503 \$83008 \$83289 \$83004 \$80086 NWELL PWELL BULK DFF_X1
X$175505 \$83002 \$83000 \$82998 \$80086 NWELL PWELL BULK DFF_X1
X$175508 \$84007 \$84393 \$84003 \$80086 NWELL PWELL BULK DFF_X1
X$175510 \$I174812 \$84071 \$84064 \$80086 NWELL PWELL BULK DFF_X1
X$175513 \$I174665 \$83662 \$83440 \$80086 NWELL PWELL BULK DFF_X1
X$175516 \$I174657 \$82888 \$82545 \$80086 NWELL PWELL BULK DFF_X1
X$175518 \$I174607 \$83832 \$84050 \$80086 NWELL PWELL BULK DFF_X1
X$175521 \$83318 \$83022 \$83311 \$80086 NWELL PWELL BULK DFF_X1
X$175524 \$83308 \$82884 \$83305 \$80086 NWELL PWELL BULK DFF_X1
X$175526 \$83435 \$83434 \$83829 \$80086 NWELL PWELL BULK DFF_X1
X$175529 \$82705 \$82696 \$82366 \$80086 NWELL PWELL BULK DFF_X1
X$175531 \$81991 \$81982 \$81979 \$80086 NWELL PWELL BULK DFF_X1
X$175533 \$I178615 \$82890 \$82731 \$80086 NWELL PWELL BULK DFF_X1
X$175536 \$I174640 \$83646 \$84038 \$80086 NWELL PWELL BULK DFF_X1
X$175539 \$84017 \$83825 \$84013 \$80086 NWELL PWELL BULK DFF_X1
X$175541 \$84043 \$83831 \$84421 \$80086 NWELL PWELL BULK DFF_X1
X$175544 \$I177799 \$82876 \$82877 \$80086 NWELL PWELL BULK DFF_X1
X$175546 \$81301 \$81148 \$81296 \$80086 NWELL PWELL BULK DFF_X1
X$175548 \$80618 \$80835 \$80979 \$80086 NWELL PWELL BULK DFF_X1
X$175551 \$82200 \$82345 \$82674 \$80086 NWELL PWELL BULK DFF_X1
X$175553 \$81971 \$81824 \$81969 \$80086 NWELL PWELL BULK DFF_X1
X$175556 \$82361 \$82689 \$82680 \$80086 NWELL PWELL BULK DFF_X1
X$175586 S0_AXI_RDATA[14] \$80093 NWELL PWELL BULK BUF_X1
X$175615 S1_AXI_RDATA[18] \$80110 NWELL PWELL BULK BUF_X1
X$175640 \$I178351 \$81499 \$81750 \$80126 NWELL PWELL BULK DFF_X1
X$175642 \$I175786 \$80140 \$80822 \$80126 NWELL PWELL BULK DFF_X1
X$175644 \$I176023 \$81185 \$81378 \$80126 NWELL PWELL BULK DFF_X1
X$175647 \$I178223 \$82237 \$82468 \$80126 NWELL PWELL BULK DFF_X1
X$175649 \$I176002 \$82865 \$82245 \$80126 NWELL PWELL BULK DFF_X1
X$175652 \$I178031 \$83205 \$83761 \$80126 NWELL PWELL BULK DFF_X1
X$175654 \$I175994 \$82579 \$82240 \$80126 NWELL PWELL BULK DFF_X1
X$175657 \$I175913 \$83151 \$82915 \$80126 NWELL PWELL BULK DFF_X1
X$175659 \$I175980 \$83875 \$83481 \$80126 NWELL PWELL BULK DFF_X1
X$175662 \$I175771 \$83869 \$83479 \$80126 NWELL PWELL BULK DFF_X1
X$175665 \$I175901 \$83773 \$83871 \$80126 NWELL PWELL BULK DFF_X1
X$175668 \$80128 \$80413 \$80411 \$80126 NWELL PWELL BULK DFF_X1
X$175670 \$81406 \$81404 \$81130 \$80126 NWELL PWELL BULK DFF_X1
X$175672 \$80136 \$80379 \$80134 \$80126 NWELL PWELL BULK DFF_X1
X$175674 \$I175779 \$81496 \$82116 \$80126 NWELL PWELL BULK DFF_X1
X$175676 \$I177733 \$82236 \$82833 \$80126 NWELL PWELL BULK DFF_X1
X$175679 \$80775 \$80475 \$80757 \$80126 NWELL PWELL BULK DFF_X1
X$175682 \$I175708 \$83159 \$82909 \$80126 NWELL PWELL BULK DFF_X1
X$175684 \$I175624 \$83863 \$84214 \$80126 NWELL PWELL BULK DFF_X1
X$175687 \$I175787 \$82913 \$82844 \$80126 NWELL PWELL BULK DFF_X1
X$175690 \$I178246 \$83390 \$83802 \$80126 NWELL PWELL BULK DFF_X1
X$175693 \$I175679 \$84670 \$84224 \$80126 NWELL PWELL BULK DFF_X1
X$175696 \$I175715 \$83868 \$84232 \$80126 NWELL PWELL BULK DFF_X1
X$175701 \$I178306 \$82571 \$83145 \$80126 NWELL PWELL BULK DFF_X1
X$175704 \$I178247 \$82907 \$83147 \$80126 NWELL PWELL BULK DFF_X1
X$175707 \$I176055 \$83782 \$84190 \$80126 NWELL PWELL BULK DFF_X1
X$175710 \$I175619 \$83860 \$84644 \$80126 NWELL PWELL BULK DFF_X1
X$175713 \$I177715 \$82806 \$83143 \$80126 NWELL PWELL BULK DFF_X1
X$175715 \$I176471 \$81182 \$81766 \$80126 NWELL PWELL BULK DFF_X1
X$175718 \$80816 \$80819 \$80488 \$80126 NWELL PWELL BULK DFF_X1
X$175768 S0_AXI_RDATA[27] \$80137 NWELL PWELL BULK BUF_X1
X$175832 \$81710 \$81715 \$80161 NWELL PWELL BULK OR2_X2
X$175856 \$80400 \$80398 \$80165 NWELL PWELL BULK OR2_X1
X$175945 \$80260 M2_AXI_RDATA[14] NWELL PWELL BULK BUF_X1
X$175952 \$80263 M2_AXI_RDATA[12] NWELL PWELL BULK BUF_X1
X$175973 \$I177622 \$80281 \$80288 \$80515 NWELL PWELL BULK DFF_X1
X$176016 \$80313 M1_AXI_RDATA[30] NWELL PWELL BULK BUF_X1
X$176097 S0_AXI_RDATA[13] \$80385 NWELL PWELL BULK BUF_X1
X$176157 S2_AXI_RDATA[30] \$80438 NWELL PWELL BULK BUF_X1
X$176199 S1_AXI_RDATA[13] \$80466 NWELL PWELL BULK BUF_X1
X$176215 \$80857 \$80680 \$80469 NWELL PWELL BULK OR2_X2
X$176272 \$I176651 \$83514 \$84035 \$80515 NWELL PWELL BULK DFF_X1
X$176275 \$I176639 \$82606 \$82605 \$80515 NWELL PWELL BULK DFF_X1
X$176278 \$I176675 \$83894 \$83896 \$80515 NWELL PWELL BULK DFF_X1
X$176281 \$I176602 \$83502 \$84078 \$80515 NWELL PWELL BULK DFF_X1
X$176284 \$I177700 \$82348 \$82346 \$80515 NWELL PWELL BULK DFF_X1
X$176286 \$I177656 \$81643 \$81524 \$80515 NWELL PWELL BULK DFF_X1
X$176288 \$I176209 \$83073 \$82773 \$80515 NWELL PWELL BULK DFF_X1
X$176290 \$I175605 \$83093 \$83315 \$80515 NWELL PWELL BULK DFF_X1
X$176293 \$I177712 \$82929 \$83078 \$80515 NWELL PWELL BULK DFF_X1
X$176295 \$I176725 \$83497 \$84093 \$80515 NWELL PWELL BULK DFF_X1
X$176297 \$I176179 \$83506 \$83505 \$80515 NWELL PWELL BULK DFF_X1
X$176300 \$I175614 \$83100 \$83103 \$80515 NWELL PWELL BULK DFF_X1
X$176303 \$I176635 \$81887 \$82407 \$80515 NWELL PWELL BULK DFF_X1
X$176305 \$I176590 \$83656 \$84056 \$80515 NWELL PWELL BULK DFF_X1
X$176308 \$I176654 \$82604 \$82264 \$80515 NWELL PWELL BULK DFF_X1
X$176312 \$I177752 \$82763 \$83071 \$80515 NWELL PWELL BULK DFF_X1
X$176314 \$I177651 \$83516 \$83221 \$80515 NWELL PWELL BULK DFF_X1
X$176316 \$I176650 \$82935 \$82607 \$80515 NWELL PWELL BULK DFF_X1
X$176319 \$I176711 \$83891 \$84047 \$80515 NWELL PWELL BULK DFF_X1
X$176322 \$I176205 \$81206 \$80996 \$80515 NWELL PWELL BULK DFF_X1
X$176325 \$I176473 \$80990 \$80991 \$80515 NWELL PWELL BULK DFF_X1
X$176328 \$I176687 \$82600 \$83218 \$80515 NWELL PWELL BULK DFF_X1
X$176331 \$I177740 \$81892 \$81893 \$80515 NWELL PWELL BULK DFF_X1
X$176333 \$I177606 \$83511 \$83637 \$80515 NWELL PWELL BULK DFF_X1
X$176336 \$I178365 \$82256 \$82257 \$80515 NWELL PWELL BULK DFF_X1
X$176339 \$I175695 \$83114 \$83130 \$80515 NWELL PWELL BULK DFF_X1
X$176342 \$I175512 \$81662 \$81995 \$80515 NWELL PWELL BULK DFF_X1
X$176344 \$I178362 \$81889 \$82394 \$80515 NWELL PWELL BULK DFF_X1
X$176347 \$I178425 \$81204 \$81670 \$80515 NWELL PWELL BULK DFF_X1
X$176418 \$80546 S2_AXI_WID[0] NWELL PWELL BULK BUF_X1
X$176445 S2_AXI_RDATA[28] \$80558 NWELL PWELL BULK BUF_X1
X$176512 \$80602 S2_AXI_WDATA[9] NWELL PWELL BULK BUF_X1
X$176732 S2_AXI_RDATA[20] \$80828 NWELL PWELL BULK BUF_X1
X$176841 \$81101 \$80872 \$80993 NWELL PWELL BULK OR2_X1
X$176854 \$80876 M0_AXI_RDATA[28] NWELL PWELL BULK BUF_X1
X$176868 \$80891 M1_AXI_RDATA[17] NWELL PWELL BULK BUF_X1
X$176949 S1_AXI_RDATA[14] \$80982 NWELL PWELL BULK BUF_X1
X$177064 \$81063 M1_AXI_RDATA[14] NWELL PWELL BULK BUF_X1
X$177136 S2_AXI_RDATA[1] \$81137 NWELL PWELL BULK BUF_X1
X$177189 \$81165 \$81161 \$81211 NWELL PWELL BULK OR2_X2
X$177204 S1_AXI_RDATA[0] \$81172 NWELL PWELL BULK BUF_X1
X$177490 S2_AXI_RDATA[17] \$81423 NWELL PWELL BULK BUF_X1
X$177517 S1_AXI_RDATA[1] \$81441 NWELL PWELL BULK BUF_X1
X$177528 S1_AXI_RDATA[20] \$81444 NWELL PWELL BULK BUF_X1
X$177560 S1_AXI_RDATA[27] \$81462 NWELL PWELL BULK BUF_X1
X$177619 \$81779 \$81489 \$81673 NWELL PWELL BULK OR2_X1
X$177651 \$81517 M2_AXI_RDATA[20] NWELL PWELL BULK BUF_X1
X$177952 S1_AXI_RDATA[22] \$81825 NWELL PWELL BULK BUF_X1
X$177965 S1_AXI_RDATA[17] \$81829 NWELL PWELL BULK BUF_X1
X$178001 \$81847 \$82479 \$82267 NWELL PWELL BULK OR2_X2
X$178026 \$82496 \$81864 \$82235 NWELL PWELL BULK OR2_X1
X$178032 \$81876 M0_AXI_RDATA[0] NWELL PWELL BULK BUF_X1
X$178072 \$81902 S2_AXI_WDATA[28] NWELL PWELL BULK BUF_X1
X$178077 \$81910 S2_AXI_WDATA[7] NWELL PWELL BULK BUF_X1
X$178233 \$82026 M1_AXI_RDATA[10] NWELL PWELL BULK BUF_X1
X$178329 \$82128 \$82482 \$82449 NWELL PWELL BULK OR2_X1
X$178463 \$82519 \$82508 \$82255 NWELL PWELL BULK OR2_X2
X$178481 \$82260 M2_AXI_RDATA[30] NWELL PWELL BULK BUF_X1
X$178519 \$82279 S2_AXI_WDATA[6] NWELL PWELL BULK BUF_X1
X$178586 S2_AXI_RDATA[14] \$82340 NWELL PWELL BULK BUF_X1
X$178638 \$82381 M2_AXI_RDATA[28] NWELL PWELL BULK BUF_X1
X$178775 S2_AXI_RDATA[10] \$82531 NWELL PWELL BULK BUF_X1
X$178786 \$82537 M0_AXI_RDATA[17] NWELL PWELL BULK BUF_X1
X$178866 \$82598 M2_AXI_RDATA[10] NWELL PWELL BULK BUF_X1
X$178938 S2_AXI_RDATA[13] \$82647 NWELL PWELL BULK BUF_X1
X$179043 \$82737 M2_AXI_RDATA[17] NWELL PWELL BULK BUF_X1
X$179182 S2_AXI_RDATA[0] \$82885 NWELL PWELL BULK BUF_X1
X$179597 \$83208 M1_AXI_RDATA[0] NWELL PWELL BULK BUF_X1
X$179600 \$83210 M1_AXI_RDATA[27] NWELL PWELL BULK BUF_X1
X$179630 \$83228 S2_AXI_WSTRB[0] NWELL PWELL BULK BUF_X1
X$179645 \$83244 prdata[31] NWELL PWELL BULK BUF_X1
X$179647 \$83244 NWELL PWELL BULK LOGIC0_X1
X$179654 \$84311 prdata[24] NWELL PWELL BULK BUF_X1
X$179686 \$83263 S2_AXI_WDATA[21] NWELL PWELL BULK BUF_X1
X$179692 \$83265 S2_AXI_WLAST NWELL PWELL BULK BUF_X1
X$179723 \$83281 M2_AXI_RDATA[22] NWELL PWELL BULK BUF_X1
X$179805 \$83883 M2_AXI_RDATA[0] NWELL PWELL BULK BUF_X1
X$179875 \$83358 M0_AXI_RDATA[29] NWELL PWELL BULK BUF_X1
X$179968 S2_AXI_RDATA[27] \$83418 NWELL PWELL BULK BUF_X1
X$179973 \$83422 NWELL PWELL BULK LOGIC0_X1
X$179975 \$83422 prdata[15] NWELL PWELL BULK BUF_X1
X$179977 \$83423 prdata[22] NWELL PWELL BULK BUF_X1
X$179979 \$83423 NWELL PWELL BULK LOGIC0_X1
X$179990 S2_AXI_RDATA[22] \$83430 NWELL PWELL BULK BUF_X1
X$180075 \$83809 M0_AXI_RDATA[1] NWELL PWELL BULK BUF_X1
X$180110 \$83704 M1_AXI_RDATA[13] NWELL PWELL BULK BUF_X1
X$180214 \$83555 S0_AXI_AWID[7] NWELL PWELL BULK BUF_X1
X$180224 \$83555 NWELL PWELL BULK LOGIC0_X1
X$180229 \$83562 prdata[20] NWELL PWELL BULK BUF_X1
X$180232 \$83562 NWELL PWELL BULK LOGIC0_X1
X$180244 \$83574 NWELL PWELL BULK LOGIC0_X1
X$180246 \$83574 prdata[21] NWELL PWELL BULK BUF_X1
X$180337 \$83718 M0_AXI_RDATA[14] NWELL PWELL BULK BUF_X1
X$180344 \$84562 M0_AXI_RDATA[23] NWELL PWELL BULK BUF_X1
X$180368 \$83744 M1_AXI_RDATA[1] NWELL PWELL BULK BUF_X1
X$180404 \$83788 M0_AXI_RDATA[10] NWELL PWELL BULK BUF_X1
X$180429 \$83817 prdata[16] NWELL PWELL BULK BUF_X1
X$180431 \$83817 NWELL PWELL BULK LOGIC0_X1
X$180451 \$83827 M0_AXI_RDATA[24] NWELL PWELL BULK BUF_X1
X$180487 \$83854 M0_AXI_RDATA[22] NWELL PWELL BULK BUF_X1
X$180576 \$83906 S2_AXI_WDATA[11] NWELL PWELL BULK BUF_X1
X$180607 \$83922 prdata[30] NWELL PWELL BULK BUF_X1
X$180609 \$83922 NWELL PWELL BULK LOGIC0_X1
X$180611 \$83926 prdata[17] NWELL PWELL BULK BUF_X1
X$180613 \$83926 NWELL PWELL BULK LOGIC0_X1
X$180615 \$83927 NWELL PWELL BULK LOGIC0_X1
X$180617 \$83927 prdata[6] NWELL PWELL BULK BUF_X1
X$180619 \$83932 prdata[25] NWELL PWELL BULK BUF_X1
X$180622 \$83932 NWELL PWELL BULK LOGIC0_X1
X$180634 \$83943 NWELL PWELL BULK LOGIC0_X1
X$180637 \$83943 prdata[8] NWELL PWELL BULK BUF_X1
X$180754 \$84069 M0_AXI_RDATA[20] NWELL PWELL BULK BUF_X1
X$180825 \$84716 M1_AXI_RDATA[20] NWELL PWELL BULK BUF_X1
X$180891 \$84210 M0_AXI_RDATA[30] NWELL PWELL BULK BUF_X1
X$180898 \$84724 M1_AXI_RDATA[11] NWELL PWELL BULK BUF_X1
X$180913 \$84229 M0_AXI_RDATA[27] NWELL PWELL BULK BUF_X1
X$180921 \$84239 NWELL PWELL BULK LOGIC0_X1
X$180923 \$84239 prdata[26] NWELL PWELL BULK BUF_X1
X$180932 \$84280 M2_AXI_RDATA[13] NWELL PWELL BULK BUF_X1
X$181057 \$84290 S2_AXI_WDATA[22] NWELL PWELL BULK BUF_X1
X$181068 \$84292 S2_AXI_WDATA[25] NWELL PWELL BULK BUF_X1
X$181072 \$84293 prdata[18] NWELL PWELL BULK BUF_X1
X$181074 \$84293 NWELL PWELL BULK LOGIC0_X1
X$181076 \$84294 prdata[28] NWELL PWELL BULK BUF_X1
X$181078 \$84294 NWELL PWELL BULK LOGIC0_X1
X$181080 \$84296 NWELL PWELL BULK LOGIC0_X1
X$181082 \$84296 prdata[19] NWELL PWELL BULK BUF_X1
X$181089 \$84300 NWELL PWELL BULK LOGIC0_X1
X$181091 \$84300 prdata[10] NWELL PWELL BULK BUF_X1
X$181093 \$84302 prdata[12] NWELL PWELL BULK BUF_X1
X$181095 \$84302 NWELL PWELL BULK LOGIC0_X1
X$181097 \$84303 prdata[29] NWELL PWELL BULK BUF_X1
X$181099 \$84303 NWELL PWELL BULK LOGIC0_X1
X$181117 \$84311 NWELL PWELL BULK LOGIC0_X1
X$181119 \$84313 prdata[27] NWELL PWELL BULK BUF_X1
X$181122 \$84313 NWELL PWELL BULK LOGIC0_X1
X$181125 \$84314 NWELL PWELL BULK LOGIC0_X1
X$181127 \$84314 S1_AXI_AWID[6] NWELL PWELL BULK BUF_X1
X$181246 \$84317 NWELL PWELL BULK LOGIC0_X1
X$181248 \$84317 prdata[11] NWELL PWELL BULK BUF_X1
X$181255 \$84319 NWELL PWELL BULK LOGIC0_X1
X$181257 \$84319 S1_AXI_ARID[6] NWELL PWELL BULK BUF_X1
X$181259 \$84323 prdata[13] NWELL PWELL BULK BUF_X1
X$181261 \$84323 NWELL PWELL BULK LOGIC0_X1
X$181268 \$84328 prdata[23] NWELL PWELL BULK BUF_X1
X$181274 \$84328 NWELL PWELL BULK LOGIC0_X1
X$181277 \$84329 NWELL PWELL BULK LOGIC0_X1
X$181279 \$84329 prdata[14] NWELL PWELL BULK BUF_X1
X$181281 \$84337 NWELL PWELL BULK LOGIC0_X1
X$181283 \$84337 prdata[7] NWELL PWELL BULK BUF_X1
X$181290 \$84340 prdata[9] NWELL PWELL BULK BUF_X1
X$181292 \$84340 NWELL PWELL BULK LOGIC0_X1
X$181315 \$84352 S2_AXI_WSTRB[1] NWELL PWELL BULK BUF_X1
X$181587 \$84533 M0_AXI_RDATA[7] NWELL PWELL BULK BUF_X1
X$181609 \$84560 M2_AXI_RDATA[27] NWELL PWELL BULK BUF_X1
X$181772 \$84612 M2_AXI_RDATA[1] NWELL PWELL BULK BUF_X1
X$181815 \$84648 M0_AXI_RDATA[13] NWELL PWELL BULK BUF_X1
X$181995 \$84745 M1_AXI_RDATA[22] NWELL PWELL BULK BUF_X1
X$182258 net1419 NWELL PWELL BULK LOGIC0_X1
.ENDS axi_interconnect

.SUBCKT AOI211_X4 C1 C2 B A ZN VDD PWELL VSS
M$1 \$7 C1 \$6 VDD PMOS_VTL L=0.05U W=0.63U AS=0.06615P AD=0.0441P PS=1.47U
+ PD=0.77U
M$2 \$6 C2 \$7 VDD PMOS_VTL L=0.05U W=0.63U AS=0.0441P AD=0.0441P PS=0.77U
+ PD=0.77U
M$3 \$7 B \$13 VDD PMOS_VTL L=0.05U W=0.63U AS=0.0441P AD=0.0441P PS=0.77U
+ PD=0.77U
M$4 \$13 A VDD VDD PMOS_VTL L=0.05U W=0.63U AS=0.0441P AD=0.0441P PS=0.77U
+ PD=0.77U
M$5 VDD \$6 \$5 VDD PMOS_VTL L=0.05U W=1.26U AS=0.0882P AD=0.0882P PS=1.54U
+ PD=1.54U
M$7 VDD \$5 ZN VDD PMOS_VTL L=0.05U W=2.52U AS=0.1764P AD=0.19845P PS=3.08U
+ PD=3.78U
M$11 \$6 C1 \$14 PWELL NMOS_VTL L=0.05U W=0.415U AS=0.043575P AD=0.02905P
+ PS=1.04U PD=0.555U
M$12 \$14 C2 VSS PWELL NMOS_VTL L=0.05U W=0.415U AS=0.02905P AD=0.02905P
+ PS=0.555U PD=0.555U
M$13 VSS B \$6 PWELL NMOS_VTL L=0.05U W=0.415U AS=0.02905P AD=0.02905P
+ PS=0.555U PD=0.555U
M$14 \$6 A VSS PWELL NMOS_VTL L=0.05U W=0.415U AS=0.02905P AD=0.02905P
+ PS=0.555U PD=0.555U
M$15 VSS \$6 \$5 PWELL NMOS_VTL L=0.05U W=0.83U AS=0.0581P AD=0.0581P PS=1.11U
+ PD=1.11U
M$17 VSS \$5 ZN PWELL NMOS_VTL L=0.05U W=1.66U AS=0.1162P AD=0.130725P PS=2.22U
+ PD=2.705U
.ENDS AOI211_X4

.SUBCKT AND2_X4 A2 A1 ZN VDD PWELL VSS
M$1 VDD A2 \$3 VDD PMOS_VTL L=0.05U W=1.26U AS=0.11025P AD=0.0882P PS=2.24U
+ PD=1.54U
M$2 \$3 A1 VDD VDD PMOS_VTL L=0.05U W=1.26U AS=0.0882P AD=0.0882P PS=1.54U
+ PD=1.54U
M$5 VDD \$3 ZN VDD PMOS_VTL L=0.05U W=2.52U AS=0.1764P AD=0.19845P PS=3.08U
+ PD=3.78U
M$9 VSS A2 \$10 PWELL NMOS_VTL L=0.05U W=0.415U AS=0.043575P AD=0.02905P
+ PS=1.04U PD=0.555U
M$10 \$10 A1 \$3 PWELL NMOS_VTL L=0.05U W=0.415U AS=0.02905P AD=0.02905P
+ PS=0.555U PD=0.555U
M$11 \$3 A1 \$9 PWELL NMOS_VTL L=0.05U W=0.415U AS=0.02905P AD=0.02905P
+ PS=0.555U PD=0.555U
M$12 \$9 A2 VSS PWELL NMOS_VTL L=0.05U W=0.415U AS=0.02905P AD=0.02905P
+ PS=0.555U PD=0.555U
M$13 VSS \$3 ZN PWELL NMOS_VTL L=0.05U W=1.66U AS=0.1162P AD=0.130725P PS=2.22U
+ PD=2.705U
.ENDS AND2_X4

.SUBCKT XOR2_X2 B A Z VDD PWELL VSS
M$1 \$3 A \$10 VDD PMOS_VTL L=0.05U W=0.63U AS=0.06615P AD=0.0441P PS=1.47U
+ PD=0.77U
M$2 \$10 B VDD VDD PMOS_VTL L=0.05U W=0.63U AS=0.0441P AD=0.0441P PS=0.77U
+ PD=0.77U
M$3 VDD \$3 \$6 VDD PMOS_VTL L=0.05U W=1.26U AS=0.0882P AD=0.11025P PS=1.54U
+ PD=2.24U
M$4 \$6 A Z VDD PMOS_VTL L=0.05U W=1.26U AS=0.0882P AD=0.0882P PS=1.54U PD=1.54U
M$5 Z B \$6 VDD PMOS_VTL L=0.05U W=1.26U AS=0.0882P AD=0.0882P PS=1.54U PD=1.54U
M$9 VSS A \$3 PWELL NMOS_VTL L=0.05U W=0.415U AS=0.043575P AD=0.02905P PS=1.04U
+ PD=0.555U
M$10 \$3 B VSS PWELL NMOS_VTL L=0.05U W=0.415U AS=0.02905P AD=0.02905P
+ PS=0.555U PD=0.555U
M$11 VSS \$3 Z PWELL NMOS_VTL L=0.05U W=0.83U AS=0.0581P AD=0.072625P PS=1.11U
+ PD=1.595U
M$12 Z A \$12 PWELL NMOS_VTL L=0.05U W=0.415U AS=0.02905P AD=0.02905P PS=0.555U
+ PD=0.555U
M$13 \$12 B VSS PWELL NMOS_VTL L=0.05U W=0.415U AS=0.02905P AD=0.02905P
+ PS=0.555U PD=0.555U
M$14 VSS B \$11 PWELL NMOS_VTL L=0.05U W=0.415U AS=0.02905P AD=0.02905P
+ PS=0.555U PD=0.555U
M$15 \$11 A Z PWELL NMOS_VTL L=0.05U W=0.415U AS=0.02905P AD=0.02905P PS=0.555U
+ PD=0.555U
.ENDS XOR2_X2

.SUBCKT INV_X16 A ZN VDD PWELL VSS
M$1 VDD A ZN VDD PMOS_VTL L=0.05U W=10.08U AS=0.72765P AD=0.72765P PS=13.02U
+ PD=13.02U
M$17 VSS A ZN PWELL NMOS_VTL L=0.05U W=6.64U AS=0.479325P AD=0.479325P
+ PS=9.365U PD=9.365U
.ENDS INV_X16

.SUBCKT NOR4_X4 A1 A2 A3 A4 ZN VDD PWELL VSS
M$1 \$10 A3 \$9 VDD PMOS_VTL L=0.05U W=2.52U AS=0.19845P AD=0.1764P PS=3.78U
+ PD=3.08U
M$5 \$10 A4 VDD VDD PMOS_VTL L=0.05U W=2.52U AS=0.1764P AD=0.19845P PS=3.08U
+ PD=3.78U
M$9 \$8 A1 ZN VDD PMOS_VTL L=0.05U W=2.52U AS=0.19845P AD=0.1764P PS=3.78U
+ PD=3.08U
M$13 \$8 A2 \$9 VDD PMOS_VTL L=0.05U W=2.52U AS=0.1764P AD=0.19845P PS=3.08U
+ PD=3.78U
M$17 ZN A3 VSS PWELL NMOS_VTL L=0.05U W=1.66U AS=0.130725P AD=0.1162P PS=2.705U
+ PD=2.22U
M$21 ZN A4 VSS PWELL NMOS_VTL L=0.05U W=1.66U AS=0.1162P AD=0.130725P PS=2.22U
+ PD=2.705U
M$25 VSS A1 ZN PWELL NMOS_VTL L=0.05U W=1.66U AS=0.130725P AD=0.1162P PS=2.705U
+ PD=2.22U
M$29 VSS A2 ZN PWELL NMOS_VTL L=0.05U W=1.66U AS=0.1162P AD=0.130725P PS=2.22U
+ PD=2.705U
.ENDS NOR4_X4

.SUBCKT OR3_X2 A1 A2 A3 ZN VDD PWELL VSS
M$1 \$4 A1 \$11 VDD PMOS_VTL L=0.05U W=0.63U AS=0.06615P AD=0.0441P PS=1.47U
+ PD=0.77U
M$2 \$11 A2 \$10 VDD PMOS_VTL L=0.05U W=0.63U AS=0.0441P AD=0.0441P PS=0.77U
+ PD=0.77U
M$3 \$10 A3 VDD VDD PMOS_VTL L=0.05U W=0.63U AS=0.0441P AD=0.0441P PS=0.77U
+ PD=0.77U
M$4 VDD \$4 ZN VDD PMOS_VTL L=0.05U W=1.26U AS=0.0882P AD=0.11025P PS=1.54U
+ PD=2.24U
M$6 \$4 A1 VSS PWELL NMOS_VTL L=0.05U W=0.415U AS=0.043575P AD=0.02905P
+ PS=1.04U PD=0.555U
M$7 VSS A2 \$4 PWELL NMOS_VTL L=0.05U W=0.415U AS=0.02905P AD=0.02905P
+ PS=0.555U PD=0.555U
M$8 \$4 A3 VSS PWELL NMOS_VTL L=0.05U W=0.415U AS=0.02905P AD=0.02905P
+ PS=0.555U PD=0.555U
M$9 VSS \$4 ZN PWELL NMOS_VTL L=0.05U W=0.83U AS=0.0581P AD=0.072625P PS=1.11U
+ PD=1.595U
.ENDS OR3_X2

.SUBCKT AND4_X2 A1 A2 A3 A4 ZN VDD PWELL VSS
M$1 VDD A1 \$5 VDD PMOS_VTL L=0.05U W=0.63U AS=0.06615P AD=0.0441P PS=1.47U
+ PD=0.77U
M$2 \$5 A2 VDD VDD PMOS_VTL L=0.05U W=0.63U AS=0.0441P AD=0.0441P PS=0.77U
+ PD=0.77U
M$3 VDD A3 \$5 VDD PMOS_VTL L=0.05U W=0.63U AS=0.0441P AD=0.0441P PS=0.77U
+ PD=0.77U
M$4 \$5 A4 VDD VDD PMOS_VTL L=0.05U W=0.63U AS=0.0441P AD=0.0441P PS=0.77U
+ PD=0.77U
M$5 VDD \$5 ZN VDD PMOS_VTL L=0.05U W=1.26U AS=0.0882P AD=0.11025P PS=1.54U
+ PD=2.24U
M$7 \$5 A1 \$13 PWELL NMOS_VTL L=0.05U W=0.415U AS=0.043575P AD=0.02905P
+ PS=1.04U PD=0.555U
M$8 \$13 A2 \$12 PWELL NMOS_VTL L=0.05U W=0.415U AS=0.02905P AD=0.02905P
+ PS=0.555U PD=0.555U
M$9 \$12 A3 \$11 PWELL NMOS_VTL L=0.05U W=0.415U AS=0.02905P AD=0.02905P
+ PS=0.555U PD=0.555U
M$10 \$11 A4 VSS PWELL NMOS_VTL L=0.05U W=0.415U AS=0.02905P AD=0.02905P
+ PS=0.555U PD=0.555U
M$11 VSS \$5 ZN PWELL NMOS_VTL L=0.05U W=0.83U AS=0.0581P AD=0.072625P PS=1.11U
+ PD=1.595U
.ENDS AND4_X2

.SUBCKT OR4_X2 A1 A2 A3 A4 ZN VDD PWELL VSS
M$1 \$5 A1 \$13 VDD PMOS_VTL L=0.05U W=0.63U AS=0.06615P AD=0.0441P PS=1.47U
+ PD=0.77U
M$2 \$13 A2 \$12 VDD PMOS_VTL L=0.05U W=0.63U AS=0.0441P AD=0.0441P PS=0.77U
+ PD=0.77U
M$3 \$12 A3 \$11 VDD PMOS_VTL L=0.05U W=0.63U AS=0.0441P AD=0.0441P PS=0.77U
+ PD=0.77U
M$4 \$11 A4 VDD VDD PMOS_VTL L=0.05U W=0.63U AS=0.0441P AD=0.0441P PS=0.77U
+ PD=0.77U
M$5 VDD \$5 ZN VDD PMOS_VTL L=0.05U W=1.26U AS=0.0882P AD=0.11025P PS=1.54U
+ PD=2.24U
M$7 VSS A1 \$5 PWELL NMOS_VTL L=0.05U W=0.415U AS=0.043575P AD=0.02905P
+ PS=1.04U PD=0.555U
M$8 \$5 A2 VSS PWELL NMOS_VTL L=0.05U W=0.415U AS=0.02905P AD=0.02905P
+ PS=0.555U PD=0.555U
M$9 VSS A3 \$5 PWELL NMOS_VTL L=0.05U W=0.415U AS=0.02905P AD=0.02905P
+ PS=0.555U PD=0.555U
M$10 \$5 A4 VSS PWELL NMOS_VTL L=0.05U W=0.415U AS=0.02905P AD=0.02905P
+ PS=0.555U PD=0.555U
M$11 VSS \$5 ZN PWELL NMOS_VTL L=0.05U W=0.83U AS=0.0581P AD=0.072625P PS=1.11U
+ PD=1.595U
.ENDS OR4_X2

.SUBCKT OR2_X4 A2 A1 ZN VDD PWELL VSS
M$1 VDD A2 \$10 VDD PMOS_VTL L=0.05U W=0.63U AS=0.06615P AD=0.0441P PS=1.47U
+ PD=0.77U
M$2 \$10 A1 \$4 VDD PMOS_VTL L=0.05U W=0.63U AS=0.0441P AD=0.0441P PS=0.77U
+ PD=0.77U
M$3 \$4 A1 \$9 VDD PMOS_VTL L=0.05U W=0.63U AS=0.0441P AD=0.0441P PS=0.77U
+ PD=0.77U
M$4 \$9 A2 VDD VDD PMOS_VTL L=0.05U W=0.63U AS=0.0441P AD=0.0441P PS=0.77U
+ PD=0.77U
M$5 VDD \$4 ZN VDD PMOS_VTL L=0.05U W=2.52U AS=0.1764P AD=0.19845P PS=3.08U
+ PD=3.78U
M$9 VSS A2 \$4 PWELL NMOS_VTL L=0.05U W=0.83U AS=0.072625P AD=0.0581P PS=1.595U
+ PD=1.11U
M$10 \$4 A1 VSS PWELL NMOS_VTL L=0.05U W=0.83U AS=0.0581P AD=0.0581P PS=1.11U
+ PD=1.11U
M$13 VSS \$4 ZN PWELL NMOS_VTL L=0.05U W=1.66U AS=0.1162P AD=0.130725P PS=2.22U
+ PD=2.705U
.ENDS OR2_X4

.SUBCKT OR4_X1 A1 A2 A3 A4 ZN VDD PWELL VSS
M$1 \$6 A1 \$12 VDD PMOS_VTL L=0.05U W=0.315U AS=0.033075P AD=0.02205P PS=0.84U
+ PD=0.455U
M$2 \$12 A2 \$11 VDD PMOS_VTL L=0.05U W=0.315U AS=0.02205P AD=0.02205P
+ PS=0.455U PD=0.455U
M$3 \$11 A3 \$13 VDD PMOS_VTL L=0.05U W=0.315U AS=0.02205P AD=0.02205P
+ PS=0.455U PD=0.455U
M$4 VDD A4 \$13 VDD PMOS_VTL L=0.05U W=0.315U AS=0.033075P AD=0.02205P PS=0.77U
+ PD=0.455U
M$5 VDD \$6 ZN VDD PMOS_VTL L=0.05U W=0.63U AS=0.033075P AD=0.06615P PS=0.77U
+ PD=1.47U
M$6 VSS A1 \$6 PWELL NMOS_VTL L=0.05U W=0.21U AS=0.02205P AD=0.0147P PS=0.63U
+ PD=0.35U
M$7 \$6 A2 VSS PWELL NMOS_VTL L=0.05U W=0.21U AS=0.0147P AD=0.0147P PS=0.35U
+ PD=0.35U
M$8 VSS A3 \$6 PWELL NMOS_VTL L=0.05U W=0.21U AS=0.0147P AD=0.0147P PS=0.35U
+ PD=0.35U
M$9 \$6 A4 VSS PWELL NMOS_VTL L=0.05U W=0.21U AS=0.0147P AD=0.021875P PS=0.35U
+ PD=0.555U
M$10 VSS \$6 ZN PWELL NMOS_VTL L=0.05U W=0.415U AS=0.021875P AD=0.043575P
+ PS=0.555U PD=1.04U
.ENDS OR4_X1

.SUBCKT AOI221_X1 B2 B1 A C2 C1 ZN VDD PWELL VSS
M$1 \$7 B2 VDD VDD PMOS_VTL L=0.05U W=0.63U AS=0.06615P AD=0.0441P PS=1.47U
+ PD=0.77U
M$2 VDD B1 \$7 VDD PMOS_VTL L=0.05U W=0.63U AS=0.0441P AD=0.0441P PS=0.77U
+ PD=0.77U
M$3 \$7 A \$10 VDD PMOS_VTL L=0.05U W=0.63U AS=0.0441P AD=0.0441P PS=0.77U
+ PD=0.77U
M$4 \$10 C2 ZN VDD PMOS_VTL L=0.05U W=0.63U AS=0.0441P AD=0.0441P PS=0.77U
+ PD=0.77U
M$5 ZN C1 \$10 VDD PMOS_VTL L=0.05U W=0.63U AS=0.0441P AD=0.06615P PS=0.77U
+ PD=1.47U
M$6 VSS B2 \$14 PWELL NMOS_VTL L=0.05U W=0.415U AS=0.043575P AD=0.02905P
+ PS=1.04U PD=0.555U
M$7 \$14 B1 ZN PWELL NMOS_VTL L=0.05U W=0.415U AS=0.02905P AD=0.02905P
+ PS=0.555U PD=0.555U
M$8 ZN A VSS PWELL NMOS_VTL L=0.05U W=0.415U AS=0.02905P AD=0.02905P PS=0.555U
+ PD=0.555U
M$9 VSS C2 \$13 PWELL NMOS_VTL L=0.05U W=0.415U AS=0.02905P AD=0.02905P
+ PS=0.555U PD=0.555U
M$10 \$13 C1 ZN PWELL NMOS_VTL L=0.05U W=0.415U AS=0.02905P AD=0.043575P
+ PS=0.555U PD=1.04U
.ENDS AOI221_X1

.SUBCKT NAND4_X1 A4 A3 A2 A1 ZN VDD PWELL VSS
M$1 VDD A4 ZN VDD PMOS_VTL L=0.05U W=0.63U AS=0.06615P AD=0.0441P PS=1.47U
+ PD=0.77U
M$2 ZN A3 VDD VDD PMOS_VTL L=0.05U W=0.63U AS=0.0441P AD=0.0441P PS=0.77U
+ PD=0.77U
M$3 VDD A2 ZN VDD PMOS_VTL L=0.05U W=0.63U AS=0.0441P AD=0.0441P PS=0.77U
+ PD=0.77U
M$4 ZN A1 VDD VDD PMOS_VTL L=0.05U W=0.63U AS=0.0441P AD=0.06615P PS=0.77U
+ PD=1.47U
M$5 VSS A4 \$12 PWELL NMOS_VTL L=0.05U W=0.415U AS=0.043575P AD=0.02905P
+ PS=1.04U PD=0.555U
M$6 \$12 A3 \$11 PWELL NMOS_VTL L=0.05U W=0.415U AS=0.02905P AD=0.02905P
+ PS=0.555U PD=0.555U
M$7 \$11 A2 \$10 PWELL NMOS_VTL L=0.05U W=0.415U AS=0.02905P AD=0.02905P
+ PS=0.555U PD=0.555U
M$8 \$10 A1 ZN PWELL NMOS_VTL L=0.05U W=0.415U AS=0.02905P AD=0.043575P
+ PS=0.555U PD=1.04U
.ENDS NAND4_X1

.SUBCKT AND3_X2 A1 A2 A3 ZN VDD PWELL VSS
M$1 \$4 A1 VDD VDD PMOS_VTL L=0.05U W=0.63U AS=0.06615P AD=0.0441P PS=1.47U
+ PD=0.77U
M$2 VDD A2 \$4 VDD PMOS_VTL L=0.05U W=0.63U AS=0.0441P AD=0.0441P PS=0.77U
+ PD=0.77U
M$3 \$4 A3 VDD VDD PMOS_VTL L=0.05U W=0.63U AS=0.0441P AD=0.0441P PS=0.77U
+ PD=0.77U
M$4 VDD \$4 ZN VDD PMOS_VTL L=0.05U W=1.26U AS=0.0882P AD=0.11025P PS=1.54U
+ PD=2.24U
M$6 \$4 A1 \$11 PWELL NMOS_VTL L=0.05U W=0.415U AS=0.043575P AD=0.02905P
+ PS=1.04U PD=0.555U
M$7 \$11 A2 \$10 PWELL NMOS_VTL L=0.05U W=0.415U AS=0.02905P AD=0.02905P
+ PS=0.555U PD=0.555U
M$8 \$10 A3 VSS PWELL NMOS_VTL L=0.05U W=0.415U AS=0.02905P AD=0.02905P
+ PS=0.555U PD=0.555U
M$9 VSS \$4 ZN PWELL NMOS_VTL L=0.05U W=0.83U AS=0.0581P AD=0.072625P PS=1.11U
+ PD=1.595U
.ENDS AND3_X2

.SUBCKT AND4_X4 A4 A3 A2 A1 ZN VDD PWELL VSS
M$1 VDD A4 \$5 VDD PMOS_VTL L=0.05U W=1.26U AS=0.11025P AD=0.0882P PS=2.24U
+ PD=1.54U
M$2 \$5 A3 VDD VDD PMOS_VTL L=0.05U W=1.26U AS=0.0882P AD=0.0882P PS=1.54U
+ PD=1.54U
M$3 VDD A2 \$5 VDD PMOS_VTL L=0.05U W=1.26U AS=0.0882P AD=0.0882P PS=1.54U
+ PD=1.54U
M$4 \$5 A1 VDD VDD PMOS_VTL L=0.05U W=1.26U AS=0.0882P AD=0.0882P PS=1.54U
+ PD=1.54U
M$9 VDD \$5 ZN VDD PMOS_VTL L=0.05U W=2.52U AS=0.1764P AD=0.19845P PS=3.08U
+ PD=3.78U
M$13 VSS A4 \$8 PWELL NMOS_VTL L=0.05U W=0.415U AS=0.043575P AD=0.02905P
+ PS=1.04U PD=0.555U
M$14 \$8 A3 \$9 PWELL NMOS_VTL L=0.05U W=0.415U AS=0.02905P AD=0.02905P
+ PS=0.555U PD=0.555U
M$15 \$9 A2 \$10 PWELL NMOS_VTL L=0.05U W=0.415U AS=0.02905P AD=0.02905P
+ PS=0.555U PD=0.555U
M$16 \$10 A1 \$5 PWELL NMOS_VTL L=0.05U W=0.415U AS=0.02905P AD=0.02905P
+ PS=0.555U PD=0.555U
M$17 \$5 A1 \$12 PWELL NMOS_VTL L=0.05U W=0.415U AS=0.02905P AD=0.02905P
+ PS=0.555U PD=0.555U
M$18 \$12 A2 \$11 PWELL NMOS_VTL L=0.05U W=0.415U AS=0.02905P AD=0.02905P
+ PS=0.555U PD=0.555U
M$19 \$11 A3 \$13 PWELL NMOS_VTL L=0.05U W=0.415U AS=0.02905P AD=0.02905P
+ PS=0.555U PD=0.555U
M$20 \$13 A4 VSS PWELL NMOS_VTL L=0.05U W=0.415U AS=0.02905P AD=0.02905P
+ PS=0.555U PD=0.555U
M$21 VSS \$5 ZN PWELL NMOS_VTL L=0.05U W=1.66U AS=0.1162P AD=0.130725P PS=2.22U
+ PD=2.705U
.ENDS AND4_X4

.SUBCKT AOI211_X2 B A C2 C1 ZN VDD PWELL VSS
M$1 \$5 B \$12 VDD PMOS_VTL L=0.05U W=0.63U AS=0.06615P AD=0.0441P PS=1.47U
+ PD=0.77U
M$2 \$12 A VDD VDD PMOS_VTL L=0.05U W=0.63U AS=0.0441P AD=0.0441P PS=0.77U
+ PD=0.77U
M$3 VDD A \$11 VDD PMOS_VTL L=0.05U W=0.63U AS=0.0441P AD=0.0441P PS=0.77U
+ PD=0.77U
M$4 \$11 B \$5 VDD PMOS_VTL L=0.05U W=0.63U AS=0.0441P AD=0.055125P PS=0.77U
+ PD=0.805U
M$5 \$5 C2 ZN VDD PMOS_VTL L=0.05U W=1.26U AS=0.099225P AD=0.11025P PS=1.575U
+ PD=2.24U
M$6 ZN C1 \$5 VDD PMOS_VTL L=0.05U W=1.26U AS=0.0882P AD=0.0882P PS=1.54U
+ PD=1.54U
M$9 VSS B ZN PWELL NMOS_VTL L=0.05U W=0.83U AS=0.072625P AD=0.0653625P
+ PS=1.595U PD=1.145U
M$10 ZN A VSS PWELL NMOS_VTL L=0.05U W=0.83U AS=0.0581P AD=0.0581P PS=1.11U
+ PD=1.11U
M$13 VSS C2 \$13 PWELL NMOS_VTL L=0.05U W=0.415U AS=0.0363125P AD=0.02905P
+ PS=0.59U PD=0.555U
M$14 \$13 C1 ZN PWELL NMOS_VTL L=0.05U W=0.415U AS=0.02905P AD=0.02905P
+ PS=0.555U PD=0.555U
M$15 ZN C1 \$14 PWELL NMOS_VTL L=0.05U W=0.415U AS=0.02905P AD=0.02905P
+ PS=0.555U PD=0.555U
M$16 \$14 C2 VSS PWELL NMOS_VTL L=0.05U W=0.415U AS=0.02905P AD=0.043575P
+ PS=0.555U PD=1.04U
.ENDS AOI211_X2

.SUBCKT OAI211_X2 A B C2 C1 ZN VDD PWELL VSS
M$1 VDD A ZN VDD PMOS_VTL L=0.05U W=1.26U AS=0.111825P AD=0.0882P PS=2.245U
+ PD=1.54U
M$2 ZN B VDD VDD PMOS_VTL L=0.05U W=1.26U AS=0.0882P AD=0.089775P PS=1.54U
+ PD=1.545U
M$5 VDD C2 \$12 VDD PMOS_VTL L=0.05U W=0.63U AS=0.0441P AD=0.0441P PS=0.77U
+ PD=0.77U
M$6 \$12 C1 ZN VDD PMOS_VTL L=0.05U W=0.63U AS=0.0441P AD=0.0441P PS=0.77U
+ PD=0.77U
M$7 ZN C1 \$11 VDD PMOS_VTL L=0.05U W=0.63U AS=0.0441P AD=0.0441P PS=0.77U
+ PD=0.77U
M$8 \$11 C2 VDD VDD PMOS_VTL L=0.05U W=0.63U AS=0.0441P AD=0.06615P PS=0.77U
+ PD=1.47U
M$9 \$5 A \$14 PWELL NMOS_VTL L=0.05U W=0.415U AS=0.043575P AD=0.02905P
+ PS=1.04U PD=0.555U
M$10 \$14 B VSS PWELL NMOS_VTL L=0.05U W=0.415U AS=0.02905P AD=0.02905P
+ PS=0.555U PD=0.555U
M$11 VSS B \$13 PWELL NMOS_VTL L=0.05U W=0.415U AS=0.02905P AD=0.0300875P
+ PS=0.555U PD=0.56U
M$12 \$13 A \$5 PWELL NMOS_VTL L=0.05U W=0.415U AS=0.0300875P AD=0.02905P
+ PS=0.56U PD=0.555U
M$13 \$5 C2 ZN PWELL NMOS_VTL L=0.05U W=0.83U AS=0.0581P AD=0.072625P PS=1.11U
+ PD=1.595U
M$14 ZN C1 \$5 PWELL NMOS_VTL L=0.05U W=0.83U AS=0.0581P AD=0.0581P PS=1.11U
+ PD=1.11U
.ENDS OAI211_X2

.SUBCKT NAND4_X2 A3 A2 A1 A4 ZN VDD PWELL VSS
M$1 VDD A4 ZN VDD PMOS_VTL L=0.05U W=1.26U AS=0.11025P AD=0.11025P PS=2.24U
+ PD=2.24U
M$2 ZN A3 VDD VDD PMOS_VTL L=0.05U W=1.26U AS=0.0882P AD=0.0882P PS=1.54U
+ PD=1.54U
M$3 VDD A2 ZN VDD PMOS_VTL L=0.05U W=1.26U AS=0.0882P AD=0.0882P PS=1.54U
+ PD=1.54U
M$4 ZN A1 VDD VDD PMOS_VTL L=0.05U W=1.26U AS=0.0882P AD=0.0882P PS=1.54U
+ PD=1.54U
M$9 VSS A4 \$15 PWELL NMOS_VTL L=0.05U W=0.415U AS=0.043575P AD=0.02905P
+ PS=1.04U PD=0.555U
M$10 \$15 A3 \$14 PWELL NMOS_VTL L=0.05U W=0.415U AS=0.02905P AD=0.02905P
+ PS=0.555U PD=0.555U
M$11 \$14 A2 \$13 PWELL NMOS_VTL L=0.05U W=0.415U AS=0.02905P AD=0.02905P
+ PS=0.555U PD=0.555U
M$12 \$13 A1 ZN PWELL NMOS_VTL L=0.05U W=0.415U AS=0.02905P AD=0.02905P
+ PS=0.555U PD=0.555U
M$13 ZN A1 \$10 PWELL NMOS_VTL L=0.05U W=0.415U AS=0.02905P AD=0.02905P
+ PS=0.555U PD=0.555U
M$14 \$10 A2 \$12 PWELL NMOS_VTL L=0.05U W=0.415U AS=0.02905P AD=0.02905P
+ PS=0.555U PD=0.555U
M$15 \$12 A3 \$11 PWELL NMOS_VTL L=0.05U W=0.415U AS=0.02905P AD=0.02905P
+ PS=0.555U PD=0.555U
M$16 \$11 A4 VSS PWELL NMOS_VTL L=0.05U W=0.415U AS=0.02905P AD=0.043575P
+ PS=0.555U PD=1.04U
.ENDS NAND4_X2

.SUBCKT AND2_X2 A1 A2 ZN VDD PWELL VSS
M$1 VDD A1 \$3 VDD PMOS_VTL L=0.05U W=0.63U AS=0.06615P AD=0.0441P PS=1.47U
+ PD=0.77U
M$2 \$3 A2 VDD VDD PMOS_VTL L=0.05U W=0.63U AS=0.0441P AD=0.0441P PS=0.77U
+ PD=0.77U
M$3 VDD \$3 ZN VDD PMOS_VTL L=0.05U W=1.26U AS=0.0882P AD=0.11025P PS=1.54U
+ PD=2.24U
M$5 \$3 A1 \$9 PWELL NMOS_VTL L=0.05U W=0.415U AS=0.043575P AD=0.02905P
+ PS=1.04U PD=0.555U
M$6 \$9 A2 VSS PWELL NMOS_VTL L=0.05U W=0.415U AS=0.02905P AD=0.02905P
+ PS=0.555U PD=0.555U
M$7 VSS \$3 ZN PWELL NMOS_VTL L=0.05U W=0.83U AS=0.0581P AD=0.072625P PS=1.11U
+ PD=1.595U
.ENDS AND2_X2

.SUBCKT AND3_X4 A3 A2 A1 ZN VDD PWELL VSS
M$1 VDD A3 \$4 VDD PMOS_VTL L=0.05U W=1.26U AS=0.11025P AD=0.0882P PS=2.24U
+ PD=1.54U
M$2 \$4 A2 VDD VDD PMOS_VTL L=0.05U W=1.26U AS=0.0882P AD=0.0882P PS=1.54U
+ PD=1.54U
M$3 VDD A1 \$4 VDD PMOS_VTL L=0.05U W=1.26U AS=0.0882P AD=0.0882P PS=1.54U
+ PD=1.54U
M$7 VDD \$4 ZN VDD PMOS_VTL L=0.05U W=2.52U AS=0.1764P AD=0.19845P PS=3.08U
+ PD=3.78U
M$11 VSS A3 \$13 PWELL NMOS_VTL L=0.05U W=0.415U AS=0.043575P AD=0.02905P
+ PS=1.04U PD=0.555U
M$12 \$13 A2 \$12 PWELL NMOS_VTL L=0.05U W=0.415U AS=0.02905P AD=0.02905P
+ PS=0.555U PD=0.555U
M$13 \$12 A1 \$4 PWELL NMOS_VTL L=0.05U W=0.415U AS=0.02905P AD=0.02905P
+ PS=0.555U PD=0.555U
M$14 \$4 A1 \$10 PWELL NMOS_VTL L=0.05U W=0.415U AS=0.02905P AD=0.02905P
+ PS=0.555U PD=0.555U
M$15 \$10 A2 \$11 PWELL NMOS_VTL L=0.05U W=0.415U AS=0.02905P AD=0.02905P
+ PS=0.555U PD=0.555U
M$16 \$11 A3 VSS PWELL NMOS_VTL L=0.05U W=0.415U AS=0.02905P AD=0.02905P
+ PS=0.555U PD=0.555U
M$17 VSS \$4 ZN PWELL NMOS_VTL L=0.05U W=1.66U AS=0.1162P AD=0.130725P PS=2.22U
+ PD=2.705U
.ENDS AND3_X4

.SUBCKT AND3_X1 A1 A2 A3 ZN VDD PWELL VSS
M$1 \$4 A1 VDD VDD PMOS_VTL L=0.05U W=0.315U AS=0.033075P AD=0.02205P PS=0.84U
+ PD=0.455U
M$2 VDD A2 \$4 VDD PMOS_VTL L=0.05U W=0.315U AS=0.02205P AD=0.02205P PS=0.455U
+ PD=0.455U
M$3 VDD A3 \$4 VDD PMOS_VTL L=0.05U W=0.315U AS=0.033075P AD=0.02205P PS=0.77U
+ PD=0.455U
M$4 VDD \$4 ZN VDD PMOS_VTL L=0.05U W=0.63U AS=0.033075P AD=0.06615P PS=0.77U
+ PD=1.47U
M$5 \$4 A1 \$10 PWELL NMOS_VTL L=0.05U W=0.21U AS=0.02205P AD=0.0147P PS=0.63U
+ PD=0.35U
M$6 \$10 A2 \$11 PWELL NMOS_VTL L=0.05U W=0.21U AS=0.0147P AD=0.0147P PS=0.35U
+ PD=0.35U
M$7 \$11 A3 VSS PWELL NMOS_VTL L=0.05U W=0.21U AS=0.0147P AD=0.021875P PS=0.35U
+ PD=0.555U
M$8 VSS \$4 ZN PWELL NMOS_VTL L=0.05U W=0.415U AS=0.021875P AD=0.043575P
+ PS=0.555U PD=1.04U
.ENDS AND3_X1

.SUBCKT OAI21_X4 A B2 B1 ZN VDD PWELL VSS
M$1 VDD A ZN VDD PMOS_VTL L=0.05U W=2.52U AS=0.19845P AD=0.1764P PS=3.78U
+ PD=3.08U
M$5 VDD B2 \$13 VDD PMOS_VTL L=0.05U W=0.63U AS=0.0441P AD=0.0441P PS=0.77U
+ PD=0.77U
M$6 \$13 B1 ZN VDD PMOS_VTL L=0.05U W=0.63U AS=0.0441P AD=0.0441P PS=0.77U
+ PD=0.77U
M$7 ZN B1 \$12 VDD PMOS_VTL L=0.05U W=0.63U AS=0.0441P AD=0.0441P PS=0.77U
+ PD=0.77U
M$8 \$12 B2 VDD VDD PMOS_VTL L=0.05U W=0.63U AS=0.0441P AD=0.0441P PS=0.77U
+ PD=0.77U
M$9 VDD B2 \$11 VDD PMOS_VTL L=0.05U W=0.63U AS=0.0441P AD=0.0441P PS=0.77U
+ PD=0.77U
M$10 \$11 B1 ZN VDD PMOS_VTL L=0.05U W=0.63U AS=0.0441P AD=0.0441P PS=0.77U
+ PD=0.77U
M$11 ZN B1 \$10 VDD PMOS_VTL L=0.05U W=0.63U AS=0.0441P AD=0.0441P PS=0.77U
+ PD=0.77U
M$12 \$10 B2 VDD VDD PMOS_VTL L=0.05U W=0.63U AS=0.0441P AD=0.06615P PS=0.77U
+ PD=1.47U
M$13 \$4 A VSS PWELL NMOS_VTL L=0.05U W=1.66U AS=0.130725P AD=0.1162P PS=2.705U
+ PD=2.22U
M$17 \$4 B2 ZN PWELL NMOS_VTL L=0.05U W=1.66U AS=0.1162P AD=0.130725P PS=2.22U
+ PD=2.705U
M$18 ZN B1 \$4 PWELL NMOS_VTL L=0.05U W=1.66U AS=0.1162P AD=0.1162P PS=2.22U
+ PD=2.22U
.ENDS OAI21_X4

.SUBCKT OAI211_X4 A B C2 ZN C1 VDD PWELL VSS
M$1 VDD A ZN VDD PMOS_VTL L=0.05U W=2.52U AS=0.19845P AD=0.1764P PS=3.78U
+ PD=3.08U
M$2 ZN B VDD VDD PMOS_VTL L=0.05U W=2.52U AS=0.1764P AD=0.1764P PS=3.08U
+ PD=3.08U
M$9 VDD C2 \$14 VDD PMOS_VTL L=0.05U W=0.63U AS=0.0441P AD=0.0441P PS=0.77U
+ PD=0.77U
M$10 \$14 C1 ZN VDD PMOS_VTL L=0.05U W=0.63U AS=0.0441P AD=0.0441P PS=0.77U
+ PD=0.77U
M$11 ZN C1 \$16 VDD PMOS_VTL L=0.05U W=0.63U AS=0.0441P AD=0.0441P PS=0.77U
+ PD=0.77U
M$12 \$16 C2 VDD VDD PMOS_VTL L=0.05U W=0.63U AS=0.0441P AD=0.0441P PS=0.77U
+ PD=0.77U
M$13 VDD C2 \$15 VDD PMOS_VTL L=0.05U W=0.63U AS=0.0441P AD=0.0441P PS=0.77U
+ PD=0.77U
M$14 \$15 C1 ZN VDD PMOS_VTL L=0.05U W=0.63U AS=0.0441P AD=0.0441P PS=0.77U
+ PD=0.77U
M$15 ZN C1 \$18 VDD PMOS_VTL L=0.05U W=0.63U AS=0.0441P AD=0.0441P PS=0.77U
+ PD=0.77U
M$16 \$18 C2 VDD VDD PMOS_VTL L=0.05U W=0.63U AS=0.0441P AD=0.06615P PS=0.77U
+ PD=1.47U
M$17 \$2 A \$8 PWELL NMOS_VTL L=0.05U W=0.415U AS=0.043575P AD=0.02905P
+ PS=1.04U PD=0.555U
M$18 \$8 B VSS PWELL NMOS_VTL L=0.05U W=0.415U AS=0.02905P AD=0.02905P
+ PS=0.555U PD=0.555U
M$19 VSS B \$10 PWELL NMOS_VTL L=0.05U W=0.415U AS=0.02905P AD=0.02905P
+ PS=0.555U PD=0.555U
M$20 \$10 A \$2 PWELL NMOS_VTL L=0.05U W=0.415U AS=0.02905P AD=0.02905P
+ PS=0.555U PD=0.555U
M$21 \$2 A \$9 PWELL NMOS_VTL L=0.05U W=0.415U AS=0.02905P AD=0.02905P
+ PS=0.555U PD=0.555U
M$22 \$9 B VSS PWELL NMOS_VTL L=0.05U W=0.415U AS=0.02905P AD=0.02905P
+ PS=0.555U PD=0.555U
M$23 VSS B \$11 PWELL NMOS_VTL L=0.05U W=0.415U AS=0.02905P AD=0.02905P
+ PS=0.555U PD=0.555U
M$24 \$11 A \$2 PWELL NMOS_VTL L=0.05U W=0.415U AS=0.02905P AD=0.02905P
+ PS=0.555U PD=0.555U
M$25 \$2 C2 ZN PWELL NMOS_VTL L=0.05U W=1.66U AS=0.1162P AD=0.130725P PS=2.22U
+ PD=2.705U
M$26 ZN C1 \$2 PWELL NMOS_VTL L=0.05U W=1.66U AS=0.1162P AD=0.1162P PS=2.22U
+ PD=2.22U
.ENDS OAI211_X4

.SUBCKT AND4_X1 A1 A2 A3 A4 ZN VDD PWELL VSS
M$1 VDD A1 \$5 VDD PMOS_VTL L=0.05U W=0.315U AS=0.033075P AD=0.02205P PS=0.84U
+ PD=0.455U
M$2 \$5 A2 VDD VDD PMOS_VTL L=0.05U W=0.315U AS=0.02205P AD=0.02205P PS=0.455U
+ PD=0.455U
M$3 VDD A3 \$5 VDD PMOS_VTL L=0.05U W=0.315U AS=0.02205P AD=0.02205P PS=0.455U
+ PD=0.455U
M$4 VDD A4 \$5 VDD PMOS_VTL L=0.05U W=0.315U AS=0.033075P AD=0.02205P PS=0.77U
+ PD=0.455U
M$5 VDD \$5 ZN VDD PMOS_VTL L=0.05U W=0.63U AS=0.033075P AD=0.06615P PS=0.77U
+ PD=1.47U
M$6 \$5 A1 \$12 PWELL NMOS_VTL L=0.05U W=0.21U AS=0.02205P AD=0.0147P PS=0.63U
+ PD=0.35U
M$7 \$12 A2 \$13 PWELL NMOS_VTL L=0.05U W=0.21U AS=0.0147P AD=0.0147P PS=0.35U
+ PD=0.35U
M$8 \$13 A3 \$11 PWELL NMOS_VTL L=0.05U W=0.21U AS=0.0147P AD=0.0147P PS=0.35U
+ PD=0.35U
M$9 \$11 A4 VSS PWELL NMOS_VTL L=0.05U W=0.21U AS=0.0147P AD=0.021875P PS=0.35U
+ PD=0.555U
M$10 VSS \$5 ZN PWELL NMOS_VTL L=0.05U W=0.415U AS=0.021875P AD=0.043575P
+ PS=0.555U PD=1.04U
.ENDS AND4_X1

.SUBCKT OAI33_X1 B3 B2 B1 A1 A2 A3 ZN VDD PWELL VSS
M$1 VDD B3 \$16 VDD PMOS_VTL L=0.05U W=0.63U AS=0.06615P AD=0.0441P PS=1.47U
+ PD=0.77U
M$2 \$16 B2 \$15 VDD PMOS_VTL L=0.05U W=0.63U AS=0.0441P AD=0.0441P PS=0.77U
+ PD=0.77U
M$3 \$15 B1 ZN VDD PMOS_VTL L=0.05U W=0.63U AS=0.0441P AD=0.0441P PS=0.77U
+ PD=0.77U
M$4 ZN A1 \$14 VDD PMOS_VTL L=0.05U W=0.63U AS=0.0441P AD=0.0441P PS=0.77U
+ PD=0.77U
M$5 \$14 A2 \$13 VDD PMOS_VTL L=0.05U W=0.63U AS=0.0441P AD=0.0441P PS=0.77U
+ PD=0.77U
M$6 \$13 A3 VDD VDD PMOS_VTL L=0.05U W=0.63U AS=0.0441P AD=0.06615P PS=0.77U
+ PD=1.47U
M$7 VSS B3 \$9 PWELL NMOS_VTL L=0.05U W=0.415U AS=0.043575P AD=0.02905P
+ PS=1.04U PD=0.555U
M$8 \$9 B2 VSS PWELL NMOS_VTL L=0.05U W=0.415U AS=0.02905P AD=0.02905P
+ PS=0.555U PD=0.555U
M$9 VSS B1 \$9 PWELL NMOS_VTL L=0.05U W=0.415U AS=0.02905P AD=0.02905P
+ PS=0.555U PD=0.555U
M$10 \$9 A1 ZN PWELL NMOS_VTL L=0.05U W=0.415U AS=0.02905P AD=0.02905P
+ PS=0.555U PD=0.555U
M$11 ZN A2 \$9 PWELL NMOS_VTL L=0.05U W=0.415U AS=0.02905P AD=0.02905P
+ PS=0.555U PD=0.555U
M$12 \$9 A3 ZN PWELL NMOS_VTL L=0.05U W=0.415U AS=0.02905P AD=0.043575P
+ PS=0.555U PD=1.04U
.ENDS OAI33_X1

.SUBCKT OR3_X1 A1 A2 A3 ZN VDD PWELL VSS
M$1 \$4 A1 \$11 VDD PMOS_VTL L=0.05U W=0.315U AS=0.033075P AD=0.02205P PS=0.84U
+ PD=0.455U
M$2 \$11 A2 \$10 VDD PMOS_VTL L=0.05U W=0.315U AS=0.02205P AD=0.02205P
+ PS=0.455U PD=0.455U
M$3 VDD A3 \$10 VDD PMOS_VTL L=0.05U W=0.315U AS=0.033075P AD=0.02205P PS=0.77U
+ PD=0.455U
M$4 VDD \$4 ZN VDD PMOS_VTL L=0.05U W=0.63U AS=0.033075P AD=0.06615P PS=0.77U
+ PD=1.47U
M$5 \$4 A1 VSS PWELL NMOS_VTL L=0.05U W=0.21U AS=0.02205P AD=0.0147P PS=0.63U
+ PD=0.35U
M$6 VSS A2 \$4 PWELL NMOS_VTL L=0.05U W=0.21U AS=0.0147P AD=0.0147P PS=0.35U
+ PD=0.35U
M$7 \$4 A3 VSS PWELL NMOS_VTL L=0.05U W=0.21U AS=0.0147P AD=0.021875P PS=0.35U
+ PD=0.555U
M$8 VSS \$4 ZN PWELL NMOS_VTL L=0.05U W=0.415U AS=0.021875P AD=0.043575P
+ PS=0.555U PD=1.04U
.ENDS OR3_X1

.SUBCKT INV_X32 A ZN VDD PWELL VSS
M$1 VDD A ZN VDD PMOS_VTL L=0.05U W=20.16U AS=1.43325P AD=1.43325P PS=25.34U
+ PD=25.34U
M$33 VSS A ZN PWELL NMOS_VTL L=0.05U W=13.28U AS=0.944125P AD=0.944125P
+ PS=18.245U PD=18.245U
.ENDS INV_X32

.SUBCKT OAI22_X4 B2 B1 A2 ZN A1 VDD PWELL VSS
M$1 VDD B2 \$10 VDD PMOS_VTL L=0.05U W=0.63U AS=0.06615P AD=0.0441P PS=1.47U
+ PD=0.77U
M$2 \$10 B1 ZN VDD PMOS_VTL L=0.05U W=0.63U AS=0.0441P AD=0.0441P PS=0.77U
+ PD=0.77U
M$3 ZN B1 \$12 VDD PMOS_VTL L=0.05U W=0.63U AS=0.0441P AD=0.0441P PS=0.77U
+ PD=0.77U
M$4 \$12 B2 VDD VDD PMOS_VTL L=0.05U W=0.63U AS=0.0441P AD=0.0441P PS=0.77U
+ PD=0.77U
M$5 VDD B2 \$11 VDD PMOS_VTL L=0.05U W=0.63U AS=0.0441P AD=0.0441P PS=0.77U
+ PD=0.77U
M$6 \$11 B1 ZN VDD PMOS_VTL L=0.05U W=0.63U AS=0.0441P AD=0.0441P PS=0.77U
+ PD=0.77U
M$7 ZN B1 \$13 VDD PMOS_VTL L=0.05U W=0.63U AS=0.0441P AD=0.0441P PS=0.77U
+ PD=0.77U
M$8 \$13 B2 VDD VDD PMOS_VTL L=0.05U W=0.63U AS=0.0441P AD=0.0441P PS=0.77U
+ PD=0.77U
M$9 VDD A2 \$14 VDD PMOS_VTL L=0.05U W=0.63U AS=0.0441P AD=0.0441P PS=0.77U
+ PD=0.77U
M$10 \$14 A1 ZN VDD PMOS_VTL L=0.05U W=0.63U AS=0.0441P AD=0.0441P PS=0.77U
+ PD=0.77U
M$11 ZN A1 \$15 VDD PMOS_VTL L=0.05U W=0.63U AS=0.0441P AD=0.0441P PS=0.77U
+ PD=0.77U
M$12 \$15 A2 VDD VDD PMOS_VTL L=0.05U W=0.63U AS=0.0441P AD=0.0441P PS=0.77U
+ PD=0.77U
M$13 VDD A2 \$16 VDD PMOS_VTL L=0.05U W=0.63U AS=0.0441P AD=0.0441P PS=0.77U
+ PD=0.77U
M$14 \$16 A1 ZN VDD PMOS_VTL L=0.05U W=0.63U AS=0.0441P AD=0.0441P PS=0.77U
+ PD=0.77U
M$15 ZN A1 \$18 VDD PMOS_VTL L=0.05U W=0.63U AS=0.0441P AD=0.0441P PS=0.77U
+ PD=0.77U
M$16 \$18 A2 VDD VDD PMOS_VTL L=0.05U W=0.63U AS=0.0441P AD=0.06615P PS=0.77U
+ PD=1.47U
M$17 \$2 B2 VSS PWELL NMOS_VTL L=0.05U W=1.66U AS=0.130725P AD=0.1162P
+ PS=2.705U PD=2.22U
M$18 VSS B1 \$2 PWELL NMOS_VTL L=0.05U W=1.66U AS=0.1162P AD=0.1162P PS=2.22U
+ PD=2.22U
M$25 \$2 A2 ZN PWELL NMOS_VTL L=0.05U W=1.66U AS=0.1162P AD=0.130725P PS=2.22U
+ PD=2.705U
M$26 ZN A1 \$2 PWELL NMOS_VTL L=0.05U W=1.66U AS=0.1162P AD=0.1162P PS=2.22U
+ PD=2.22U
.ENDS OAI22_X4

.SUBCKT LOGIC0_X1 Z VDD PWELL VSS
M$1 \$2 \$2 VDD VDD PMOS_VTL L=0.05U W=0.09U AS=0.00945P AD=0.00945P PS=0.39U
+ PD=0.39U
M$2 Z \$2 VSS PWELL NMOS_VTL L=0.05U W=0.09U AS=0.00945P AD=0.00945P PS=0.39U
+ PD=0.39U
.ENDS LOGIC0_X1

.SUBCKT AOI22_X4 B2 B1 ZN A2 A1 VDD PWELL VSS
M$1 \$15 B2 VDD VDD PMOS_VTL L=0.05U W=2.52U AS=0.19845P AD=0.1764P PS=3.78U
+ PD=3.08U
M$2 VDD B1 \$15 VDD PMOS_VTL L=0.05U W=2.52U AS=0.1764P AD=0.1764P PS=3.08U
+ PD=3.08U
M$9 \$15 A2 ZN VDD PMOS_VTL L=0.05U W=2.52U AS=0.1764P AD=0.19845P PS=3.08U
+ PD=3.78U
M$10 ZN A1 \$15 VDD PMOS_VTL L=0.05U W=2.52U AS=0.1764P AD=0.1764P PS=3.08U
+ PD=3.08U
M$17 VSS B2 \$7 PWELL NMOS_VTL L=0.05U W=0.415U AS=0.043575P AD=0.02905P
+ PS=1.04U PD=0.555U
M$18 \$7 B1 ZN PWELL NMOS_VTL L=0.05U W=0.415U AS=0.02905P AD=0.02905P
+ PS=0.555U PD=0.555U
M$19 ZN B1 \$10 PWELL NMOS_VTL L=0.05U W=0.415U AS=0.02905P AD=0.02905P
+ PS=0.555U PD=0.555U
M$20 \$10 B2 VSS PWELL NMOS_VTL L=0.05U W=0.415U AS=0.02905P AD=0.02905P
+ PS=0.555U PD=0.555U
M$21 VSS B2 \$8 PWELL NMOS_VTL L=0.05U W=0.415U AS=0.02905P AD=0.02905P
+ PS=0.555U PD=0.555U
M$22 \$8 B1 ZN PWELL NMOS_VTL L=0.05U W=0.415U AS=0.02905P AD=0.02905P
+ PS=0.555U PD=0.555U
M$23 ZN B1 \$12 PWELL NMOS_VTL L=0.05U W=0.415U AS=0.02905P AD=0.02905P
+ PS=0.555U PD=0.555U
M$24 \$12 B2 VSS PWELL NMOS_VTL L=0.05U W=0.415U AS=0.02905P AD=0.02905P
+ PS=0.555U PD=0.555U
M$25 VSS A2 \$13 PWELL NMOS_VTL L=0.05U W=0.415U AS=0.02905P AD=0.02905P
+ PS=0.555U PD=0.555U
M$26 \$13 A1 ZN PWELL NMOS_VTL L=0.05U W=0.415U AS=0.02905P AD=0.02905P
+ PS=0.555U PD=0.555U
M$27 ZN A1 \$11 PWELL NMOS_VTL L=0.05U W=0.415U AS=0.02905P AD=0.02905P
+ PS=0.555U PD=0.555U
M$28 \$11 A2 VSS PWELL NMOS_VTL L=0.05U W=0.415U AS=0.02905P AD=0.02905P
+ PS=0.555U PD=0.555U
M$29 VSS A2 \$14 PWELL NMOS_VTL L=0.05U W=0.415U AS=0.02905P AD=0.02905P
+ PS=0.555U PD=0.555U
M$30 \$14 A1 ZN PWELL NMOS_VTL L=0.05U W=0.415U AS=0.02905P AD=0.02905P
+ PS=0.555U PD=0.555U
M$31 ZN A1 \$9 PWELL NMOS_VTL L=0.05U W=0.415U AS=0.02905P AD=0.02905P
+ PS=0.555U PD=0.555U
M$32 \$9 A2 VSS PWELL NMOS_VTL L=0.05U W=0.415U AS=0.02905P AD=0.043575P
+ PS=0.555U PD=1.04U
.ENDS AOI22_X4

.SUBCKT AOI21_X2 A B2 B1 ZN VDD PWELL VSS
M$1 \$5 A VDD VDD PMOS_VTL L=0.05U W=1.26U AS=0.11025P AD=0.0882P PS=2.24U
+ PD=1.54U
M$3 \$5 B2 ZN VDD PMOS_VTL L=0.05U W=1.26U AS=0.0882P AD=0.11025P PS=1.54U
+ PD=2.24U
M$4 ZN B1 \$5 VDD PMOS_VTL L=0.05U W=1.26U AS=0.0882P AD=0.0882P PS=1.54U
+ PD=1.54U
M$7 VSS A ZN PWELL NMOS_VTL L=0.05U W=0.83U AS=0.072625P AD=0.0581P PS=1.595U
+ PD=1.11U
M$9 VSS B2 \$11 PWELL NMOS_VTL L=0.05U W=0.415U AS=0.02905P AD=0.02905P
+ PS=0.555U PD=0.555U
M$10 \$11 B1 ZN PWELL NMOS_VTL L=0.05U W=0.415U AS=0.02905P AD=0.02905P
+ PS=0.555U PD=0.555U
M$11 ZN B1 \$10 PWELL NMOS_VTL L=0.05U W=0.415U AS=0.02905P AD=0.02905P
+ PS=0.555U PD=0.555U
M$12 \$10 B2 VSS PWELL NMOS_VTL L=0.05U W=0.415U AS=0.02905P AD=0.043575P
+ PS=0.555U PD=1.04U
.ENDS AOI21_X2

.SUBCKT CLKBUF_X3 A Z VDD PWELL VSS
M$1 \$2 A VDD VDD PMOS_VTL L=0.05U W=0.63U AS=0.06615P AD=0.0441P PS=1.47U
+ PD=0.77U
M$2 VDD \$2 Z VDD PMOS_VTL L=0.05U W=1.89U AS=0.1323P AD=0.15435P PS=2.31U
+ PD=3.01U
M$5 \$2 A VSS PWELL NMOS_VTL L=0.05U W=0.195U AS=0.020475P AD=0.01365P PS=0.6U
+ PD=0.335U
M$6 VSS \$2 Z PWELL NMOS_VTL L=0.05U W=0.585U AS=0.04095P AD=0.047775P
+ PS=1.005U PD=1.27U
.ENDS CLKBUF_X3

.SUBCKT BUF_X2 A Z VDD PWELL VSS
M$1 \$2 A VDD VDD PMOS_VTL L=0.05U W=0.63U AS=0.06615P AD=0.0441P PS=1.47U
+ PD=0.77U
M$2 VDD \$2 Z VDD PMOS_VTL L=0.05U W=1.26U AS=0.0882P AD=0.11025P PS=1.54U
+ PD=2.24U
M$4 \$2 A VSS PWELL NMOS_VTL L=0.05U W=0.415U AS=0.043575P AD=0.02905P PS=1.04U
+ PD=0.555U
M$5 VSS \$2 Z PWELL NMOS_VTL L=0.05U W=0.83U AS=0.0581P AD=0.072625P PS=1.11U
+ PD=1.595U
.ENDS BUF_X2

.SUBCKT NAND4_X4 A3 A4 A1 A2 ZN VDD PWELL VSS
M$1 ZN A1 VDD VDD PMOS_VTL L=0.05U W=2.52U AS=0.19845P AD=0.1764P PS=3.78U
+ PD=3.08U
M$5 ZN A2 VDD VDD PMOS_VTL L=0.05U W=2.52U AS=0.1764P AD=0.22365P PS=3.08U
+ PD=3.23U
M$9 ZN A3 VDD VDD PMOS_VTL L=0.05U W=2.52U AS=0.22365P AD=0.1764P PS=3.23U
+ PD=3.08U
M$13 ZN A4 VDD VDD PMOS_VTL L=0.05U W=2.52U AS=0.1764P AD=0.19845P PS=3.08U
+ PD=3.78U
M$17 \$6 A3 \$5 PWELL NMOS_VTL L=0.05U W=1.66U AS=0.130725P AD=0.1162P
+ PS=2.705U PD=2.22U
M$21 \$6 A4 VSS PWELL NMOS_VTL L=0.05U W=1.66U AS=0.1162P AD=0.130725P PS=2.22U
+ PD=2.705U
M$25 \$4 A1 ZN PWELL NMOS_VTL L=0.05U W=1.66U AS=0.130725P AD=0.1162P PS=2.705U
+ PD=2.22U
M$29 \$4 A2 \$5 PWELL NMOS_VTL L=0.05U W=1.66U AS=0.1162P AD=0.130725P PS=2.22U
+ PD=2.705U
.ENDS NAND4_X4

.SUBCKT NOR4_X1 A4 A3 A2 A1 ZN VDD PWELL VSS
M$1 VDD A4 \$12 VDD PMOS_VTL L=0.05U W=0.63U AS=0.06615P AD=0.0441P PS=1.47U
+ PD=0.77U
M$2 \$12 A3 \$11 VDD PMOS_VTL L=0.05U W=0.63U AS=0.0441P AD=0.0441P PS=0.77U
+ PD=0.77U
M$3 \$11 A2 \$10 VDD PMOS_VTL L=0.05U W=0.63U AS=0.0441P AD=0.0441P PS=0.77U
+ PD=0.77U
M$4 \$10 A1 ZN VDD PMOS_VTL L=0.05U W=0.63U AS=0.0441P AD=0.06615P PS=0.77U
+ PD=1.47U
M$5 VSS A4 ZN PWELL NMOS_VTL L=0.05U W=0.415U AS=0.043575P AD=0.02905P PS=1.04U
+ PD=0.555U
M$6 ZN A3 VSS PWELL NMOS_VTL L=0.05U W=0.415U AS=0.02905P AD=0.02905P PS=0.555U
+ PD=0.555U
M$7 VSS A2 ZN PWELL NMOS_VTL L=0.05U W=0.415U AS=0.02905P AD=0.02905P PS=0.555U
+ PD=0.555U
M$8 ZN A1 VSS PWELL NMOS_VTL L=0.05U W=0.415U AS=0.02905P AD=0.043575P
+ PS=0.555U PD=1.04U
.ENDS NOR4_X1

.SUBCKT OAI21_X2 A B2 B1 ZN VDD PWELL VSS
M$1 VDD A ZN VDD PMOS_VTL L=0.05U W=1.26U AS=0.11025P AD=0.0882P PS=2.24U
+ PD=1.54U
M$3 VDD B2 \$10 VDD PMOS_VTL L=0.05U W=0.63U AS=0.0441P AD=0.0441P PS=0.77U
+ PD=0.77U
M$4 \$10 B1 ZN VDD PMOS_VTL L=0.05U W=0.63U AS=0.0441P AD=0.0441P PS=0.77U
+ PD=0.77U
M$5 ZN B1 \$11 VDD PMOS_VTL L=0.05U W=0.63U AS=0.0441P AD=0.0441P PS=0.77U
+ PD=0.77U
M$6 \$11 B2 VDD VDD PMOS_VTL L=0.05U W=0.63U AS=0.0441P AD=0.06615P PS=0.77U
+ PD=1.47U
M$7 \$4 A VSS PWELL NMOS_VTL L=0.05U W=0.83U AS=0.072625P AD=0.0581P PS=1.595U
+ PD=1.11U
M$9 \$4 B2 ZN PWELL NMOS_VTL L=0.05U W=0.83U AS=0.0581P AD=0.072625P PS=1.11U
+ PD=1.595U
M$10 ZN B1 \$4 PWELL NMOS_VTL L=0.05U W=0.83U AS=0.0581P AD=0.0581P PS=1.11U
+ PD=1.11U
.ENDS OAI21_X2

.SUBCKT FA_X1 B CO S CI A VDD PWELL VSS
M$1 VDD B \$18 VDD PMOS_VTL L=0.05U W=0.315U AS=0.033075P AD=0.02205P PS=0.77U
+ PD=0.455U
M$2 \$18 A \$4 VDD PMOS_VTL L=0.05U W=0.315U AS=0.02205P AD=0.02205P PS=0.455U
+ PD=0.455U
M$3 \$4 CI \$16 VDD PMOS_VTL L=0.05U W=0.315U AS=0.02205P AD=0.02265P PS=0.455U
+ PD=0.535U
M$4 \$16 A VDD VDD PMOS_VTL L=0.05U W=0.315U AS=0.02265P AD=0.02205P PS=0.535U
+ PD=0.455U
M$5 VDD B \$16 VDD PMOS_VTL L=0.05U W=0.315U AS=0.02205P AD=0.033075P PS=0.455U
+ PD=0.84U
M$6 CO \$4 VDD VDD PMOS_VTL L=0.05U W=0.63U AS=0.06615P AD=0.033075P PS=1.47U
+ PD=0.77U
M$7 VDD B \$17 VDD PMOS_VTL L=0.05U W=0.315U AS=0.033075P AD=0.02205P PS=0.84U
+ PD=0.455U
M$8 \$17 CI VDD VDD PMOS_VTL L=0.05U W=0.315U AS=0.02205P AD=0.02205P PS=0.455U
+ PD=0.455U
M$9 VDD A \$17 VDD PMOS_VTL L=0.05U W=0.315U AS=0.02205P AD=0.02205P PS=0.455U
+ PD=0.455U
M$10 \$17 \$4 \$7 VDD PMOS_VTL L=0.05U W=0.315U AS=0.02205P AD=0.023625P
+ PS=0.455U PD=0.465U
M$11 \$7 CI \$19 VDD PMOS_VTL L=0.05U W=0.315U AS=0.023625P AD=0.02205P
+ PS=0.465U PD=0.455U
M$12 \$19 B \$20 VDD PMOS_VTL L=0.05U W=0.315U AS=0.02205P AD=0.02205P
+ PS=0.455U PD=0.455U
M$13 VDD A \$20 VDD PMOS_VTL L=0.05U W=0.315U AS=0.033075P AD=0.02205P PS=0.77U
+ PD=0.455U
M$14 VDD \$7 S VDD PMOS_VTL L=0.05U W=0.63U AS=0.033075P AD=0.06615P PS=0.77U
+ PD=1.47U
M$15 VSS B \$14 PWELL NMOS_VTL L=0.05U W=0.21U AS=0.021875P AD=0.0147P
+ PS=0.555U PD=0.35U
M$16 \$14 A \$4 PWELL NMOS_VTL L=0.05U W=0.21U AS=0.0147P AD=0.0147P PS=0.35U
+ PD=0.35U
M$17 \$4 CI \$5 PWELL NMOS_VTL L=0.05U W=0.21U AS=0.0147P AD=0.015225P PS=0.35U
+ PD=0.355U
M$18 \$5 A VSS PWELL NMOS_VTL L=0.05U W=0.21U AS=0.015225P AD=0.0147P PS=0.355U
+ PD=0.35U
M$19 VSS B \$5 PWELL NMOS_VTL L=0.05U W=0.21U AS=0.0147P AD=0.02205P PS=0.35U
+ PD=0.63U
M$20 CO \$4 VSS PWELL NMOS_VTL L=0.05U W=0.415U AS=0.043575P AD=0.021875P
+ PS=1.04U PD=0.555U
M$21 VSS B \$6 PWELL NMOS_VTL L=0.05U W=0.21U AS=0.02205P AD=0.0147P PS=0.63U
+ PD=0.35U
M$22 \$6 CI VSS PWELL NMOS_VTL L=0.05U W=0.21U AS=0.0147P AD=0.0147P PS=0.35U
+ PD=0.35U
M$23 VSS A \$6 PWELL NMOS_VTL L=0.05U W=0.21U AS=0.0147P AD=0.0147P PS=0.35U
+ PD=0.35U
M$24 \$6 \$4 \$7 PWELL NMOS_VTL L=0.05U W=0.21U AS=0.0147P AD=0.01575P PS=0.35U
+ PD=0.36U
M$25 \$7 CI \$9 PWELL NMOS_VTL L=0.05U W=0.21U AS=0.01575P AD=0.0147P PS=0.36U
+ PD=0.35U
M$26 \$9 B \$10 PWELL NMOS_VTL L=0.05U W=0.21U AS=0.0147P AD=0.0147P PS=0.35U
+ PD=0.35U
M$27 \$10 A VSS PWELL NMOS_VTL L=0.05U W=0.21U AS=0.0147P AD=0.021875P PS=0.35U
+ PD=0.555U
M$28 VSS \$7 S PWELL NMOS_VTL L=0.05U W=0.415U AS=0.021875P AD=0.043575P
+ PS=0.555U PD=1.04U
.ENDS FA_X1

.SUBCKT OR2_X2 A1 A2 ZN VDD PWELL VSS
M$1 \$4 A1 \$9 VDD PMOS_VTL L=0.05U W=0.63U AS=0.06615P AD=0.0441P PS=1.47U
+ PD=0.77U
M$2 \$9 A2 VDD VDD PMOS_VTL L=0.05U W=0.63U AS=0.0441P AD=0.0441P PS=0.77U
+ PD=0.77U
M$3 VDD \$4 ZN VDD PMOS_VTL L=0.05U W=1.26U AS=0.0882P AD=0.11025P PS=1.54U
+ PD=2.24U
M$5 VSS A1 \$4 PWELL NMOS_VTL L=0.05U W=0.415U AS=0.043575P AD=0.02905P
+ PS=1.04U PD=0.555U
M$6 \$4 A2 VSS PWELL NMOS_VTL L=0.05U W=0.415U AS=0.02905P AD=0.02905P
+ PS=0.555U PD=0.555U
M$7 VSS \$4 ZN PWELL NMOS_VTL L=0.05U W=0.83U AS=0.0581P AD=0.072625P PS=1.11U
+ PD=1.595U
.ENDS OR2_X2

.SUBCKT NAND2_X2 A2 A1 ZN VDD PWELL VSS
M$1 VDD A2 ZN VDD PMOS_VTL L=0.05U W=1.26U AS=0.11025P AD=0.11025P PS=2.24U
+ PD=2.24U
M$2 ZN A1 VDD VDD PMOS_VTL L=0.05U W=1.26U AS=0.0882P AD=0.0882P PS=1.54U
+ PD=1.54U
M$5 VSS A2 \$9 PWELL NMOS_VTL L=0.05U W=0.415U AS=0.043575P AD=0.02905P
+ PS=1.04U PD=0.555U
M$6 \$9 A1 ZN PWELL NMOS_VTL L=0.05U W=0.415U AS=0.02905P AD=0.02905P PS=0.555U
+ PD=0.555U
M$7 ZN A1 \$8 PWELL NMOS_VTL L=0.05U W=0.415U AS=0.02905P AD=0.02905P PS=0.555U
+ PD=0.555U
M$8 \$8 A2 VSS PWELL NMOS_VTL L=0.05U W=0.415U AS=0.02905P AD=0.043575P
+ PS=0.555U PD=1.04U
.ENDS NAND2_X2

.SUBCKT XNOR2_X1 A B ZN VDD PWELL VSS
M$1 VDD A \$3 VDD PMOS_VTL L=0.05U W=0.315U AS=0.033075P AD=0.02205P PS=0.84U
+ PD=0.455U
M$2 VDD B \$3 VDD PMOS_VTL L=0.05U W=0.315U AS=0.0338625P AD=0.02205P PS=0.775U
+ PD=0.455U
M$3 VDD \$3 ZN VDD PMOS_VTL L=0.05U W=0.63U AS=0.0338625P AD=0.0441P PS=0.775U
+ PD=0.77U
M$4 ZN A \$10 VDD PMOS_VTL L=0.05U W=0.63U AS=0.0441P AD=0.0441P PS=0.77U
+ PD=0.77U
M$5 \$10 B VDD VDD PMOS_VTL L=0.05U W=0.63U AS=0.0441P AD=0.06615P PS=0.77U
+ PD=1.47U
M$6 \$3 A \$11 PWELL NMOS_VTL L=0.05U W=0.21U AS=0.02205P AD=0.0147P PS=0.63U
+ PD=0.35U
M$7 \$11 B VSS PWELL NMOS_VTL L=0.05U W=0.21U AS=0.0147P AD=0.0224P PS=0.35U
+ PD=0.56U
M$8 VSS \$3 \$6 PWELL NMOS_VTL L=0.05U W=0.415U AS=0.0224P AD=0.02905P PS=0.56U
+ PD=0.555U
M$9 \$6 A ZN PWELL NMOS_VTL L=0.05U W=0.415U AS=0.02905P AD=0.02905P PS=0.555U
+ PD=0.555U
M$10 ZN B \$6 PWELL NMOS_VTL L=0.05U W=0.415U AS=0.02905P AD=0.043575P
+ PS=0.555U PD=1.04U
.ENDS XNOR2_X1

.SUBCKT BUF_X32 A Z VDD PWELL VSS
M$1 VDD A \$3 VDD PMOS_VTL L=0.05U W=10.08U AS=0.729225P AD=0.707175P
+ PS=13.025U PD=12.325U
M$17 VDD \$3 Z VDD PMOS_VTL L=0.05U W=20.16U AS=1.4175P AD=1.43955P PS=24.66U
+ PD=25.36U
M$49 VSS A \$3 PWELL NMOS_VTL L=0.05U W=6.64U AS=0.4803625P AD=0.4658375P
+ PS=9.37U PD=8.885U
M$65 VSS \$3 Z PWELL NMOS_VTL L=0.05U W=13.28U AS=0.93375P AD=0.948275P
+ PS=17.78U PD=18.265U
.ENDS BUF_X32

.SUBCKT INV_X4 A ZN VDD PWELL VSS
M$1 VDD A ZN VDD PMOS_VTL L=0.05U W=2.52U AS=0.19845P AD=0.19845P PS=3.78U
+ PD=3.78U
M$5 VSS A ZN PWELL NMOS_VTL L=0.05U W=1.66U AS=0.130725P AD=0.130725P PS=2.705U
+ PD=2.705U
.ENDS INV_X4

.SUBCKT XOR2_X1 A B Z VDD PWELL VSS
M$1 \$2 A \$10 VDD PMOS_VTL L=0.05U W=0.315U AS=0.033075P AD=0.02205P PS=0.84U
+ PD=0.455U
M$2 VDD B \$10 VDD PMOS_VTL L=0.05U W=0.315U AS=0.0338625P AD=0.02205P
+ PS=0.775U PD=0.455U
M$3 VDD \$2 \$7 VDD PMOS_VTL L=0.05U W=0.63U AS=0.0338625P AD=0.0441P PS=0.775U
+ PD=0.77U
M$4 \$7 A Z VDD PMOS_VTL L=0.05U W=0.63U AS=0.0441P AD=0.0441P PS=0.77U PD=0.77U
M$5 Z B \$7 VDD PMOS_VTL L=0.05U W=0.63U AS=0.0441P AD=0.06615P PS=0.77U
+ PD=1.47U
M$6 VSS A \$2 PWELL NMOS_VTL L=0.05U W=0.21U AS=0.02205P AD=0.0147P PS=0.63U
+ PD=0.35U
M$7 \$2 B VSS PWELL NMOS_VTL L=0.05U W=0.21U AS=0.0147P AD=0.0224P PS=0.35U
+ PD=0.56U
M$8 VSS \$2 Z PWELL NMOS_VTL L=0.05U W=0.415U AS=0.0224P AD=0.02905P PS=0.56U
+ PD=0.555U
M$9 Z A \$11 PWELL NMOS_VTL L=0.05U W=0.415U AS=0.02905P AD=0.02905P PS=0.555U
+ PD=0.555U
M$10 \$11 B VSS PWELL NMOS_VTL L=0.05U W=0.415U AS=0.02905P AD=0.043575P
+ PS=0.555U PD=1.04U
.ENDS XOR2_X1

.SUBCKT XNOR2_X2 A B ZN VDD PWELL VSS
M$1 \$8 A ZN VDD PMOS_VTL L=0.05U W=0.63U AS=0.06615P AD=0.0441P PS=1.47U
+ PD=0.77U
M$2 ZN A \$11 VDD PMOS_VTL L=0.05U W=0.63U AS=0.0441P AD=0.0441P PS=0.77U
+ PD=0.77U
M$3 \$11 B VDD VDD PMOS_VTL L=0.05U W=0.63U AS=0.0441P AD=0.0441P PS=0.77U
+ PD=0.77U
M$4 VDD B \$8 VDD PMOS_VTL L=0.05U W=0.63U AS=0.0441P AD=0.06615P PS=0.77U
+ PD=1.47U
M$5 VDD \$1 ZN VDD PMOS_VTL L=0.05U W=1.26U AS=0.11025P AD=0.0882P PS=2.24U
+ PD=1.54U
M$7 VDD B \$1 VDD PMOS_VTL L=0.05U W=0.63U AS=0.0441P AD=0.0441P PS=0.77U
+ PD=0.77U
M$8 \$1 A VDD VDD PMOS_VTL L=0.05U W=0.63U AS=0.0441P AD=0.06615P PS=0.77U
+ PD=1.47U
M$9 ZN A \$6 PWELL NMOS_VTL L=0.05U W=0.83U AS=0.072625P AD=0.0581P PS=1.595U
+ PD=1.11U
M$11 ZN B \$6 PWELL NMOS_VTL L=0.05U W=0.83U AS=0.0581P AD=0.072625P PS=1.11U
+ PD=1.595U
M$13 VSS \$1 \$6 PWELL NMOS_VTL L=0.05U W=0.83U AS=0.072625P AD=0.0581P
+ PS=1.595U PD=1.11U
M$15 VSS B \$12 PWELL NMOS_VTL L=0.05U W=0.415U AS=0.02905P AD=0.02905P
+ PS=0.555U PD=0.555U
M$16 \$12 A \$1 PWELL NMOS_VTL L=0.05U W=0.415U AS=0.02905P AD=0.043575P
+ PS=0.555U PD=1.04U
.ENDS XNOR2_X2

.SUBCKT OR4_X4 ZN A4 A3 A2 A1 VDD PWELL VSS
M$1 VDD A4 \$11 VDD PMOS_VTL L=0.05U W=0.63U AS=0.06615P AD=0.0441P PS=1.47U
+ PD=0.77U
M$2 \$11 A3 \$10 VDD PMOS_VTL L=0.05U W=0.63U AS=0.0441P AD=0.0441P PS=0.77U
+ PD=0.77U
M$3 \$10 A2 \$12 VDD PMOS_VTL L=0.05U W=0.63U AS=0.0441P AD=0.0441P PS=0.77U
+ PD=0.77U
M$4 \$12 A1 \$2 VDD PMOS_VTL L=0.05U W=0.63U AS=0.0441P AD=0.0441P PS=0.77U
+ PD=0.77U
M$5 \$2 A1 \$14 VDD PMOS_VTL L=0.05U W=0.63U AS=0.0441P AD=0.0441P PS=0.77U
+ PD=0.77U
M$6 \$14 A2 \$15 VDD PMOS_VTL L=0.05U W=0.63U AS=0.0441P AD=0.0441P PS=0.77U
+ PD=0.77U
M$7 \$15 A3 \$13 VDD PMOS_VTL L=0.05U W=0.63U AS=0.0441P AD=0.0441P PS=0.77U
+ PD=0.77U
M$8 \$13 A4 VDD VDD PMOS_VTL L=0.05U W=0.63U AS=0.0441P AD=0.0441P PS=0.77U
+ PD=0.77U
M$9 VDD \$2 ZN VDD PMOS_VTL L=0.05U W=2.52U AS=0.1764P AD=0.19845P PS=3.08U
+ PD=3.78U
M$13 VSS A4 \$2 PWELL NMOS_VTL L=0.05U W=0.83U AS=0.072625P AD=0.0581P
+ PS=1.595U PD=1.11U
M$14 \$2 A3 VSS PWELL NMOS_VTL L=0.05U W=0.83U AS=0.0581P AD=0.0581P PS=1.11U
+ PD=1.11U
M$15 VSS A2 \$2 PWELL NMOS_VTL L=0.05U W=0.83U AS=0.0581P AD=0.0581P PS=1.11U
+ PD=1.11U
M$16 \$2 A1 VSS PWELL NMOS_VTL L=0.05U W=0.83U AS=0.0581P AD=0.0581P PS=1.11U
+ PD=1.11U
M$21 VSS \$2 ZN PWELL NMOS_VTL L=0.05U W=1.66U AS=0.1162P AD=0.130725P PS=2.22U
+ PD=2.705U
.ENDS OR4_X4

.SUBCKT OR3_X4 A3 A2 A1 ZN VDD PWELL VSS
M$1 VDD A3 \$13 VDD PMOS_VTL L=0.05U W=0.63U AS=0.06615P AD=0.0441P PS=1.47U
+ PD=0.77U
M$2 \$13 A2 \$12 VDD PMOS_VTL L=0.05U W=0.63U AS=0.0441P AD=0.0441P PS=0.77U
+ PD=0.77U
M$3 \$12 A1 \$4 VDD PMOS_VTL L=0.05U W=0.63U AS=0.0441P AD=0.0441P PS=0.77U
+ PD=0.77U
M$4 \$4 A1 \$11 VDD PMOS_VTL L=0.05U W=0.63U AS=0.0441P AD=0.0441P PS=0.77U
+ PD=0.77U
M$5 \$11 A2 \$10 VDD PMOS_VTL L=0.05U W=0.63U AS=0.0441P AD=0.0441P PS=0.77U
+ PD=0.77U
M$6 \$10 A3 VDD VDD PMOS_VTL L=0.05U W=0.63U AS=0.0441P AD=0.0441P PS=0.77U
+ PD=0.77U
M$7 VDD \$4 ZN VDD PMOS_VTL L=0.05U W=2.52U AS=0.177975P AD=0.200025P PS=3.085U
+ PD=3.785U
M$11 VSS A3 \$4 PWELL NMOS_VTL L=0.05U W=0.83U AS=0.072625P AD=0.0581P
+ PS=1.595U PD=1.11U
M$12 \$4 A2 VSS PWELL NMOS_VTL L=0.05U W=0.83U AS=0.0581P AD=0.0581P PS=1.11U
+ PD=1.11U
M$13 VSS A1 \$4 PWELL NMOS_VTL L=0.05U W=0.83U AS=0.0581P AD=0.0581P PS=1.11U
+ PD=1.11U
M$17 VSS \$4 ZN PWELL NMOS_VTL L=0.05U W=1.66U AS=0.1172375P AD=0.1317625P
+ PS=2.225U PD=2.71U
.ENDS OR3_X4

.SUBCKT OR2_X1 A1 A2 ZN VDD PWELL VSS
M$1 \$4 A1 \$9 VDD PMOS_VTL L=0.05U W=0.315U AS=0.033075P AD=0.02205P PS=0.84U
+ PD=0.455U
M$2 VDD A2 \$9 VDD PMOS_VTL L=0.05U W=0.315U AS=0.033075P AD=0.02205P PS=0.77U
+ PD=0.455U
M$3 VDD \$4 ZN VDD PMOS_VTL L=0.05U W=0.63U AS=0.033075P AD=0.06615P PS=0.77U
+ PD=1.47U
M$4 VSS A1 \$4 PWELL NMOS_VTL L=0.05U W=0.21U AS=0.02205P AD=0.0147P PS=0.63U
+ PD=0.35U
M$5 \$4 A2 VSS PWELL NMOS_VTL L=0.05U W=0.21U AS=0.0147P AD=0.021875P PS=0.35U
+ PD=0.555U
M$6 VSS \$4 ZN PWELL NMOS_VTL L=0.05U W=0.415U AS=0.021875P AD=0.043575P
+ PS=0.555U PD=1.04U
.ENDS OR2_X1

.SUBCKT OAI22_X2 B2 B1 A2 A1 ZN VDD PWELL VSS
M$1 VDD B2 \$12 VDD PMOS_VTL L=0.05U W=0.63U AS=0.06615P AD=0.0441P PS=1.47U
+ PD=0.77U
M$2 \$12 B1 ZN VDD PMOS_VTL L=0.05U W=0.63U AS=0.0441P AD=0.0441P PS=0.77U
+ PD=0.77U
M$3 ZN B1 \$11 VDD PMOS_VTL L=0.05U W=0.63U AS=0.0441P AD=0.0441P PS=0.77U
+ PD=0.77U
M$4 \$11 B2 VDD VDD PMOS_VTL L=0.05U W=0.63U AS=0.0441P AD=0.0441P PS=0.77U
+ PD=0.77U
M$5 VDD A2 \$14 VDD PMOS_VTL L=0.05U W=0.63U AS=0.0441P AD=0.0441P PS=0.77U
+ PD=0.77U
M$6 \$14 A1 ZN VDD PMOS_VTL L=0.05U W=0.63U AS=0.0441P AD=0.0441P PS=0.77U
+ PD=0.77U
M$7 ZN A1 \$13 VDD PMOS_VTL L=0.05U W=0.63U AS=0.0441P AD=0.0441P PS=0.77U
+ PD=0.77U
M$8 \$13 A2 VDD VDD PMOS_VTL L=0.05U W=0.63U AS=0.0441P AD=0.06615P PS=0.77U
+ PD=1.47U
M$9 \$5 B2 VSS PWELL NMOS_VTL L=0.05U W=0.83U AS=0.072625P AD=0.0581P PS=1.595U
+ PD=1.11U
M$10 VSS B1 \$5 PWELL NMOS_VTL L=0.05U W=0.83U AS=0.0581P AD=0.0581P PS=1.11U
+ PD=1.11U
M$13 \$5 A2 ZN PWELL NMOS_VTL L=0.05U W=0.83U AS=0.0581P AD=0.072625P PS=1.11U
+ PD=1.595U
M$14 ZN A1 \$5 PWELL NMOS_VTL L=0.05U W=0.83U AS=0.0581P AD=0.0581P PS=1.11U
+ PD=1.11U
.ENDS OAI22_X2

.SUBCKT OAI22_X1 B2 B1 A1 A2 ZN VDD PWELL VSS
M$1 VDD B2 \$12 VDD PMOS_VTL L=0.05U W=0.63U AS=0.06615P AD=0.0441P PS=1.47U
+ PD=0.77U
M$2 \$12 B1 ZN VDD PMOS_VTL L=0.05U W=0.63U AS=0.0441P AD=0.0441P PS=0.77U
+ PD=0.77U
M$3 ZN A1 \$11 VDD PMOS_VTL L=0.05U W=0.63U AS=0.0441P AD=0.0441P PS=0.77U
+ PD=0.77U
M$4 \$11 A2 VDD VDD PMOS_VTL L=0.05U W=0.63U AS=0.0441P AD=0.06615P PS=0.77U
+ PD=1.47U
M$5 \$5 B2 VSS PWELL NMOS_VTL L=0.05U W=0.415U AS=0.043575P AD=0.02905P
+ PS=1.04U PD=0.555U
M$6 VSS B1 \$5 PWELL NMOS_VTL L=0.05U W=0.415U AS=0.02905P AD=0.02905P
+ PS=0.555U PD=0.555U
M$7 \$5 A1 ZN PWELL NMOS_VTL L=0.05U W=0.415U AS=0.02905P AD=0.02905P PS=0.555U
+ PD=0.555U
M$8 ZN A2 \$5 PWELL NMOS_VTL L=0.05U W=0.415U AS=0.02905P AD=0.043575P
+ PS=0.555U PD=1.04U
.ENDS OAI22_X1

.SUBCKT OAI222_X2 C1 C2 B1 B2 A1 A2 ZN VDD PWELL VSS
M$1 ZN C1 \$13 VDD PMOS_VTL L=0.05U W=0.63U AS=0.06615P AD=0.0441P PS=1.47U
+ PD=0.77U
M$2 \$13 C2 VDD VDD PMOS_VTL L=0.05U W=0.63U AS=0.0441P AD=0.0441P PS=0.77U
+ PD=0.77U
M$3 VDD C2 \$14 VDD PMOS_VTL L=0.05U W=0.63U AS=0.0441P AD=0.0441P PS=0.77U
+ PD=0.77U
M$4 \$14 C1 ZN VDD PMOS_VTL L=0.05U W=0.63U AS=0.0441P AD=0.0441P PS=0.77U
+ PD=0.77U
M$5 ZN B1 \$15 VDD PMOS_VTL L=0.05U W=0.63U AS=0.0441P AD=0.0441P PS=0.77U
+ PD=0.77U
M$6 \$15 B2 VDD VDD PMOS_VTL L=0.05U W=0.63U AS=0.0441P AD=0.0441P PS=0.77U
+ PD=0.77U
M$7 VDD B2 \$16 VDD PMOS_VTL L=0.05U W=0.63U AS=0.0441P AD=0.0441P PS=0.77U
+ PD=0.77U
M$8 \$16 B1 ZN VDD PMOS_VTL L=0.05U W=0.63U AS=0.0441P AD=0.0945P PS=0.77U
+ PD=0.93U
M$9 ZN A1 \$17 VDD PMOS_VTL L=0.05U W=0.63U AS=0.0945P AD=0.0441P PS=0.93U
+ PD=0.77U
M$10 \$17 A2 VDD VDD PMOS_VTL L=0.05U W=0.63U AS=0.0441P AD=0.0441P PS=0.77U
+ PD=0.77U
M$11 VDD A2 \$19 VDD PMOS_VTL L=0.05U W=0.63U AS=0.0441P AD=0.0441P PS=0.77U
+ PD=0.77U
M$12 \$19 A1 ZN VDD PMOS_VTL L=0.05U W=0.63U AS=0.0441P AD=0.0693P PS=0.77U
+ PD=1.48U
M$13 \$3 A1 ZN PWELL NMOS_VTL L=0.05U W=0.83U AS=0.072625P AD=0.072625P
+ PS=1.595U PD=1.595U
M$14 ZN A2 \$3 PWELL NMOS_VTL L=0.05U W=0.83U AS=0.0581P AD=0.0581P PS=1.11U
+ PD=1.11U
M$17 \$2 C1 VSS PWELL NMOS_VTL L=0.05U W=0.83U AS=0.072625P AD=0.0581P
+ PS=1.595U PD=1.11U
M$18 VSS C2 \$2 PWELL NMOS_VTL L=0.05U W=0.83U AS=0.0581P AD=0.0581P PS=1.11U
+ PD=1.11U
M$21 \$2 B1 \$3 PWELL NMOS_VTL L=0.05U W=0.83U AS=0.0581P AD=0.072625P PS=1.11U
+ PD=1.595U
M$22 \$3 B2 \$2 PWELL NMOS_VTL L=0.05U W=0.83U AS=0.0581P AD=0.0581P PS=1.11U
+ PD=1.11U
.ENDS OAI222_X2

.SUBCKT OAI221_X2 C2 C1 B1 B2 A ZN VDD PWELL VSS
M$1 VDD C2 \$14 VDD PMOS_VTL L=0.05U W=0.63U AS=0.06615P AD=0.0441P PS=1.47U
+ PD=0.77U
M$2 \$14 C1 ZN VDD PMOS_VTL L=0.05U W=0.63U AS=0.0441P AD=0.0441P PS=0.77U
+ PD=0.77U
M$3 ZN C1 \$13 VDD PMOS_VTL L=0.05U W=0.63U AS=0.0441P AD=0.0441P PS=0.77U
+ PD=0.77U
M$4 \$13 C2 VDD VDD PMOS_VTL L=0.05U W=0.63U AS=0.0441P AD=0.0441P PS=0.77U
+ PD=0.77U
M$5 VDD A ZN VDD PMOS_VTL L=0.05U W=1.26U AS=0.0882P AD=0.11025P PS=1.54U
+ PD=2.24U
M$6 ZN B1 \$16 VDD PMOS_VTL L=0.05U W=0.63U AS=0.0441P AD=0.0441P PS=0.77U
+ PD=0.77U
M$7 \$16 B2 VDD VDD PMOS_VTL L=0.05U W=0.63U AS=0.0441P AD=0.0441P PS=0.77U
+ PD=0.77U
M$8 VDD B2 \$15 VDD PMOS_VTL L=0.05U W=0.63U AS=0.0441P AD=0.0441P PS=0.77U
+ PD=0.77U
M$9 \$15 B1 ZN VDD PMOS_VTL L=0.05U W=0.63U AS=0.0441P AD=0.0441P PS=0.77U
+ PD=0.77U
M$11 \$6 C2 ZN PWELL NMOS_VTL L=0.05U W=0.83U AS=0.072625P AD=0.0581P PS=1.595U
+ PD=1.11U
M$12 ZN C1 \$6 PWELL NMOS_VTL L=0.05U W=0.83U AS=0.0581P AD=0.0581P PS=1.11U
+ PD=1.11U
M$15 \$6 A \$8 PWELL NMOS_VTL L=0.05U W=0.83U AS=0.0581P AD=0.072625P PS=1.11U
+ PD=1.595U
M$16 \$8 B1 VSS PWELL NMOS_VTL L=0.05U W=0.83U AS=0.0581P AD=0.0581P PS=1.11U
+ PD=1.11U
M$17 VSS B2 \$8 PWELL NMOS_VTL L=0.05U W=0.83U AS=0.0581P AD=0.0581P PS=1.11U
+ PD=1.11U
.ENDS OAI221_X2

.SUBCKT OAI221_X1 B2 B1 A C2 C1 ZN VDD PWELL VSS
M$1 VDD B2 \$14 VDD PMOS_VTL L=0.05U W=0.63U AS=0.06615P AD=0.0441P PS=1.47U
+ PD=0.77U
M$2 \$14 B1 ZN VDD PMOS_VTL L=0.05U W=0.63U AS=0.0441P AD=0.0441P PS=0.77U
+ PD=0.77U
M$3 ZN A VDD VDD PMOS_VTL L=0.05U W=0.63U AS=0.0441P AD=0.0441P PS=0.77U
+ PD=0.77U
M$4 VDD C2 \$13 VDD PMOS_VTL L=0.05U W=0.63U AS=0.0441P AD=0.0441P PS=0.77U
+ PD=0.77U
M$5 \$13 C1 ZN VDD PMOS_VTL L=0.05U W=0.63U AS=0.0441P AD=0.06615P PS=0.77U
+ PD=1.47U
M$6 \$6 B2 VSS PWELL NMOS_VTL L=0.05U W=0.415U AS=0.043575P AD=0.02905P
+ PS=1.04U PD=0.555U
M$7 VSS B1 \$6 PWELL NMOS_VTL L=0.05U W=0.415U AS=0.02905P AD=0.02905P
+ PS=0.555U PD=0.555U
M$8 \$6 A \$10 PWELL NMOS_VTL L=0.05U W=0.415U AS=0.02905P AD=0.02905P
+ PS=0.555U PD=0.555U
M$9 \$10 C2 ZN PWELL NMOS_VTL L=0.05U W=0.415U AS=0.02905P AD=0.02905P
+ PS=0.555U PD=0.555U
M$10 ZN C1 \$10 PWELL NMOS_VTL L=0.05U W=0.415U AS=0.02905P AD=0.043575P
+ PS=0.555U PD=1.04U
.ENDS OAI221_X1

.SUBCKT OAI21_X1 B2 B1 A ZN VDD PWELL VSS
M$1 VDD B2 \$10 VDD PMOS_VTL L=0.05U W=0.63U AS=0.06615P AD=0.0441P PS=1.47U
+ PD=0.77U
M$2 \$10 B1 ZN VDD PMOS_VTL L=0.05U W=0.63U AS=0.0441P AD=0.0441P PS=0.77U
+ PD=0.77U
M$3 ZN A VDD VDD PMOS_VTL L=0.05U W=0.63U AS=0.0441P AD=0.06615P PS=0.77U
+ PD=1.47U
M$4 \$4 B2 ZN PWELL NMOS_VTL L=0.05U W=0.415U AS=0.043575P AD=0.02905P PS=1.04U
+ PD=0.555U
M$5 ZN B1 \$4 PWELL NMOS_VTL L=0.05U W=0.415U AS=0.02905P AD=0.02905P PS=0.555U
+ PD=0.555U
M$6 \$4 A VSS PWELL NMOS_VTL L=0.05U W=0.415U AS=0.02905P AD=0.043575P
+ PS=0.555U PD=1.04U
.ENDS OAI21_X1

.SUBCKT NOR4_X2 A3 A2 A1 A4 ZN VDD PWELL VSS
M$1 VDD A4 \$14 VDD PMOS_VTL L=0.05U W=0.63U AS=0.06615P AD=0.0441P PS=1.47U
+ PD=0.77U
M$2 \$14 A3 \$13 VDD PMOS_VTL L=0.05U W=0.63U AS=0.0441P AD=0.0441P PS=0.77U
+ PD=0.77U
M$3 \$13 A2 \$12 VDD PMOS_VTL L=0.05U W=0.63U AS=0.0441P AD=0.0441P PS=0.77U
+ PD=0.77U
M$4 \$12 A1 ZN VDD PMOS_VTL L=0.05U W=0.63U AS=0.0441P AD=0.0441P PS=0.77U
+ PD=0.77U
M$5 ZN A1 \$11 VDD PMOS_VTL L=0.05U W=0.63U AS=0.0441P AD=0.0441P PS=0.77U
+ PD=0.77U
M$6 \$11 A2 \$15 VDD PMOS_VTL L=0.05U W=0.63U AS=0.0441P AD=0.0441P PS=0.77U
+ PD=0.77U
M$7 \$15 A3 \$10 VDD PMOS_VTL L=0.05U W=0.63U AS=0.0441P AD=0.0441P PS=0.77U
+ PD=0.77U
M$8 \$10 A4 VDD VDD PMOS_VTL L=0.05U W=0.63U AS=0.0441P AD=0.06615P PS=0.77U
+ PD=1.47U
M$9 VSS A4 ZN PWELL NMOS_VTL L=0.05U W=0.83U AS=0.072625P AD=0.072625P
+ PS=1.595U PD=1.595U
M$10 ZN A3 VSS PWELL NMOS_VTL L=0.05U W=0.83U AS=0.0581P AD=0.0581P PS=1.11U
+ PD=1.11U
M$11 VSS A2 ZN PWELL NMOS_VTL L=0.05U W=0.83U AS=0.0581P AD=0.0581P PS=1.11U
+ PD=1.11U
M$12 ZN A1 VSS PWELL NMOS_VTL L=0.05U W=0.83U AS=0.0581P AD=0.0581P PS=1.11U
+ PD=1.11U
.ENDS NOR4_X2

.SUBCKT NOR3_X4 A1 A2 A3 ZN VDD PWELL VSS
M$1 \$8 A1 ZN VDD PMOS_VTL L=0.05U W=2.52U AS=0.19845P AD=0.1764P PS=3.78U
+ PD=3.08U
M$5 \$8 A2 \$6 VDD PMOS_VTL L=0.05U W=2.52U AS=0.1764P AD=0.19845P PS=3.08U
+ PD=3.78U
M$9 VDD A3 \$6 VDD PMOS_VTL L=0.05U W=2.52U AS=0.19845P AD=0.19845P PS=3.78U
+ PD=3.78U
M$13 VSS A1 ZN PWELL NMOS_VTL L=0.05U W=1.66U AS=0.130725P AD=0.1162P PS=2.705U
+ PD=2.22U
M$17 VSS A2 ZN PWELL NMOS_VTL L=0.05U W=1.66U AS=0.1162P AD=0.130725P PS=2.22U
+ PD=2.705U
M$21 VSS A3 ZN PWELL NMOS_VTL L=0.05U W=1.66U AS=0.130725P AD=0.130725P
+ PS=2.705U PD=2.705U
.ENDS NOR3_X4

.SUBCKT NOR3_X2 A3 A2 A1 ZN VDD PWELL VSS
M$1 VDD A3 \$12 VDD PMOS_VTL L=0.05U W=0.63U AS=0.06615P AD=0.0441P PS=1.47U
+ PD=0.77U
M$2 \$12 A2 \$11 VDD PMOS_VTL L=0.05U W=0.63U AS=0.0441P AD=0.0441P PS=0.77U
+ PD=0.77U
M$3 \$11 A1 ZN VDD PMOS_VTL L=0.05U W=0.63U AS=0.0441P AD=0.0441P PS=0.77U
+ PD=0.77U
M$4 ZN A1 \$10 VDD PMOS_VTL L=0.05U W=0.63U AS=0.0441P AD=0.0441P PS=0.77U
+ PD=0.77U
M$5 \$10 A2 \$9 VDD PMOS_VTL L=0.05U W=0.63U AS=0.0441P AD=0.0441P PS=0.77U
+ PD=0.77U
M$6 \$9 A3 VDD VDD PMOS_VTL L=0.05U W=0.63U AS=0.0441P AD=0.06615P PS=0.77U
+ PD=1.47U
M$7 VSS A3 ZN PWELL NMOS_VTL L=0.05U W=0.83U AS=0.072625P AD=0.072625P
+ PS=1.595U PD=1.595U
M$8 ZN A2 VSS PWELL NMOS_VTL L=0.05U W=0.83U AS=0.0581P AD=0.0581P PS=1.11U
+ PD=1.11U
M$9 VSS A1 ZN PWELL NMOS_VTL L=0.05U W=0.83U AS=0.0581P AD=0.0581P PS=1.11U
+ PD=1.11U
.ENDS NOR3_X2

.SUBCKT NOR3_X1 A3 A2 A1 ZN VDD PWELL VSS
M$1 VDD A3 \$10 VDD PMOS_VTL L=0.05U W=0.63U AS=0.06615P AD=0.0441P PS=1.47U
+ PD=0.77U
M$2 \$10 A2 \$9 VDD PMOS_VTL L=0.05U W=0.63U AS=0.0441P AD=0.0441P PS=0.77U
+ PD=0.77U
M$3 \$9 A1 ZN VDD PMOS_VTL L=0.05U W=0.63U AS=0.0441P AD=0.06615P PS=0.77U
+ PD=1.47U
M$4 VSS A3 ZN PWELL NMOS_VTL L=0.05U W=0.415U AS=0.043575P AD=0.02905P PS=1.04U
+ PD=0.555U
M$5 ZN A2 VSS PWELL NMOS_VTL L=0.05U W=0.415U AS=0.02905P AD=0.02905P PS=0.555U
+ PD=0.555U
M$6 VSS A1 ZN PWELL NMOS_VTL L=0.05U W=0.415U AS=0.02905P AD=0.043575P
+ PS=0.555U PD=1.04U
.ENDS NOR3_X1

.SUBCKT NOR2_X4 A2 A1 ZN VDD PWELL VSS
M$1 VDD A2 \$11 VDD PMOS_VTL L=0.05U W=0.63U AS=0.06615P AD=0.0441P PS=1.47U
+ PD=0.77U
M$2 \$11 A1 ZN VDD PMOS_VTL L=0.05U W=0.63U AS=0.0441P AD=0.0441P PS=0.77U
+ PD=0.77U
M$3 ZN A1 \$10 VDD PMOS_VTL L=0.05U W=0.63U AS=0.0441P AD=0.0441P PS=0.77U
+ PD=0.77U
M$4 \$10 A2 VDD VDD PMOS_VTL L=0.05U W=0.63U AS=0.0441P AD=0.0441P PS=0.77U
+ PD=0.77U
M$5 VDD A2 \$9 VDD PMOS_VTL L=0.05U W=0.63U AS=0.0441P AD=0.0441P PS=0.77U
+ PD=0.77U
M$6 \$9 A1 ZN VDD PMOS_VTL L=0.05U W=0.63U AS=0.0441P AD=0.0441P PS=0.77U
+ PD=0.77U
M$7 ZN A1 \$8 VDD PMOS_VTL L=0.05U W=0.63U AS=0.0441P AD=0.0441P PS=0.77U
+ PD=0.77U
M$8 \$8 A2 VDD VDD PMOS_VTL L=0.05U W=0.63U AS=0.0441P AD=0.06615P PS=0.77U
+ PD=1.47U
M$9 VSS A2 ZN PWELL NMOS_VTL L=0.05U W=1.66U AS=0.130725P AD=0.130725P
+ PS=2.705U PD=2.705U
M$10 ZN A1 VSS PWELL NMOS_VTL L=0.05U W=1.66U AS=0.1162P AD=0.1162P PS=2.22U
+ PD=2.22U
.ENDS NOR2_X4

.SUBCKT NOR2_X2 A2 A1 ZN VDD PWELL VSS
M$1 VDD A2 \$9 VDD PMOS_VTL L=0.05U W=0.63U AS=0.06615P AD=0.0441P PS=1.47U
+ PD=0.77U
M$2 \$9 A1 ZN VDD PMOS_VTL L=0.05U W=0.63U AS=0.0441P AD=0.0441P PS=0.77U
+ PD=0.77U
M$3 ZN A1 \$8 VDD PMOS_VTL L=0.05U W=0.63U AS=0.0441P AD=0.0441P PS=0.77U
+ PD=0.77U
M$4 \$8 A2 VDD VDD PMOS_VTL L=0.05U W=0.63U AS=0.0441P AD=0.06615P PS=0.77U
+ PD=1.47U
M$5 VSS A2 ZN PWELL NMOS_VTL L=0.05U W=0.83U AS=0.072625P AD=0.072625P
+ PS=1.595U PD=1.595U
M$6 ZN A1 VSS PWELL NMOS_VTL L=0.05U W=0.83U AS=0.0581P AD=0.0581P PS=1.11U
+ PD=1.11U
.ENDS NOR2_X2

.SUBCKT NOR2_X1 A2 A1 ZN VDD PWELL VSS
M$1 VDD A2 \$8 VDD PMOS_VTL L=0.05U W=0.63U AS=0.06615P AD=0.0441P PS=1.47U
+ PD=0.77U
M$2 \$8 A1 ZN VDD PMOS_VTL L=0.05U W=0.63U AS=0.0441P AD=0.06615P PS=0.77U
+ PD=1.47U
M$3 VSS A2 ZN PWELL NMOS_VTL L=0.05U W=0.415U AS=0.043575P AD=0.02905P PS=1.04U
+ PD=0.555U
M$4 ZN A1 VSS PWELL NMOS_VTL L=0.05U W=0.415U AS=0.02905P AD=0.043575P
+ PS=0.555U PD=1.04U
.ENDS NOR2_X1

.SUBCKT NAND3_X4 A2 A1 A3 ZN VDD PWELL VSS
M$1 VDD A3 ZN VDD PMOS_VTL L=0.05U W=2.52U AS=0.19845P AD=0.19845P PS=3.78U
+ PD=3.78U
M$2 ZN A2 VDD VDD PMOS_VTL L=0.05U W=2.52U AS=0.1764P AD=0.1764P PS=3.08U
+ PD=3.08U
M$3 VDD A1 ZN VDD PMOS_VTL L=0.05U W=2.52U AS=0.1764P AD=0.1764P PS=3.08U
+ PD=3.08U
M$13 VSS A3 \$15 PWELL NMOS_VTL L=0.05U W=0.415U AS=0.043575P AD=0.02905P
+ PS=1.04U PD=0.555U
M$14 \$15 A2 \$14 PWELL NMOS_VTL L=0.05U W=0.415U AS=0.02905P AD=0.02905P
+ PS=0.555U PD=0.555U
M$15 \$14 A1 ZN PWELL NMOS_VTL L=0.05U W=0.415U AS=0.02905P AD=0.02905P
+ PS=0.555U PD=0.555U
M$16 ZN A1 \$12 PWELL NMOS_VTL L=0.05U W=0.415U AS=0.02905P AD=0.02905P
+ PS=0.555U PD=0.555U
M$17 \$12 A2 \$10 PWELL NMOS_VTL L=0.05U W=0.415U AS=0.02905P AD=0.02905P
+ PS=0.555U PD=0.555U
M$18 \$10 A3 VSS PWELL NMOS_VTL L=0.05U W=0.415U AS=0.02905P AD=0.02905P
+ PS=0.555U PD=0.555U
M$19 VSS A3 \$11 PWELL NMOS_VTL L=0.05U W=0.415U AS=0.02905P AD=0.02905P
+ PS=0.555U PD=0.555U
M$20 \$11 A2 \$9 PWELL NMOS_VTL L=0.05U W=0.415U AS=0.02905P AD=0.02905P
+ PS=0.555U PD=0.555U
M$21 \$9 A1 ZN PWELL NMOS_VTL L=0.05U W=0.415U AS=0.02905P AD=0.02905P
+ PS=0.555U PD=0.555U
M$22 ZN A1 \$16 PWELL NMOS_VTL L=0.05U W=0.415U AS=0.02905P AD=0.02905P
+ PS=0.555U PD=0.555U
M$23 \$16 A2 \$13 PWELL NMOS_VTL L=0.05U W=0.415U AS=0.02905P AD=0.02905P
+ PS=0.555U PD=0.555U
M$24 \$13 A3 VSS PWELL NMOS_VTL L=0.05U W=0.415U AS=0.02905P AD=0.043575P
+ PS=0.555U PD=1.04U
.ENDS NAND3_X4

.SUBCKT NAND3_X2 A3 A2 A1 ZN VDD PWELL VSS
M$1 VDD A3 ZN VDD PMOS_VTL L=0.05U W=1.26U AS=0.11025P AD=0.11025P PS=2.24U
+ PD=2.24U
M$2 ZN A2 VDD VDD PMOS_VTL L=0.05U W=1.26U AS=0.0882P AD=0.0882P PS=1.54U
+ PD=1.54U
M$3 VDD A1 ZN VDD PMOS_VTL L=0.05U W=1.26U AS=0.0882P AD=0.0882P PS=1.54U
+ PD=1.54U
M$7 VSS A3 \$12 PWELL NMOS_VTL L=0.05U W=0.415U AS=0.043575P AD=0.02905P
+ PS=1.04U PD=0.555U
M$8 \$12 A2 \$11 PWELL NMOS_VTL L=0.05U W=0.415U AS=0.02905P AD=0.02905P
+ PS=0.555U PD=0.555U
M$9 \$11 A1 ZN PWELL NMOS_VTL L=0.05U W=0.415U AS=0.02905P AD=0.02905P
+ PS=0.555U PD=0.555U
M$10 ZN A1 \$10 PWELL NMOS_VTL L=0.05U W=0.415U AS=0.02905P AD=0.02905P
+ PS=0.555U PD=0.555U
M$11 \$10 A2 \$9 PWELL NMOS_VTL L=0.05U W=0.415U AS=0.02905P AD=0.02905P
+ PS=0.555U PD=0.555U
M$12 \$9 A3 VSS PWELL NMOS_VTL L=0.05U W=0.415U AS=0.02905P AD=0.043575P
+ PS=0.555U PD=1.04U
.ENDS NAND3_X2

.SUBCKT NAND3_X1 A3 A2 A1 ZN VDD PWELL VSS
M$1 VDD A3 ZN VDD PMOS_VTL L=0.05U W=0.63U AS=0.06615P AD=0.0441P PS=1.47U
+ PD=0.77U
M$2 ZN A2 VDD VDD PMOS_VTL L=0.05U W=0.63U AS=0.0441P AD=0.0441P PS=0.77U
+ PD=0.77U
M$3 VDD A1 ZN VDD PMOS_VTL L=0.05U W=0.63U AS=0.0441P AD=0.06615P PS=0.77U
+ PD=1.47U
M$4 VSS A3 \$10 PWELL NMOS_VTL L=0.05U W=0.415U AS=0.043575P AD=0.02905P
+ PS=1.04U PD=0.555U
M$5 \$10 A2 \$9 PWELL NMOS_VTL L=0.05U W=0.415U AS=0.02905P AD=0.02905P
+ PS=0.555U PD=0.555U
M$6 \$9 A1 ZN PWELL NMOS_VTL L=0.05U W=0.415U AS=0.02905P AD=0.043575P
+ PS=0.555U PD=1.04U
.ENDS NAND3_X1

.SUBCKT NAND2_X4 A2 A1 ZN VDD PWELL VSS
M$1 VDD A2 ZN VDD PMOS_VTL L=0.05U W=2.52U AS=0.19845P AD=0.1764P PS=3.78U
+ PD=3.08U
M$5 VDD A1 ZN VDD PMOS_VTL L=0.05U W=2.52U AS=0.1764P AD=0.19845P PS=3.08U
+ PD=3.78U
M$9 \$3 A2 VSS PWELL NMOS_VTL L=0.05U W=1.66U AS=0.130725P AD=0.1162P PS=2.705U
+ PD=2.22U
M$13 \$3 A1 ZN PWELL NMOS_VTL L=0.05U W=1.66U AS=0.1162P AD=0.130725P PS=2.22U
+ PD=2.705U
.ENDS NAND2_X4

.SUBCKT NAND2_X1 A2 A1 ZN VDD PWELL VSS
M$1 VDD A2 ZN VDD PMOS_VTL L=0.05U W=0.63U AS=0.06615P AD=0.0441P PS=1.47U
+ PD=0.77U
M$2 ZN A1 VDD VDD PMOS_VTL L=0.05U W=0.63U AS=0.0441P AD=0.06615P PS=0.77U
+ PD=1.47U
M$3 VSS A2 \$8 PWELL NMOS_VTL L=0.05U W=0.415U AS=0.043575P AD=0.02905P
+ PS=1.04U PD=0.555U
M$4 \$8 A1 ZN PWELL NMOS_VTL L=0.05U W=0.415U AS=0.02905P AD=0.043575P
+ PS=0.555U PD=1.04U
.ENDS NAND2_X1

.SUBCKT MUX2_X2 A B S Z VDD PWELL VSS
M$1 VDD \$4 Z VDD PMOS_VTL L=0.05U W=1.26U AS=0.11025P AD=0.077175P PS=2.24U
+ PD=1.54U
M$3 VDD S \$9 VDD PMOS_VTL L=0.05U W=0.315U AS=0.033075P AD=0.033075P PS=0.77U
+ PD=0.84U
M$4 \$5 A VDD VDD PMOS_VTL L=0.05U W=0.63U AS=0.06615P AD=0.0441P PS=1.47U
+ PD=0.77U
M$5 VDD \$9 \$5 VDD PMOS_VTL L=0.05U W=0.63U AS=0.0441P AD=0.0441P PS=0.77U
+ PD=0.77U
M$6 \$5 B \$4 VDD PMOS_VTL L=0.05U W=0.63U AS=0.0441P AD=0.045675P PS=0.77U
+ PD=0.775U
M$7 \$4 S \$5 VDD PMOS_VTL L=0.05U W=0.63U AS=0.045675P AD=0.0693P PS=0.775U
+ PD=1.48U
M$8 VSS S \$9 PWELL NMOS_VTL L=0.05U W=0.21U AS=0.021875P AD=0.02205P PS=0.555U
+ PD=0.63U
M$9 VSS \$4 Z PWELL NMOS_VTL L=0.05U W=0.83U AS=0.072625P AD=0.050925P
+ PS=1.595U PD=1.11U
M$11 \$4 A \$13 PWELL NMOS_VTL L=0.05U W=0.415U AS=0.043575P AD=0.02905P
+ PS=1.04U PD=0.555U
M$12 \$13 \$9 VSS PWELL NMOS_VTL L=0.05U W=0.415U AS=0.02905P AD=0.02905P
+ PS=0.555U PD=0.555U
M$13 VSS B \$12 PWELL NMOS_VTL L=0.05U W=0.415U AS=0.02905P AD=0.0300875P
+ PS=0.555U PD=0.56U
M$14 \$12 S \$4 PWELL NMOS_VTL L=0.05U W=0.415U AS=0.0300875P AD=0.043575P
+ PS=0.56U PD=1.04U
.ENDS MUX2_X2

.SUBCKT MUX2_X1 A S B Z VDD PWELL VSS
M$1 \$4 S VDD VDD PMOS_VTL L=0.05U W=0.315U AS=0.033075P AD=0.02205P PS=0.84U
+ PD=0.455U
M$2 VDD A \$11 VDD PMOS_VTL L=0.05U W=0.315U AS=0.02205P AD=0.02205P PS=0.455U
+ PD=0.455U
M$3 \$11 S \$7 VDD PMOS_VTL L=0.05U W=0.315U AS=0.02205P AD=0.02205P PS=0.455U
+ PD=0.455U
M$4 \$7 \$4 \$12 VDD PMOS_VTL L=0.05U W=0.315U AS=0.02205P AD=0.02205P
+ PS=0.455U PD=0.455U
M$5 VDD B \$12 VDD PMOS_VTL L=0.05U W=0.315U AS=0.033075P AD=0.02205P PS=0.77U
+ PD=0.455U
M$6 VDD \$7 Z VDD PMOS_VTL L=0.05U W=0.63U AS=0.033075P AD=0.06615P PS=0.77U
+ PD=1.47U
M$7 \$4 S VSS PWELL NMOS_VTL L=0.05U W=0.21U AS=0.02205P AD=0.0147P PS=0.63U
+ PD=0.35U
M$8 VSS A \$14 PWELL NMOS_VTL L=0.05U W=0.21U AS=0.0147P AD=0.0147P PS=0.35U
+ PD=0.35U
M$9 \$14 \$4 \$7 PWELL NMOS_VTL L=0.05U W=0.21U AS=0.0147P AD=0.0147P PS=0.35U
+ PD=0.35U
M$10 \$7 S \$13 PWELL NMOS_VTL L=0.05U W=0.21U AS=0.0147P AD=0.0147P PS=0.35U
+ PD=0.35U
M$11 \$13 B VSS PWELL NMOS_VTL L=0.05U W=0.21U AS=0.0147P AD=0.021875P PS=0.35U
+ PD=0.555U
M$12 VSS \$7 Z PWELL NMOS_VTL L=0.05U W=0.415U AS=0.021875P AD=0.043575P
+ PS=0.555U PD=1.04U
.ENDS MUX2_X1

.SUBCKT INV_X2 A ZN VDD PWELL VSS
M$1 VDD A ZN VDD PMOS_VTL L=0.05U W=1.26U AS=0.11025P AD=0.11025P PS=2.24U
+ PD=2.24U
M$3 VSS A ZN PWELL NMOS_VTL L=0.05U W=0.83U AS=0.072625P AD=0.072625P PS=1.595U
+ PD=1.595U
.ENDS INV_X2

.SUBCKT INV_X1 A ZN VDD PWELL VSS
M$1 VDD A ZN VDD PMOS_VTL L=0.05U W=0.63U AS=0.06615P AD=0.06615P PS=1.47U
+ PD=1.47U
M$2 VSS A ZN PWELL NMOS_VTL L=0.05U W=0.415U AS=0.043575P AD=0.043575P PS=1.04U
+ PD=1.04U
.ENDS INV_X1

.SUBCKT HA_X1 A B S CO VDD PWELL VSS
M$1 VDD B \$12 VDD PMOS_VTL L=0.05U W=0.315U AS=0.0338625P AD=0.02205P
+ PS=0.775U PD=0.455U
M$2 \$12 A \$7 VDD PMOS_VTL L=0.05U W=0.315U AS=0.02205P AD=0.033075P PS=0.455U
+ PD=0.84U
M$3 \$3 B S VDD PMOS_VTL L=0.05U W=0.63U AS=0.06615P AD=0.0441P PS=1.47U
+ PD=0.77U
M$4 S A \$3 VDD PMOS_VTL L=0.05U W=0.63U AS=0.0441P AD=0.0441P PS=0.77U PD=0.77U
M$5 \$3 \$7 VDD VDD PMOS_VTL L=0.05U W=0.63U AS=0.0441P AD=0.0338625P PS=0.77U
+ PD=0.775U
M$6 VDD A \$8 VDD PMOS_VTL L=0.05U W=0.315U AS=0.033075P AD=0.02205P PS=0.84U
+ PD=0.455U
M$7 VDD B \$8 VDD PMOS_VTL L=0.05U W=0.315U AS=0.033075P AD=0.02205P PS=0.77U
+ PD=0.455U
M$8 VDD \$8 CO VDD PMOS_VTL L=0.05U W=0.63U AS=0.033075P AD=0.06615P PS=0.77U
+ PD=1.47U
M$9 \$8 A \$14 PWELL NMOS_VTL L=0.05U W=0.21U AS=0.02205P AD=0.0147P PS=0.63U
+ PD=0.35U
M$10 \$14 B VSS PWELL NMOS_VTL L=0.05U W=0.21U AS=0.0147P AD=0.021875P PS=0.35U
+ PD=0.555U
M$11 VSS \$8 CO PWELL NMOS_VTL L=0.05U W=0.415U AS=0.021875P AD=0.043575P
+ PS=0.555U PD=1.04U
M$12 VSS B \$7 PWELL NMOS_VTL L=0.05U W=0.21U AS=0.0224P AD=0.0147P PS=0.56U
+ PD=0.35U
M$13 \$7 A VSS PWELL NMOS_VTL L=0.05U W=0.21U AS=0.0147P AD=0.02205P PS=0.35U
+ PD=0.63U
M$14 VSS B \$13 PWELL NMOS_VTL L=0.05U W=0.415U AS=0.043575P AD=0.02905P
+ PS=1.04U PD=0.555U
M$15 \$13 A S PWELL NMOS_VTL L=0.05U W=0.415U AS=0.02905P AD=0.02905P PS=0.555U
+ PD=0.555U
M$16 S \$7 VSS PWELL NMOS_VTL L=0.05U W=0.415U AS=0.02905P AD=0.0224P PS=0.555U
+ PD=0.56U
.ENDS HA_X1

.SUBCKT DFF_X2 D CK QN Q VDD PWELL VSS
M$1 VDD \$9 QN VDD PMOS_VTL L=0.05U W=1.26U AS=0.11025P AD=0.0882P PS=2.24U
+ PD=1.54U
M$3 VDD \$2 Q VDD PMOS_VTL L=0.05U W=1.26U AS=0.0882P AD=0.11025P PS=1.54U
+ PD=2.24U
M$5 \$3 \$7 VDD VDD PMOS_VTL L=0.05U W=0.315U AS=0.033075P AD=0.014175P
+ PS=0.84U PD=0.455U
M$6 VDD \$4 \$18 VDD PMOS_VTL L=0.05U W=0.09U AS=0.014175P AD=0.0063P PS=0.455U
+ PD=0.23U
M$7 \$5 \$7 \$18 VDD PMOS_VTL L=0.05U W=0.09U AS=0.01785P AD=0.0063P PS=0.56U
+ PD=0.23U
M$8 \$5 \$3 \$19 VDD PMOS_VTL L=0.05U W=0.42U AS=0.01785P AD=0.0294P PS=0.56U
+ PD=0.56U
M$9 \$19 D VDD VDD PMOS_VTL L=0.05U W=0.42U AS=0.0294P AD=0.025725P PS=0.56U
+ PD=0.56U
M$10 VDD \$5 \$4 VDD PMOS_VTL L=0.05U W=0.315U AS=0.025725P AD=0.0567P PS=0.56U
+ PD=0.99U
M$11 \$9 \$3 \$21 VDD PMOS_VTL L=0.05U W=0.09U AS=0.014175P AD=0.0063P
+ PS=0.455U PD=0.23U
M$12 VDD \$2 \$21 VDD PMOS_VTL L=0.05U W=0.09U AS=0.0252P AD=0.0063P PS=0.77U
+ PD=0.23U
M$13 \$7 CK VDD VDD PMOS_VTL L=0.05U W=0.315U AS=0.033075P AD=0.02205P PS=0.84U
+ PD=0.455U
M$14 VDD \$5 \$20 VDD PMOS_VTL L=0.05U W=0.315U AS=0.02205P AD=0.02205P
+ PS=0.455U PD=0.455U
M$15 \$20 \$7 \$9 VDD PMOS_VTL L=0.05U W=0.315U AS=0.02205P AD=0.014175P
+ PS=0.455U PD=0.455U
M$16 VDD \$9 \$2 VDD PMOS_VTL L=0.05U W=0.63U AS=0.0252P AD=0.06615P PS=0.77U
+ PD=1.47U
M$17 VSS \$9 QN PWELL NMOS_VTL L=0.05U W=0.83U AS=0.072625P AD=0.0581P
+ PS=1.595U PD=1.11U
M$19 VSS \$2 Q PWELL NMOS_VTL L=0.05U W=0.83U AS=0.0581P AD=0.072625P PS=1.11U
+ PD=1.595U
M$21 VSS \$4 \$13 PWELL NMOS_VTL L=0.05U W=0.09U AS=0.0105P AD=0.0063P PS=0.35U
+ PD=0.23U
M$22 \$5 \$3 \$13 PWELL NMOS_VTL L=0.05U W=0.09U AS=0.012775P AD=0.0063P
+ PS=0.415U PD=0.23U
M$23 VSS \$5 \$4 PWELL NMOS_VTL L=0.05U W=0.21U AS=0.016975P AD=0.02205P
+ PS=0.415U PD=0.63U
M$24 \$5 \$7 \$14 PWELL NMOS_VTL L=0.05U W=0.275U AS=0.012775P AD=0.01925P
+ PS=0.415U PD=0.415U
M$25 \$14 D VSS PWELL NMOS_VTL L=0.05U W=0.275U AS=0.01925P AD=0.016975P
+ PS=0.415U PD=0.415U
M$26 \$3 \$7 VSS PWELL NMOS_VTL L=0.05U W=0.21U AS=0.02205P AD=0.0105P PS=0.63U
+ PD=0.35U
M$27 \$7 CK VSS PWELL NMOS_VTL L=0.05U W=0.21U AS=0.02205P AD=0.0147P PS=0.63U
+ PD=0.35U
M$28 VSS \$5 \$15 PWELL NMOS_VTL L=0.05U W=0.21U AS=0.0147P AD=0.0147P PS=0.35U
+ PD=0.35U
M$29 \$15 \$3 \$9 PWELL NMOS_VTL L=0.05U W=0.21U AS=0.0147P AD=0.0105P PS=0.35U
+ PD=0.35U
M$30 \$9 \$7 \$16 PWELL NMOS_VTL L=0.05U W=0.09U AS=0.0105P AD=0.0063P PS=0.35U
+ PD=0.23U
M$31 VSS \$2 \$16 PWELL NMOS_VTL L=0.05U W=0.09U AS=0.017675P AD=0.0063P
+ PS=0.555U PD=0.23U
M$32 VSS \$9 \$2 PWELL NMOS_VTL L=0.05U W=0.415U AS=0.017675P AD=0.043575P
+ PS=0.555U PD=1.04U
.ENDS DFF_X2

.SUBCKT DFF_X1 QN Q D CK VDD PWELL VSS
M$1 QN \$6 VDD VDD PMOS_VTL L=0.05U W=0.63U AS=0.06615P AD=0.0441P PS=1.47U
+ PD=0.77U
M$2 VDD \$7 Q VDD PMOS_VTL L=0.05U W=0.63U AS=0.0441P AD=0.06615P PS=0.77U
+ PD=1.47U
M$3 \$2 \$5 VDD VDD PMOS_VTL L=0.05U W=0.315U AS=0.033075P AD=0.014175P
+ PS=0.84U PD=0.455U
M$4 VDD \$3 \$18 VDD PMOS_VTL L=0.05U W=0.09U AS=0.014175P AD=0.0063P PS=0.455U
+ PD=0.23U
M$5 \$4 \$5 \$18 VDD PMOS_VTL L=0.05U W=0.09U AS=0.018075P AD=0.0063P PS=0.565U
+ PD=0.23U
M$6 \$4 \$2 \$19 VDD PMOS_VTL L=0.05U W=0.42U AS=0.018075P AD=0.0294P PS=0.565U
+ PD=0.56U
M$7 \$19 D VDD VDD PMOS_VTL L=0.05U W=0.42U AS=0.0294P AD=0.025725P PS=0.56U
+ PD=0.56U
M$8 VDD \$4 \$3 VDD PMOS_VTL L=0.05U W=0.315U AS=0.025725P AD=0.0567P PS=0.56U
+ PD=0.99U
M$9 \$5 CK VDD VDD PMOS_VTL L=0.05U W=0.315U AS=0.033075P AD=0.02205P PS=0.84U
+ PD=0.455U
M$10 VDD \$4 \$20 VDD PMOS_VTL L=0.05U W=0.315U AS=0.02205P AD=0.02205P
+ PS=0.455U PD=0.455U
M$11 \$20 \$5 \$6 VDD PMOS_VTL L=0.05U W=0.315U AS=0.02205P AD=0.014175P
+ PS=0.455U PD=0.455U
M$12 \$6 \$2 \$21 VDD PMOS_VTL L=0.05U W=0.09U AS=0.014175P AD=0.006525P
+ PS=0.455U PD=0.235U
M$13 VDD \$7 \$21 VDD PMOS_VTL L=0.05U W=0.09U AS=0.014175P AD=0.006525P
+ PS=0.455U PD=0.235U
M$14 VDD \$6 \$7 VDD PMOS_VTL L=0.05U W=0.315U AS=0.014175P AD=0.033075P
+ PS=0.455U PD=0.84U
M$15 QN \$6 VSS PWELL NMOS_VTL L=0.05U W=0.415U AS=0.043575P AD=0.02905P
+ PS=1.04U PD=0.555U
M$16 VSS \$7 Q PWELL NMOS_VTL L=0.05U W=0.415U AS=0.02905P AD=0.043575P
+ PS=0.555U PD=1.04U
M$17 \$6 \$5 \$12 PWELL NMOS_VTL L=0.05U W=0.09U AS=0.0105P AD=0.006525P
+ PS=0.35U PD=0.235U
M$18 VSS \$7 \$12 PWELL NMOS_VTL L=0.05U W=0.09U AS=0.0105P AD=0.006525P
+ PS=0.35U PD=0.235U
M$19 \$5 CK VSS PWELL NMOS_VTL L=0.05U W=0.21U AS=0.02205P AD=0.0147P PS=0.63U
+ PD=0.35U
M$20 VSS \$4 \$13 PWELL NMOS_VTL L=0.05U W=0.21U AS=0.0147P AD=0.0147P PS=0.35U
+ PD=0.35U
M$21 \$13 \$2 \$6 PWELL NMOS_VTL L=0.05U W=0.21U AS=0.0147P AD=0.0105P PS=0.35U
+ PD=0.35U
M$22 VSS \$6 \$7 PWELL NMOS_VTL L=0.05U W=0.21U AS=0.0105P AD=0.02205P PS=0.35U
+ PD=0.63U
M$23 \$2 \$5 VSS PWELL NMOS_VTL L=0.05U W=0.21U AS=0.02205P AD=0.0105P PS=0.63U
+ PD=0.35U
M$24 VSS \$3 \$10 PWELL NMOS_VTL L=0.05U W=0.09U AS=0.0105P AD=0.0063P PS=0.35U
+ PD=0.23U
M$25 \$4 \$2 \$10 PWELL NMOS_VTL L=0.05U W=0.09U AS=0.013P AD=0.0063P PS=0.42U
+ PD=0.23U
M$26 VSS \$4 \$3 PWELL NMOS_VTL L=0.05U W=0.21U AS=0.016975P AD=0.02205P
+ PS=0.415U PD=0.63U
M$27 \$4 \$5 \$11 PWELL NMOS_VTL L=0.05U W=0.275U AS=0.013P AD=0.01925P
+ PS=0.42U PD=0.415U
M$28 \$11 D VSS PWELL NMOS_VTL L=0.05U W=0.275U AS=0.01925P AD=0.016975P
+ PS=0.415U PD=0.415U
.ENDS DFF_X1

.SUBCKT CLKBUF_X2 A Z VDD PWELL VSS
M$1 \$2 A VDD VDD PMOS_VTL L=0.05U W=0.63U AS=0.06615P AD=0.0441P PS=1.47U
+ PD=0.77U
M$2 VDD \$2 Z VDD PMOS_VTL L=0.05U W=1.26U AS=0.0882P AD=0.11025P PS=1.54U
+ PD=2.24U
M$4 \$2 A VSS PWELL NMOS_VTL L=0.05U W=0.195U AS=0.020475P AD=0.01365P PS=0.6U
+ PD=0.335U
M$5 VSS \$2 Z PWELL NMOS_VTL L=0.05U W=0.39U AS=0.0273P AD=0.034125P PS=0.67U
+ PD=0.935U
.ENDS CLKBUF_X2

.SUBCKT BUF_X8 Z A VDD PWELL VSS
M$1 VDD A \$2 VDD PMOS_VTL L=0.05U W=2.52U AS=0.19845P AD=0.1764P PS=3.78U
+ PD=3.08U
M$5 VDD \$2 Z VDD PMOS_VTL L=0.05U W=5.04U AS=0.3528P AD=0.37485P PS=6.16U
+ PD=6.86U
M$13 VSS A \$2 PWELL NMOS_VTL L=0.05U W=1.66U AS=0.130725P AD=0.1162P PS=2.705U
+ PD=2.22U
M$17 VSS \$2 Z PWELL NMOS_VTL L=0.05U W=3.32U AS=0.2324P AD=0.246925P PS=4.44U
+ PD=4.925U
.ENDS BUF_X8

.SUBCKT BUF_X4 A Z VDD PWELL VSS
M$1 VDD A \$2 VDD PMOS_VTL L=0.05U W=1.26U AS=0.11025P AD=0.0882P PS=2.24U
+ PD=1.54U
M$3 VDD \$2 Z VDD PMOS_VTL L=0.05U W=2.52U AS=0.1764P AD=0.19845P PS=3.08U
+ PD=3.78U
M$7 VSS A \$2 PWELL NMOS_VTL L=0.05U W=0.83U AS=0.072625P AD=0.0581P PS=1.595U
+ PD=1.11U
M$9 VSS \$2 Z PWELL NMOS_VTL L=0.05U W=1.66U AS=0.1162P AD=0.130725P PS=2.22U
+ PD=2.705U
.ENDS BUF_X4

.SUBCKT BUF_X16 A Z VDD PWELL VSS
M$1 VDD A \$3 VDD PMOS_VTL L=0.05U W=5.04U AS=0.37485P AD=0.3528P PS=6.86U
+ PD=6.16U
M$9 VDD \$3 Z VDD PMOS_VTL L=0.05U W=10.08U AS=0.7056P AD=0.72765P PS=12.32U
+ PD=13.02U
M$25 VSS A \$3 PWELL NMOS_VTL L=0.05U W=3.32U AS=0.246925P AD=0.2324P PS=4.925U
+ PD=4.44U
M$33 VSS \$3 Z PWELL NMOS_VTL L=0.05U W=6.64U AS=0.4648P AD=0.479325P PS=8.88U
+ PD=9.365U
.ENDS BUF_X16

.SUBCKT BUF_X1 A Z VDD PWELL VSS
M$1 VDD A \$2 VDD PMOS_VTL L=0.05U W=0.315U AS=0.033075P AD=0.033075P PS=0.77U
+ PD=0.84U
M$2 VDD \$2 Z VDD PMOS_VTL L=0.05U W=0.63U AS=0.033075P AD=0.06615P PS=0.77U
+ PD=1.47U
M$3 \$2 A VSS PWELL NMOS_VTL L=0.05U W=0.21U AS=0.02205P AD=0.021875P PS=0.63U
+ PD=0.555U
M$4 VSS \$2 Z PWELL NMOS_VTL L=0.05U W=0.415U AS=0.021875P AD=0.043575P
+ PS=0.555U PD=1.04U
.ENDS BUF_X1

.SUBCKT AOI22_X2 B2 B1 A2 A1 ZN VDD PWELL VSS
M$1 \$6 B2 VDD VDD PMOS_VTL L=0.05U W=1.26U AS=0.11025P AD=0.0882P PS=2.24U
+ PD=1.54U
M$2 VDD B1 \$6 VDD PMOS_VTL L=0.05U W=1.26U AS=0.0882P AD=0.0882P PS=1.54U
+ PD=1.54U
M$5 \$6 A2 ZN VDD PMOS_VTL L=0.05U W=1.26U AS=0.0882P AD=0.11025P PS=1.54U
+ PD=2.24U
M$6 ZN A1 \$6 VDD PMOS_VTL L=0.05U W=1.26U AS=0.0882P AD=0.0882P PS=1.54U
+ PD=1.54U
M$9 VSS B2 \$14 PWELL NMOS_VTL L=0.05U W=0.415U AS=0.043575P AD=0.02905P
+ PS=1.04U PD=0.555U
M$10 \$14 B1 ZN PWELL NMOS_VTL L=0.05U W=0.415U AS=0.02905P AD=0.02905P
+ PS=0.555U PD=0.555U
M$11 ZN B1 \$12 PWELL NMOS_VTL L=0.05U W=0.415U AS=0.02905P AD=0.02905P
+ PS=0.555U PD=0.555U
M$12 \$12 B2 VSS PWELL NMOS_VTL L=0.05U W=0.415U AS=0.02905P AD=0.02905P
+ PS=0.555U PD=0.555U
M$13 VSS A2 \$13 PWELL NMOS_VTL L=0.05U W=0.415U AS=0.02905P AD=0.02905P
+ PS=0.555U PD=0.555U
M$14 \$13 A1 ZN PWELL NMOS_VTL L=0.05U W=0.415U AS=0.02905P AD=0.02905P
+ PS=0.555U PD=0.555U
M$15 ZN A1 \$11 PWELL NMOS_VTL L=0.05U W=0.415U AS=0.02905P AD=0.02905P
+ PS=0.555U PD=0.555U
M$16 \$11 A2 VSS PWELL NMOS_VTL L=0.05U W=0.415U AS=0.02905P AD=0.043575P
+ PS=0.555U PD=1.04U
.ENDS AOI22_X2

.SUBCKT AOI22_X1 B2 B1 A1 A2 ZN VDD PWELL VSS
M$1 \$6 B2 VDD VDD PMOS_VTL L=0.05U W=0.63U AS=0.06615P AD=0.0441P PS=1.47U
+ PD=0.77U
M$2 VDD B1 \$6 VDD PMOS_VTL L=0.05U W=0.63U AS=0.0441P AD=0.0441P PS=0.77U
+ PD=0.77U
M$3 \$6 A1 ZN VDD PMOS_VTL L=0.05U W=0.63U AS=0.0441P AD=0.0441P PS=0.77U
+ PD=0.77U
M$4 ZN A2 \$6 VDD PMOS_VTL L=0.05U W=0.63U AS=0.0441P AD=0.06615P PS=0.77U
+ PD=1.47U
M$5 VSS B2 \$12 PWELL NMOS_VTL L=0.05U W=0.415U AS=0.043575P AD=0.02905P
+ PS=1.04U PD=0.555U
M$6 \$12 B1 ZN PWELL NMOS_VTL L=0.05U W=0.415U AS=0.02905P AD=0.02905P
+ PS=0.555U PD=0.555U
M$7 ZN A1 \$11 PWELL NMOS_VTL L=0.05U W=0.415U AS=0.02905P AD=0.02905P
+ PS=0.555U PD=0.555U
M$8 \$11 A2 VSS PWELL NMOS_VTL L=0.05U W=0.415U AS=0.02905P AD=0.043575P
+ PS=0.555U PD=1.04U
.ENDS AOI22_X1

.SUBCKT AOI222_X2 C2 C1 ZN B2 B1 A1 A2 VDD PWELL VSS
M$1 \$15 C2 VDD VDD PMOS_VTL L=0.05U W=1.26U AS=0.11025P AD=0.0882P PS=2.24U
+ PD=1.54U
M$2 VDD C1 \$15 VDD PMOS_VTL L=0.05U W=1.26U AS=0.0882P AD=0.0882P PS=1.54U
+ PD=1.54U
M$5 \$15 B2 \$18 VDD PMOS_VTL L=0.05U W=1.26U AS=0.0882P AD=0.11025P PS=1.54U
+ PD=2.24U
M$6 \$18 B1 \$15 VDD PMOS_VTL L=0.05U W=1.26U AS=0.0882P AD=0.0882P PS=1.54U
+ PD=1.54U
M$9 \$18 A1 ZN VDD PMOS_VTL L=0.05U W=1.26U AS=0.11025P AD=0.0882P PS=2.24U
+ PD=1.54U
M$11 \$18 A2 ZN VDD PMOS_VTL L=0.05U W=1.26U AS=0.0882P AD=0.11025P PS=1.54U
+ PD=2.24U
M$13 VSS C2 \$10 PWELL NMOS_VTL L=0.05U W=0.415U AS=0.043575P AD=0.02905P
+ PS=1.04U PD=0.555U
M$14 \$10 C1 ZN PWELL NMOS_VTL L=0.05U W=0.415U AS=0.02905P AD=0.02905P
+ PS=0.555U PD=0.555U
M$15 ZN C1 \$12 PWELL NMOS_VTL L=0.05U W=0.415U AS=0.02905P AD=0.02905P
+ PS=0.555U PD=0.555U
M$16 \$12 C2 VSS PWELL NMOS_VTL L=0.05U W=0.415U AS=0.02905P AD=0.02905P
+ PS=0.555U PD=0.555U
M$17 VSS B2 \$13 PWELL NMOS_VTL L=0.05U W=0.415U AS=0.02905P AD=0.02905P
+ PS=0.555U PD=0.555U
M$18 \$13 B1 ZN PWELL NMOS_VTL L=0.05U W=0.415U AS=0.02905P AD=0.02905P
+ PS=0.555U PD=0.555U
M$19 ZN B1 \$14 PWELL NMOS_VTL L=0.05U W=0.415U AS=0.02905P AD=0.02905P
+ PS=0.555U PD=0.555U
M$20 \$14 B2 VSS PWELL NMOS_VTL L=0.05U W=0.415U AS=0.02905P AD=0.043575P
+ PS=0.555U PD=1.04U
M$21 \$7 A1 ZN PWELL NMOS_VTL L=0.05U W=0.415U AS=0.043575P AD=0.02905P
+ PS=1.04U PD=0.555U
M$22 ZN A1 \$11 PWELL NMOS_VTL L=0.05U W=0.415U AS=0.02905P AD=0.02905P
+ PS=0.555U PD=0.555U
M$23 \$11 A2 VSS PWELL NMOS_VTL L=0.05U W=0.415U AS=0.02905P AD=0.02905P
+ PS=0.555U PD=0.555U
M$24 VSS A2 \$7 PWELL NMOS_VTL L=0.05U W=0.415U AS=0.02905P AD=0.043575P
+ PS=0.555U PD=1.04U
.ENDS AOI222_X2

.SUBCKT AOI221_X2 B1 B2 A C2 C1 ZN VDD PWELL VSS
M$1 \$10 A \$7 VDD PMOS_VTL L=0.05U W=1.26U AS=0.11025P AD=0.09135P PS=2.24U
+ PD=1.55U
M$2 \$7 B1 VDD VDD PMOS_VTL L=0.05U W=1.26U AS=0.0882P AD=0.0882P PS=1.54U
+ PD=1.54U
M$3 VDD B2 \$7 VDD PMOS_VTL L=0.05U W=1.26U AS=0.0882P AD=0.0882P PS=1.54U
+ PD=1.54U
M$7 \$10 C2 ZN VDD PMOS_VTL L=0.05U W=1.26U AS=0.09135P AD=0.11025P PS=1.55U
+ PD=2.24U
M$8 ZN C1 \$10 VDD PMOS_VTL L=0.05U W=1.26U AS=0.0882P AD=0.0882P PS=1.54U
+ PD=1.54U
M$11 VSS A ZN PWELL NMOS_VTL L=0.05U W=0.83U AS=0.072625P AD=0.060175P
+ PS=1.595U PD=1.12U
M$12 ZN B1 \$16 PWELL NMOS_VTL L=0.05U W=0.415U AS=0.02905P AD=0.02905P
+ PS=0.555U PD=0.555U
M$13 \$16 B2 VSS PWELL NMOS_VTL L=0.05U W=0.415U AS=0.02905P AD=0.02905P
+ PS=0.555U PD=0.555U
M$14 VSS B2 \$15 PWELL NMOS_VTL L=0.05U W=0.415U AS=0.02905P AD=0.02905P
+ PS=0.555U PD=0.555U
M$15 \$15 B1 ZN PWELL NMOS_VTL L=0.05U W=0.415U AS=0.02905P AD=0.02905P
+ PS=0.555U PD=0.555U
M$17 VSS C2 \$14 PWELL NMOS_VTL L=0.05U W=0.415U AS=0.031125P AD=0.02905P
+ PS=0.565U PD=0.555U
M$18 \$14 C1 ZN PWELL NMOS_VTL L=0.05U W=0.415U AS=0.02905P AD=0.02905P
+ PS=0.555U PD=0.555U
M$19 ZN C1 \$13 PWELL NMOS_VTL L=0.05U W=0.415U AS=0.02905P AD=0.02905P
+ PS=0.555U PD=0.555U
M$20 \$13 C2 VSS PWELL NMOS_VTL L=0.05U W=0.415U AS=0.02905P AD=0.043575P
+ PS=0.555U PD=1.04U
.ENDS AOI221_X2

.SUBCKT AOI21_X4 ZN A B2 B1 VDD PWELL VSS
M$1 \$11 A VDD VDD PMOS_VTL L=0.05U W=2.52U AS=0.19845P AD=0.1764P PS=3.78U
+ PD=3.08U
M$5 \$11 B2 ZN VDD PMOS_VTL L=0.05U W=2.52U AS=0.1764P AD=0.19845P PS=3.08U
+ PD=3.78U
M$6 ZN B1 \$11 VDD PMOS_VTL L=0.05U W=2.52U AS=0.1764P AD=0.1764P PS=3.08U
+ PD=3.08U
M$13 VSS A ZN PWELL NMOS_VTL L=0.05U W=1.66U AS=0.130725P AD=0.1162P PS=2.705U
+ PD=2.22U
M$17 VSS B2 \$8 PWELL NMOS_VTL L=0.05U W=0.415U AS=0.02905P AD=0.02905P
+ PS=0.555U PD=0.555U
M$18 \$8 B1 ZN PWELL NMOS_VTL L=0.05U W=0.415U AS=0.02905P AD=0.02905P
+ PS=0.555U PD=0.555U
M$19 ZN B1 \$9 PWELL NMOS_VTL L=0.05U W=0.415U AS=0.02905P AD=0.02905P
+ PS=0.555U PD=0.555U
M$20 \$9 B2 VSS PWELL NMOS_VTL L=0.05U W=0.415U AS=0.02905P AD=0.02905P
+ PS=0.555U PD=0.555U
M$21 VSS B2 \$6 PWELL NMOS_VTL L=0.05U W=0.415U AS=0.02905P AD=0.02905P
+ PS=0.555U PD=0.555U
M$22 \$6 B1 ZN PWELL NMOS_VTL L=0.05U W=0.415U AS=0.02905P AD=0.02905P
+ PS=0.555U PD=0.555U
M$23 ZN B1 \$7 PWELL NMOS_VTL L=0.05U W=0.415U AS=0.02905P AD=0.02905P
+ PS=0.555U PD=0.555U
M$24 \$7 B2 VSS PWELL NMOS_VTL L=0.05U W=0.415U AS=0.02905P AD=0.043575P
+ PS=0.555U PD=1.04U
.ENDS AOI21_X4

.SUBCKT AOI21_X1 A B2 B1 ZN VDD PWELL VSS
M$1 \$5 B2 ZN VDD PMOS_VTL L=0.05U W=0.63U AS=0.06615P AD=0.0441P PS=1.47U
+ PD=0.77U
M$2 ZN B1 \$5 VDD PMOS_VTL L=0.05U W=0.63U AS=0.0441P AD=0.0441P PS=0.77U
+ PD=0.77U
M$3 \$5 A VDD VDD PMOS_VTL L=0.05U W=0.63U AS=0.0441P AD=0.06615P PS=0.77U
+ PD=1.47U
M$4 VSS B2 \$10 PWELL NMOS_VTL L=0.05U W=0.415U AS=0.043575P AD=0.02905P
+ PS=1.04U PD=0.555U
M$5 \$10 B1 ZN PWELL NMOS_VTL L=0.05U W=0.415U AS=0.02905P AD=0.02905P
+ PS=0.555U PD=0.555U
M$6 ZN A VSS PWELL NMOS_VTL L=0.05U W=0.415U AS=0.02905P AD=0.043575P PS=0.555U
+ PD=1.04U
.ENDS AOI21_X1

.SUBCKT AND2_X1 A1 A2 ZN VDD PWELL VSS
M$1 VDD A1 \$3 VDD PMOS_VTL L=0.05U W=0.315U AS=0.033075P AD=0.02205P PS=0.84U
+ PD=0.455U
M$2 VDD A2 \$3 VDD PMOS_VTL L=0.05U W=0.315U AS=0.033075P AD=0.02205P PS=0.77U
+ PD=0.455U
M$3 VDD \$3 ZN VDD PMOS_VTL L=0.05U W=0.63U AS=0.033075P AD=0.06615P PS=0.77U
+ PD=1.47U
M$4 \$3 A1 \$9 PWELL NMOS_VTL L=0.05U W=0.21U AS=0.02205P AD=0.0147P PS=0.63U
+ PD=0.35U
M$5 \$9 A2 VSS PWELL NMOS_VTL L=0.05U W=0.21U AS=0.0147P AD=0.021875P PS=0.35U
+ PD=0.555U
M$6 VSS \$3 ZN PWELL NMOS_VTL L=0.05U W=0.415U AS=0.021875P AD=0.043575P
+ PS=0.555U PD=1.04U
.ENDS AND2_X1
